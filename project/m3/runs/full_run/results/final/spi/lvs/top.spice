* NGSPICE file created from top.ext - technology: sky130A

* Black-box entry subcircuit for sky130_fd_sc_hd__or3_1 abstract view
.subckt sky130_fd_sc_hd__or3_1 A B C VGND VNB VPB VPWR X
.ends

* Black-box entry subcircuit for sky130_fd_sc_hd__nand2_1 abstract view
.subckt sky130_fd_sc_hd__nand2_1 A B VGND VNB VPB VPWR Y
.ends

* Black-box entry subcircuit for sky130_fd_sc_hd__tapvpwrvgnd_1 abstract view
.subckt sky130_fd_sc_hd__tapvpwrvgnd_1 VGND VPWR
.ends

* Black-box entry subcircuit for sky130_fd_sc_hd__decap_6 abstract view
.subckt sky130_fd_sc_hd__decap_6 VGND VNB VPB VPWR
.ends

* Black-box entry subcircuit for sky130_fd_sc_hd__o21a_1 abstract view
.subckt sky130_fd_sc_hd__o21a_1 A1 A2 B1 VGND VNB VPB VPWR X
.ends

* Black-box entry subcircuit for sky130_fd_sc_hd__fill_1 abstract view
.subckt sky130_fd_sc_hd__fill_1 VGND VNB VPB VPWR
.ends

* Black-box entry subcircuit for sky130_fd_sc_hd__and2_1 abstract view
.subckt sky130_fd_sc_hd__and2_1 A B VGND VNB VPB VPWR X
.ends

* Black-box entry subcircuit for sky130_ef_sc_hd__decap_12 abstract view
.subckt sky130_ef_sc_hd__decap_12 VPWR VGND VPB VNB
.ends

* Black-box entry subcircuit for sky130_fd_sc_hd__fill_2 abstract view
.subckt sky130_fd_sc_hd__fill_2 VGND VNB VPB VPWR
.ends

* Black-box entry subcircuit for sky130_fd_sc_hd__dlygate4sd1_1 abstract view
.subckt sky130_fd_sc_hd__dlygate4sd1_1 A VGND VNB VPB VPWR X
.ends

* Black-box entry subcircuit for sky130_fd_sc_hd__decap_4 abstract view
.subckt sky130_fd_sc_hd__decap_4 VGND VNB VPB VPWR
.ends

* Black-box entry subcircuit for sky130_fd_sc_hd__decap_3 abstract view
.subckt sky130_fd_sc_hd__decap_3 VGND VNB VPB VPWR
.ends

* Black-box entry subcircuit for sky130_fd_sc_hd__and3_1 abstract view
.subckt sky130_fd_sc_hd__and3_1 A B C VGND VNB VPB VPWR X
.ends

* Black-box entry subcircuit for sky130_fd_sc_hd__a21oi_1 abstract view
.subckt sky130_fd_sc_hd__a21oi_1 A1 A2 B1 VGND VNB VPB VPWR Y
.ends

* Black-box entry subcircuit for sky130_fd_sc_hd__decap_8 abstract view
.subckt sky130_fd_sc_hd__decap_8 VGND VNB VPB VPWR
.ends

* Black-box entry subcircuit for sky130_fd_sc_hd__or2_1 abstract view
.subckt sky130_fd_sc_hd__or2_1 A B VGND VNB VPB VPWR X
.ends

* Black-box entry subcircuit for sky130_fd_sc_hd__a2bb2o_1 abstract view
.subckt sky130_fd_sc_hd__a2bb2o_1 A1_N A2_N B1 B2 VGND VNB VPB VPWR X
.ends

* Black-box entry subcircuit for sky130_fd_sc_hd__clkbuf_2 abstract view
.subckt sky130_fd_sc_hd__clkbuf_2 A VGND VNB VPB VPWR X
.ends

* Black-box entry subcircuit for sky130_fd_sc_hd__buf_2 abstract view
.subckt sky130_fd_sc_hd__buf_2 A VGND VNB VPB VPWR X
.ends

* Black-box entry subcircuit for sky130_fd_sc_hd__nor2b_1 abstract view
.subckt sky130_fd_sc_hd__nor2b_1 A B_N VGND VNB VPB VPWR Y
.ends

* Black-box entry subcircuit for sky130_fd_sc_hd__xnor2_1 abstract view
.subckt sky130_fd_sc_hd__xnor2_1 A B VGND VNB VPB VPWR Y
.ends

* Black-box entry subcircuit for sky130_fd_sc_hd__a31o_1 abstract view
.subckt sky130_fd_sc_hd__a31o_1 A1 A2 A3 B1 VGND VNB VPB VPWR X
.ends

* Black-box entry subcircuit for sky130_fd_sc_hd__o211a_1 abstract view
.subckt sky130_fd_sc_hd__o211a_1 A1 A2 B1 C1 VGND VNB VPB VPWR X
.ends

* Black-box entry subcircuit for sky130_fd_sc_hd__clkbuf_8 abstract view
.subckt sky130_fd_sc_hd__clkbuf_8 A VGND VNB VPB VPWR X
.ends

* Black-box entry subcircuit for sky130_fd_sc_hd__a32o_1 abstract view
.subckt sky130_fd_sc_hd__a32o_1 A1 A2 A3 B1 B2 VGND VNB VPB VPWR X
.ends

* Black-box entry subcircuit for sky130_fd_sc_hd__nor3b_1 abstract view
.subckt sky130_fd_sc_hd__nor3b_1 A B C_N VGND VNB VPB VPWR Y
.ends

* Black-box entry subcircuit for sky130_fd_sc_hd__xor2_1 abstract view
.subckt sky130_fd_sc_hd__xor2_1 A B VGND VNB VPB VPWR X
.ends

* Black-box entry subcircuit for sky130_fd_sc_hd__xnor2_2 abstract view
.subckt sky130_fd_sc_hd__xnor2_2 A B VGND VNB VPB VPWR Y
.ends

* Black-box entry subcircuit for sky130_fd_sc_hd__o2bb2a_1 abstract view
.subckt sky130_fd_sc_hd__o2bb2a_1 A1_N A2_N B1 B2 VGND VNB VPB VPWR X
.ends

* Black-box entry subcircuit for sky130_fd_sc_hd__a22o_1 abstract view
.subckt sky130_fd_sc_hd__a22o_1 A1 A2 B1 B2 VGND VNB VPB VPWR X
.ends

* Black-box entry subcircuit for sky130_fd_sc_hd__dfxtp_1 abstract view
.subckt sky130_fd_sc_hd__dfxtp_1 CLK D VGND VNB VPB VPWR Q
.ends

* Black-box entry subcircuit for sky130_fd_sc_hd__nor2_1 abstract view
.subckt sky130_fd_sc_hd__nor2_1 A B VGND VNB VPB VPWR Y
.ends

* Black-box entry subcircuit for sky130_fd_sc_hd__dfxtp_2 abstract view
.subckt sky130_fd_sc_hd__dfxtp_2 CLK D VGND VNB VPB VPWR Q
.ends

* Black-box entry subcircuit for sky130_fd_sc_hd__mux2_1 abstract view
.subckt sky130_fd_sc_hd__mux2_1 A0 A1 S VGND VNB VPB VPWR X
.ends

* Black-box entry subcircuit for sky130_fd_sc_hd__buf_4 abstract view
.subckt sky130_fd_sc_hd__buf_4 A VGND VNB VPB VPWR X
.ends

* Black-box entry subcircuit for sky130_fd_sc_hd__and2b_1 abstract view
.subckt sky130_fd_sc_hd__and2b_1 A_N B VGND VNB VPB VPWR X
.ends

* Black-box entry subcircuit for sky130_fd_sc_hd__inv_2 abstract view
.subckt sky130_fd_sc_hd__inv_2 A VGND VNB VPB VPWR Y
.ends

* Black-box entry subcircuit for sky130_fd_sc_hd__dlygate4sd3_1 abstract view
.subckt sky130_fd_sc_hd__dlygate4sd3_1 A VGND VNB VPB VPWR X
.ends

* Black-box entry subcircuit for sky130_fd_sc_hd__clkbuf_4 abstract view
.subckt sky130_fd_sc_hd__clkbuf_4 A VGND VNB VPB VPWR X
.ends

* Black-box entry subcircuit for sky130_fd_sc_hd__a21o_1 abstract view
.subckt sky130_fd_sc_hd__a21o_1 A1 A2 B1 VGND VNB VPB VPWR X
.ends

* Black-box entry subcircuit for sky130_fd_sc_hd__clkbuf_1 abstract view
.subckt sky130_fd_sc_hd__clkbuf_1 A VGND VNB VPB VPWR X
.ends

* Black-box entry subcircuit for sky130_fd_sc_hd__o221a_4 abstract view
.subckt sky130_fd_sc_hd__o221a_4 A1 A2 B1 B2 C1 VGND VNB VPB VPWR X
.ends

* Black-box entry subcircuit for sky130_fd_sc_hd__or2b_1 abstract view
.subckt sky130_fd_sc_hd__or2b_1 A B_N VGND VNB VPB VPWR X
.ends

* Black-box entry subcircuit for sky130_fd_sc_hd__and4bb_1 abstract view
.subckt sky130_fd_sc_hd__and4bb_1 A_N B_N C D VGND VNB VPB VPWR X
.ends

* Black-box entry subcircuit for sky130_fd_sc_hd__o31ai_1 abstract view
.subckt sky130_fd_sc_hd__o31ai_1 A1 A2 A3 B1 VGND VNB VPB VPWR Y
.ends

* Black-box entry subcircuit for sky130_fd_sc_hd__nor2_4 abstract view
.subckt sky130_fd_sc_hd__nor2_4 A B VGND VNB VPB VPWR Y
.ends

* Black-box entry subcircuit for sky130_fd_sc_hd__and4_1 abstract view
.subckt sky130_fd_sc_hd__and4_1 A B C D VGND VNB VPB VPWR X
.ends

* Black-box entry subcircuit for sky130_fd_sc_hd__nor3_1 abstract view
.subckt sky130_fd_sc_hd__nor3_1 A B C VGND VNB VPB VPWR Y
.ends

* Black-box entry subcircuit for sky130_fd_sc_hd__xor2_2 abstract view
.subckt sky130_fd_sc_hd__xor2_2 A B VGND VNB VPB VPWR X
.ends

* Black-box entry subcircuit for sky130_fd_sc_hd__o21ai_1 abstract view
.subckt sky130_fd_sc_hd__o21ai_1 A1 A2 B1 VGND VNB VPB VPWR Y
.ends

* Black-box entry subcircuit for sky130_fd_sc_hd__nand3_1 abstract view
.subckt sky130_fd_sc_hd__nand3_1 A B C VGND VNB VPB VPWR Y
.ends

* Black-box entry subcircuit for sky130_fd_sc_hd__o311a_1 abstract view
.subckt sky130_fd_sc_hd__o311a_1 A1 A2 A3 B1 C1 VGND VNB VPB VPWR X
.ends

* Black-box entry subcircuit for sky130_fd_sc_hd__a22oi_1 abstract view
.subckt sky130_fd_sc_hd__a22oi_1 A1 A2 B1 B2 VGND VNB VPB VPWR Y
.ends

* Black-box entry subcircuit for sky130_fd_sc_hd__o21bai_1 abstract view
.subckt sky130_fd_sc_hd__o21bai_1 A1 A2 B1_N VGND VNB VPB VPWR Y
.ends

* Black-box entry subcircuit for sky130_fd_sc_hd__nor2b_2 abstract view
.subckt sky130_fd_sc_hd__nor2b_2 A B_N VGND VNB VPB VPWR Y
.ends

* Black-box entry subcircuit for sky130_fd_sc_hd__a21bo_1 abstract view
.subckt sky130_fd_sc_hd__a21bo_1 A1 A2 B1_N VGND VNB VPB VPWR X
.ends

* Black-box entry subcircuit for sky130_fd_sc_hd__o21ba_1 abstract view
.subckt sky130_fd_sc_hd__o21ba_1 A1 A2 B1_N VGND VNB VPB VPWR X
.ends

* Black-box entry subcircuit for sky130_fd_sc_hd__xnor2_4 abstract view
.subckt sky130_fd_sc_hd__xnor2_4 A B VGND VNB VPB VPWR Y
.ends

* Black-box entry subcircuit for sky130_fd_sc_hd__a211o_1 abstract view
.subckt sky130_fd_sc_hd__a211o_1 A1 A2 B1 C1 VGND VNB VPB VPWR X
.ends

* Black-box entry subcircuit for sky130_fd_sc_hd__or3_4 abstract view
.subckt sky130_fd_sc_hd__or3_4 A B C VGND VNB VPB VPWR X
.ends

* Black-box entry subcircuit for sky130_fd_sc_hd__a21oi_2 abstract view
.subckt sky130_fd_sc_hd__a21oi_2 A1 A2 B1 VGND VNB VPB VPWR Y
.ends

* Black-box entry subcircuit for sky130_fd_sc_hd__a21oi_4 abstract view
.subckt sky130_fd_sc_hd__a21oi_4 A1 A2 B1 VGND VNB VPB VPWR Y
.ends

* Black-box entry subcircuit for sky130_fd_sc_hd__a21boi_1 abstract view
.subckt sky130_fd_sc_hd__a21boi_1 A1 A2 B1_N VGND VNB VPB VPWR Y
.ends

* Black-box entry subcircuit for sky130_fd_sc_hd__a21boi_2 abstract view
.subckt sky130_fd_sc_hd__a21boi_2 A1 A2 B1_N VGND VNB VPB VPWR Y
.ends

* Black-box entry subcircuit for sky130_fd_sc_hd__clkinv_4 abstract view
.subckt sky130_fd_sc_hd__clkinv_4 A VGND VNB VPB VPWR Y
.ends

* Black-box entry subcircuit for sky130_fd_sc_hd__a311o_1 abstract view
.subckt sky130_fd_sc_hd__a311o_1 A1 A2 A3 B1 C1 VGND VNB VPB VPWR X
.ends

* Black-box entry subcircuit for sky130_fd_sc_hd__and4b_1 abstract view
.subckt sky130_fd_sc_hd__and4b_1 A_N B C D VGND VNB VPB VPWR X
.ends

* Black-box entry subcircuit for sky130_fd_sc_hd__a31oi_1 abstract view
.subckt sky130_fd_sc_hd__a31oi_1 A1 A2 A3 B1 VGND VNB VPB VPWR Y
.ends

* Black-box entry subcircuit for sky130_fd_sc_hd__nor4_1 abstract view
.subckt sky130_fd_sc_hd__nor4_1 A B C D VGND VNB VPB VPWR Y
.ends

* Black-box entry subcircuit for sky130_fd_sc_hd__nand2b_1 abstract view
.subckt sky130_fd_sc_hd__nand2b_1 A_N B VGND VNB VPB VPWR Y
.ends

* Black-box entry subcircuit for sky130_fd_sc_hd__clkinvlp_2 abstract view
.subckt sky130_fd_sc_hd__clkinvlp_2 A VGND VNB VPB VPWR Y
.ends

* Black-box entry subcircuit for sky130_fd_sc_hd__or2_4 abstract view
.subckt sky130_fd_sc_hd__or2_4 A B VGND VNB VPB VPWR X
.ends

* Black-box entry subcircuit for sky130_fd_sc_hd__nand3b_1 abstract view
.subckt sky130_fd_sc_hd__nand3b_1 A_N B C VGND VNB VPB VPWR Y
.ends

* Black-box entry subcircuit for sky130_fd_sc_hd__a221o_1 abstract view
.subckt sky130_fd_sc_hd__a221o_1 A1 A2 B1 B2 C1 VGND VNB VPB VPWR X
.ends

* Black-box entry subcircuit for sky130_fd_sc_hd__bufinv_16 abstract view
.subckt sky130_fd_sc_hd__bufinv_16 A VGND VNB VPB VPWR Y
.ends

* Black-box entry subcircuit for sky130_fd_sc_hd__a211oi_1 abstract view
.subckt sky130_fd_sc_hd__a211oi_1 A1 A2 B1 C1 VGND VNB VPB VPWR Y
.ends

* Black-box entry subcircuit for sky130_fd_sc_hd__nand4_2 abstract view
.subckt sky130_fd_sc_hd__nand4_2 A B C D VGND VNB VPB VPWR Y
.ends

* Black-box entry subcircuit for sky130_fd_sc_hd__clkbuf_16 abstract view
.subckt sky130_fd_sc_hd__clkbuf_16 A VGND VNB VPB VPWR X
.ends

* Black-box entry subcircuit for sky130_fd_sc_hd__or3b_1 abstract view
.subckt sky130_fd_sc_hd__or3b_1 A B C_N VGND VNB VPB VPWR X
.ends

* Black-box entry subcircuit for sky130_fd_sc_hd__nand3_2 abstract view
.subckt sky130_fd_sc_hd__nand3_2 A B C VGND VNB VPB VPWR Y
.ends

* Black-box entry subcircuit for sky130_fd_sc_hd__inv_8 abstract view
.subckt sky130_fd_sc_hd__inv_8 A VGND VNB VPB VPWR Y
.ends

* Black-box entry subcircuit for sky130_fd_sc_hd__o21ai_2 abstract view
.subckt sky130_fd_sc_hd__o21ai_2 A1 A2 B1 VGND VNB VPB VPWR Y
.ends

* Black-box entry subcircuit for sky130_fd_sc_hd__inv_6 abstract view
.subckt sky130_fd_sc_hd__inv_6 A VGND VNB VPB VPWR Y
.ends

* Black-box entry subcircuit for sky130_fd_sc_hd__and3b_1 abstract view
.subckt sky130_fd_sc_hd__and3b_1 A_N B C VGND VNB VPB VPWR X
.ends

* Black-box entry subcircuit for sky130_fd_sc_hd__o22a_1 abstract view
.subckt sky130_fd_sc_hd__o22a_1 A1 A2 B1 B2 VGND VNB VPB VPWR X
.ends

* Black-box entry subcircuit for sky130_fd_sc_hd__o211ai_2 abstract view
.subckt sky130_fd_sc_hd__o211ai_2 A1 A2 B1 C1 VGND VNB VPB VPWR Y
.ends

* Black-box entry subcircuit for sky130_fd_sc_hd__a22oi_4 abstract view
.subckt sky130_fd_sc_hd__a22oi_4 A1 A2 B1 B2 VGND VNB VPB VPWR Y
.ends

* Black-box entry subcircuit for sky130_fd_sc_hd__dfxtp_4 abstract view
.subckt sky130_fd_sc_hd__dfxtp_4 CLK D VGND VNB VPB VPWR Q
.ends

* Black-box entry subcircuit for sky130_fd_sc_hd__a311o_4 abstract view
.subckt sky130_fd_sc_hd__a311o_4 A1 A2 A3 B1 C1 VGND VNB VPB VPWR X
.ends

* Black-box entry subcircuit for sky130_fd_sc_hd__a21o_2 abstract view
.subckt sky130_fd_sc_hd__a21o_2 A1 A2 B1 VGND VNB VPB VPWR X
.ends

* Black-box entry subcircuit for sky130_fd_sc_hd__buf_1 abstract view
.subckt sky130_fd_sc_hd__buf_1 A VGND VNB VPB VPWR X
.ends

* Black-box entry subcircuit for sky130_fd_sc_hd__o41a_1 abstract view
.subckt sky130_fd_sc_hd__o41a_1 A1 A2 A3 A4 B1 VGND VNB VPB VPWR X
.ends

* Black-box entry subcircuit for sky130_fd_sc_hd__buf_6 abstract view
.subckt sky130_fd_sc_hd__buf_6 A VGND VNB VPB VPWR X
.ends

* Black-box entry subcircuit for sky130_fd_sc_hd__dlymetal6s2s_1 abstract view
.subckt sky130_fd_sc_hd__dlymetal6s2s_1 A VGND VNB VPB VPWR X
.ends

* Black-box entry subcircuit for sky130_fd_sc_hd__nand4_4 abstract view
.subckt sky130_fd_sc_hd__nand4_4 A B C D VGND VNB VPB VPWR Y
.ends

* Black-box entry subcircuit for sky130_fd_sc_hd__nor4b_1 abstract view
.subckt sky130_fd_sc_hd__nor4b_1 A B C D_N VGND VNB VPB VPWR Y
.ends

* Black-box entry subcircuit for sky130_fd_sc_hd__o221a_1 abstract view
.subckt sky130_fd_sc_hd__o221a_1 A1 A2 B1 B2 C1 VGND VNB VPB VPWR X
.ends

* Black-box entry subcircuit for sky130_fd_sc_hd__and2_4 abstract view
.subckt sky130_fd_sc_hd__and2_4 A B VGND VNB VPB VPWR X
.ends

* Black-box entry subcircuit for sky130_fd_sc_hd__nand2_2 abstract view
.subckt sky130_fd_sc_hd__nand2_2 A B VGND VNB VPB VPWR Y
.ends

* Black-box entry subcircuit for sky130_fd_sc_hd__xor2_4 abstract view
.subckt sky130_fd_sc_hd__xor2_4 A B VGND VNB VPB VPWR X
.ends

* Black-box entry subcircuit for sky130_fd_sc_hd__nand4_1 abstract view
.subckt sky130_fd_sc_hd__nand4_1 A B C D VGND VNB VPB VPWR Y
.ends

* Black-box entry subcircuit for sky130_fd_sc_hd__a2111o_1 abstract view
.subckt sky130_fd_sc_hd__a2111o_1 A1 A2 B1 C1 D1 VGND VNB VPB VPWR X
.ends

* Black-box entry subcircuit for sky130_fd_sc_hd__a211o_4 abstract view
.subckt sky130_fd_sc_hd__a211o_4 A1 A2 B1 C1 VGND VNB VPB VPWR X
.ends

* Black-box entry subcircuit for sky130_fd_sc_hd__nor2_2 abstract view
.subckt sky130_fd_sc_hd__nor2_2 A B VGND VNB VPB VPWR Y
.ends

* Black-box entry subcircuit for sky130_fd_sc_hd__a221oi_1 abstract view
.subckt sky130_fd_sc_hd__a221oi_1 A1 A2 B1 B2 C1 VGND VNB VPB VPWR Y
.ends

* Black-box entry subcircuit for sky130_fd_sc_hd__o2111ai_1 abstract view
.subckt sky130_fd_sc_hd__o2111ai_1 A1 A2 B1 C1 D1 VGND VNB VPB VPWR Y
.ends

* Black-box entry subcircuit for sky130_fd_sc_hd__or4_1 abstract view
.subckt sky130_fd_sc_hd__or4_1 A B C D VGND VNB VPB VPWR X
.ends

* Black-box entry subcircuit for sky130_fd_sc_hd__or3b_4 abstract view
.subckt sky130_fd_sc_hd__or3b_4 A B C_N VGND VNB VPB VPWR X
.ends

* Black-box entry subcircuit for sky130_fd_sc_hd__o31ai_2 abstract view
.subckt sky130_fd_sc_hd__o31ai_2 A1 A2 A3 B1 VGND VNB VPB VPWR Y
.ends

* Black-box entry subcircuit for sky130_fd_sc_hd__o31a_1 abstract view
.subckt sky130_fd_sc_hd__o31a_1 A1 A2 A3 B1 VGND VNB VPB VPWR X
.ends

* Black-box entry subcircuit for sky130_fd_sc_hd__and3b_2 abstract view
.subckt sky130_fd_sc_hd__and3b_2 A_N B C VGND VNB VPB VPWR X
.ends

* Black-box entry subcircuit for sky130_fd_sc_hd__a31oi_2 abstract view
.subckt sky130_fd_sc_hd__a31oi_2 A1 A2 A3 B1 VGND VNB VPB VPWR Y
.ends

* Black-box entry subcircuit for sky130_fd_sc_hd__nand2_4 abstract view
.subckt sky130_fd_sc_hd__nand2_4 A B VGND VNB VPB VPWR Y
.ends

* Black-box entry subcircuit for sky130_fd_sc_hd__or4b_4 abstract view
.subckt sky130_fd_sc_hd__or4b_4 A B C D_N VGND VNB VPB VPWR X
.ends

* Black-box entry subcircuit for sky130_fd_sc_hd__nor4bb_2 abstract view
.subckt sky130_fd_sc_hd__nor4bb_2 A B C_N D_N VGND VNB VPB VPWR Y
.ends

* Black-box entry subcircuit for sky130_fd_sc_hd__a41o_1 abstract view
.subckt sky130_fd_sc_hd__a41o_1 A1 A2 A3 A4 B1 VGND VNB VPB VPWR X
.ends

* Black-box entry subcircuit for sky130_fd_sc_hd__a221oi_2 abstract view
.subckt sky130_fd_sc_hd__a221oi_2 A1 A2 B1 B2 C1 VGND VNB VPB VPWR Y
.ends

* Black-box entry subcircuit for sky130_fd_sc_hd__o211ai_1 abstract view
.subckt sky130_fd_sc_hd__o211ai_1 A1 A2 B1 C1 VGND VNB VPB VPWR Y
.ends

* Black-box entry subcircuit for sky130_fd_sc_hd__diode_2 abstract view
.subckt sky130_fd_sc_hd__diode_2 DIODE VGND VNB VPB VPWR
.ends

* Black-box entry subcircuit for sky130_fd_sc_hd__buf_8 abstract view
.subckt sky130_fd_sc_hd__buf_8 A VGND VNB VPB VPWR X
.ends

* Black-box entry subcircuit for sky130_fd_sc_hd__o21ai_4 abstract view
.subckt sky130_fd_sc_hd__o21ai_4 A1 A2 B1 VGND VNB VPB VPWR Y
.ends

.subckt top VGND VPWR clk m_tdata[0] m_tdata[10] m_tdata[11] m_tdata[12] m_tdata[13]
+ m_tdata[14] m_tdata[15] m_tdata[16] m_tdata[17] m_tdata[18] m_tdata[19] m_tdata[1]
+ m_tdata[20] m_tdata[21] m_tdata[22] m_tdata[23] m_tdata[24] m_tdata[25] m_tdata[26]
+ m_tdata[27] m_tdata[28] m_tdata[29] m_tdata[2] m_tdata[30] m_tdata[31] m_tdata[3]
+ m_tdata[4] m_tdata[5] m_tdata[6] m_tdata[7] m_tdata[8] m_tdata[9] m_tready m_tvalid
+ rst s_tdata[0] s_tdata[10] s_tdata[11] s_tdata[12] s_tdata[13] s_tdata[14] s_tdata[15]
+ s_tdata[16] s_tdata[17] s_tdata[18] s_tdata[19] s_tdata[1] s_tdata[20] s_tdata[21]
+ s_tdata[22] s_tdata[23] s_tdata[2] s_tdata[3] s_tdata[4] s_tdata[5] s_tdata[6] s_tdata[7]
+ s_tdata[8] s_tdata[9] s_tlast s_tready s_tvalid
X_3155_ _0387_ _0390_ _0407_ VGND VGND VPWR VPWR _0408_ sky130_fd_sc_hd__or3_1
X_3086_ _0339_ _0340_ VGND VGND VPWR VPWR _0341_ sky130_fd_sc_hd__nand2_1
XTAP_TAPCELL_ROW_65_732 VGND VPWR sky130_fd_sc_hd__tapvpwrvgnd_1
XFILLER_0_76_133 VGND VGND VPWR VPWR sky130_fd_sc_hd__decap_6
XTAP_TAPCELL_ROW_37_489 VGND VPWR sky130_fd_sc_hd__tapvpwrvgnd_1
X_3988_ _1159_ _1161_ _1211_ VGND VGND VPWR VPWR _1212_ sky130_fd_sc_hd__o21a_1
X_2939_ _0191_ _0196_ VGND VGND VPWR VPWR _0198_ sky130_fd_sc_hd__nand2_1
XTAP_TAPCELL_ROW_20_345 VGND VPWR sky130_fd_sc_hd__tapvpwrvgnd_1
XFILLER_0_32_269 VGND VGND VPWR VPWR sky130_fd_sc_hd__fill_1
X_4609_ _1775_ _1793_ VGND VGND VPWR VPWR _1794_ sky130_fd_sc_hd__and2_1
XTAP_TAPCELL_ROW_28_412 VGND VPWR sky130_fd_sc_hd__tapvpwrvgnd_1
XFILLER_0_23_18 VGND VGND VPWR VPWR sky130_fd_sc_hd__fill_1
XFILLER_0_23_29 VPWR VGND VPWR VGND sky130_ef_sc_hd__decap_12
XTAP_TAPCELL_ROW_71_779 VGND VPWR sky130_fd_sc_hd__tapvpwrvgnd_1
XFILLER_0_67_199 VPWR VGND VPWR VGND sky130_ef_sc_hd__decap_12
XFILLER_0_48_391 VGND VGND VPWR VPWR sky130_fd_sc_hd__fill_2
XFILLER_0_23_225 VGND VGND VPWR VPWR sky130_fd_sc_hd__decap_6
Xrebuffer7 net70 VGND VGND VPWR VPWR net71 sky130_fd_sc_hd__dlygate4sd1_1
XFILLER_0_23_269 VGND VGND VPWR VPWR sky130_fd_sc_hd__decap_4
XPHY_EDGE_ROW_39_Left_121 VGND VGND VPWR VPWR sky130_fd_sc_hd__decap_3
XFILLER_0_48_15 VPWR VGND VPWR VGND sky130_ef_sc_hd__decap_12
XFILLER_0_31_291 VPWR VGND VPWR VGND sky130_ef_sc_hd__decap_12
XTAP_TAPCELL_ROW_79_846 VGND VPWR sky130_fd_sc_hd__tapvpwrvgnd_1
XFILLER_0_3_39 VPWR VGND VPWR VGND sky130_ef_sc_hd__decap_12
XPHY_EDGE_ROW_48_Left_130 VGND VGND VPWR VPWR sky130_fd_sc_hd__decap_3
XTAP_TAPCELL_ROW_62_702 VGND VPWR sky130_fd_sc_hd__tapvpwrvgnd_1
X_3911_ _0468_ u_interface.u_compute_core.relu_data\[15\] _1087_ VGND VGND VPWR VPWR
+ _1136_ sky130_fd_sc_hd__and3_1
X_3842_ _1036_ _1037_ _1067_ VGND VGND VPWR VPWR _1069_ sky130_fd_sc_hd__a21oi_1
XFILLER_0_46_317 VGND VGND VPWR VPWR sky130_fd_sc_hd__decap_8
XFILLER_0_73_169 VGND VGND VPWR VPWR sky130_fd_sc_hd__decap_3
XFILLER_0_6_403 VGND VGND VPWR VPWR sky130_fd_sc_hd__fill_2
X_3773_ _0639_ u_interface.u_compute_core.relu_data\[12\] VGND VGND VPWR VPWR _1001_
+ sky130_fd_sc_hd__nand2_1
X_2724_ _2130_ _2131_ VGND VGND VPWR VPWR _2132_ sky130_fd_sc_hd__nand2_1
XFILLER_0_54_383 VPWR VGND VPWR VGND sky130_ef_sc_hd__decap_12
X_2655_ _2064_ u_interface.u_compute_core.mac_accum\[16\] VGND VGND VPWR VPWR _2073_
+ sky130_fd_sc_hd__or2_1
X_4325_ _0432_ _1893_ VGND VGND VPWR VPWR _1542_ sky130_fd_sc_hd__nand2_1
XFILLER_0_10_442 VGND VGND VPWR VPWR sky130_fd_sc_hd__fill_2
X_2586_ _2012_ _2013_ net105 _2006_ VGND VGND VPWR VPWR _0065_ sky130_fd_sc_hd__a2bb2o_1
X_4256_ _1439_ _1441_ VGND VGND VPWR VPWR _1474_ sky130_fd_sc_hd__or2_1
X_3207_ _0449_ VGND VGND VPWR VPWR _0450_ sky130_fd_sc_hd__clkbuf_2
X_4187_ _1297_ _1349_ _1347_ VGND VGND VPWR VPWR _1407_ sky130_fd_sc_hd__a21oi_1
X_3138_ _0390_ _0391_ net127 _2026_ VGND VGND VPWR VPWR _0104_ sky130_fd_sc_hd__a2bb2o_1
X_3069_ _0281_ _0324_ VGND VGND VPWR VPWR _0325_ sky130_fd_sc_hd__or2_1
XFILLER_0_49_111 VGND VGND VPWR VPWR sky130_fd_sc_hd__fill_1
XFILLER_0_49_177 VGND VGND VPWR VPWR sky130_fd_sc_hd__fill_1
XFILLER_0_72_180 VPWR VGND VPWR VGND sky130_ef_sc_hd__decap_12
XFILLER_0_18_29 VGND VGND VPWR VPWR sky130_fd_sc_hd__decap_6
XFILLER_0_28_306 VGND VGND VPWR VPWR sky130_fd_sc_hd__fill_2
XFILLER_0_68_475 VGND VGND VPWR VPWR sky130_fd_sc_hd__fill_1
XFILLER_0_55_169 VGND VGND VPWR VPWR sky130_fd_sc_hd__decap_6
XFILLER_0_3_417 VPWR VGND VPWR VGND sky130_ef_sc_hd__decap_12
X_2440_ _1813_ _1903_ VGND VGND VPWR VPWR _1904_ sky130_fd_sc_hd__and2_1
X_2371_ u_interface.u_compute_core.relu_data\[11\] VGND VGND VPWR VPWR _1853_ sky130_fd_sc_hd__buf_2
X_4110_ _1325_ _1330_ VGND VGND VPWR VPWR _1331_ sky130_fd_sc_hd__nor2b_1
XFILLER_0_75_57 VPWR VGND VPWR VGND sky130_ef_sc_hd__decap_12
XTAP_TAPCELL_ROW_39_507 VGND VPWR sky130_fd_sc_hd__tapvpwrvgnd_1
X_4041_ _1261_ _1263_ VGND VGND VPWR VPWR _1264_ sky130_fd_sc_hd__xnor2_1
XTAP_TAPCELL_ROW_47_573 VGND VPWR sky130_fd_sc_hd__tapvpwrvgnd_1
XFILLER_0_24_50 VGND VGND VPWR VPWR sky130_fd_sc_hd__decap_4
XFILLER_0_19_317 VGND VGND VPWR VPWR sky130_fd_sc_hd__decap_6
XFILLER_0_27_350 VPWR VGND VPWR VGND sky130_ef_sc_hd__decap_12
X_3825_ _0639_ _1856_ _1000_ _1051_ VGND VGND VPWR VPWR _1052_ sky130_fd_sc_hd__a31o_1
X_3756_ _0938_ _0983_ _0984_ _0667_ VGND VGND VPWR VPWR _0129_ sky130_fd_sc_hd__o211a_1
Xclkbuf_4_12_0_clk clknet_0_clk VGND VGND VPWR VPWR clknet_4_12_0_clk sky130_fd_sc_hd__clkbuf_8
X_2707_ _2095_ _2112_ _2116_ VGND VGND VPWR VPWR _2117_ sky130_fd_sc_hd__and3_1
XFILLER_0_71_3 VPWR VGND VPWR VGND sky130_ef_sc_hd__decap_12
X_3687_ _0863_ _0865_ VGND VGND VPWR VPWR _0917_ sky130_fd_sc_hd__and2_1
XFILLER_0_2_483 VGND VGND VPWR VPWR sky130_fd_sc_hd__fill_1
X_2638_ u_interface.u_compute_core.u_mac.product_reg\[14\] u_interface.u_compute_core.mac_accum\[14\]
+ VGND VGND VPWR VPWR _2058_ sky130_fd_sc_hd__or2_1
X_2569_ _1973_ _1997_ _1998_ _1980_ net103 VGND VGND VPWR VPWR _0063_ sky130_fd_sc_hd__a32o_1
X_4308_ _1467_ _1517_ _1518_ VGND VGND VPWR VPWR _1525_ sky130_fd_sc_hd__nor3b_1
X_4239_ _1456_ _1457_ VGND VGND VPWR VPWR _1458_ sky130_fd_sc_hd__nand2_1
XFILLER_0_69_217 VGND VGND VPWR VPWR sky130_fd_sc_hd__decap_6
XTAP_TAPCELL_ROW_81_874 VGND VPWR sky130_fd_sc_hd__tapvpwrvgnd_1
XTAP_TAPCELL_ROW_81_863 VGND VPWR sky130_fd_sc_hd__tapvpwrvgnd_1
XFILLER_0_65_423 VGND VGND VPWR VPWR sky130_fd_sc_hd__decap_3
XFILLER_0_37_147 VGND VGND VPWR VPWR sky130_fd_sc_hd__decap_8
XFILLER_0_37_169 VGND VGND VPWR VPWR sky130_fd_sc_hd__decap_4
XFILLER_0_52_106 VGND VGND VPWR VPWR sky130_fd_sc_hd__decap_8
XFILLER_0_20_19 VGND VGND VPWR VPWR sky130_fd_sc_hd__decap_8
XFILLER_0_33_331 VGND VGND VPWR VPWR sky130_fd_sc_hd__decap_4
XFILLER_0_52_139 VGND VGND VPWR VPWR sky130_fd_sc_hd__fill_1
XFILLER_0_0_29 VPWR VGND VPWR VGND sky130_ef_sc_hd__decap_12
XFILLER_0_61_15 VPWR VGND VPWR VGND sky130_ef_sc_hd__decap_12
XTAP_TAPCELL_ROW_44_554 VGND VPWR sky130_fd_sc_hd__tapvpwrvgnd_1
XFILLER_0_68_283 VGND VGND VPWR VPWR sky130_fd_sc_hd__fill_1
XFILLER_0_16_309 VGND VGND VPWR VPWR sky130_fd_sc_hd__fill_2
X_3610_ u_interface.core_attn_out\[9\] _0841_ VGND VGND VPWR VPWR _0842_ sky130_fd_sc_hd__xor2_1
X_4590_ _1775_ _1780_ VGND VGND VPWR VPWR _1781_ sky130_fd_sc_hd__and2_1
XFILLER_0_3_225 VPWR VGND VPWR VGND sky130_ef_sc_hd__decap_12
X_3541_ _0770_ _0773_ VGND VGND VPWR VPWR _0774_ sky130_fd_sc_hd__xnor2_2
X_3472_ net65 _0661_ _0659_ VGND VGND VPWR VPWR _0707_ sky130_fd_sc_hd__a21oi_1
X_2423_ u_interface.u_compute_core.scaled_data\[24\] _1814_ _1891_ _1816_ VGND VGND
+ VPWR VPWR _1892_ sky130_fd_sc_hd__o2bb2a_1
X_2354_ u_interface.u_compute_core.scaled_data\[7\] _1815_ _1839_ _1817_ VGND VGND
+ VPWR VPWR _1840_ sky130_fd_sc_hd__o2bb2a_1
X_4024_ _0423_ _1246_ _1197_ _0427_ VGND VGND VPWR VPWR _1247_ sky130_fd_sc_hd__a22o_1
XFILLER_0_66_209 VGND VGND VPWR VPWR sky130_fd_sc_hd__decap_8
XFILLER_0_74_253 VPWR VGND VPWR VGND sky130_ef_sc_hd__decap_12
XFILLER_0_19_169 VPWR VGND VPWR VGND sky130_ef_sc_hd__decap_12
XFILLER_0_74_297 VGND VGND VPWR VPWR sky130_fd_sc_hd__decap_4
X_3808_ _0978_ _1029_ _1027_ VGND VGND VPWR VPWR _1035_ sky130_fd_sc_hd__o21a_1
XFILLER_0_15_353 VPWR VGND VPWR VGND sky130_ef_sc_hd__decap_12
X_4788_ clknet_4_11_0_clk _0153_ VGND VGND VPWR VPWR net54 sky130_fd_sc_hd__dfxtp_1
XFILLER_0_70_470 VGND VGND VPWR VPWR sky130_fd_sc_hd__decap_6
X_3739_ _0965_ _0967_ VGND VGND VPWR VPWR _0968_ sky130_fd_sc_hd__xnor2_1
XTAP_TAPCELL_ROW_7_235 VGND VPWR sky130_fd_sc_hd__tapvpwrvgnd_1
XTAP_TAPCELL_ROW_58_668 VGND VPWR sky130_fd_sc_hd__tapvpwrvgnd_1
XFILLER_0_57_209 VGND VGND VPWR VPWR sky130_fd_sc_hd__fill_2
XFILLER_0_38_401 VPWR VGND VPWR VGND sky130_ef_sc_hd__decap_12
XFILLER_0_38_434 VGND VGND VPWR VPWR sky130_fd_sc_hd__fill_2
XTAP_TAPCELL_ROW_41_524 VGND VPWR sky130_fd_sc_hd__tapvpwrvgnd_1
XFILLER_0_25_117 VGND VGND VPWR VPWR sky130_fd_sc_hd__fill_1
XFILLER_0_53_426 VPWR VGND VPWR VGND sky130_ef_sc_hd__decap_12
XFILLER_0_18_191 VGND VGND VPWR VPWR sky130_fd_sc_hd__decap_4
XFILLER_0_40_109 VPWR VGND VPWR VGND sky130_ef_sc_hd__decap_12
XFILLER_0_21_378 VGND VGND VPWR VPWR sky130_fd_sc_hd__fill_2
XFILLER_0_56_15 VPWR VGND VPWR VGND sky130_ef_sc_hd__decap_12
XFILLER_0_56_37 VGND VGND VPWR VPWR sky130_fd_sc_hd__decap_3
X_2972_ _0228_ _0229_ VGND VGND VPWR VPWR _0230_ sky130_fd_sc_hd__nor2_1
XFILLER_0_29_423 VGND VGND VPWR VPWR sky130_fd_sc_hd__decap_6
XFILLER_0_29_445 VGND VGND VPWR VPWR sky130_fd_sc_hd__decap_3
XFILLER_0_56_220 VGND VGND VPWR VPWR sky130_fd_sc_hd__fill_2
XFILLER_0_16_106 VPWR VGND VPWR VGND sky130_ef_sc_hd__decap_12
X_4711_ clknet_4_4_0_clk _0076_ VGND VGND VPWR VPWR u_interface.u_compute_core.mac_accum\[17\]
+ sky130_fd_sc_hd__dfxtp_1
XFILLER_0_56_253 VGND VGND VPWR VPWR sky130_fd_sc_hd__fill_1
XFILLER_0_16_139 VGND VGND VPWR VPWR sky130_fd_sc_hd__fill_1
X_4642_ clknet_4_3_0_clk _0007_ VGND VGND VPWR VPWR u_interface.u_compute_core.relu_data\[7\]
+ sky130_fd_sc_hd__dfxtp_2
XFILLER_0_56_297 VGND VGND VPWR VPWR sky130_fd_sc_hd__decap_8
XFILLER_0_71_278 VGND VGND VPWR VPWR sky130_fd_sc_hd__fill_2
XTAP_TAPCELL_ROW_12_281 VGND VPWR sky130_fd_sc_hd__tapvpwrvgnd_1
X_4573_ net32 u_interface.core_attn_out\[12\] _1760_ VGND VGND VPWR VPWR _1769_ sky130_fd_sc_hd__mux2_1
X_3524_ _0715_ _0757_ VGND VGND VPWR VPWR _0758_ sky130_fd_sc_hd__nand2_1
X_3455_ _0437_ _1832_ _0641_ VGND VGND VPWR VPWR _0690_ sky130_fd_sc_hd__and3_1
X_2406_ net2 VGND VGND VPWR VPWR _1879_ sky130_fd_sc_hd__buf_4
X_3386_ _0588_ _0584_ VGND VGND VPWR VPWR _0622_ sky130_fd_sc_hd__and2b_1
X_2337_ u_interface.u_compute_core.relu_data\[3\] VGND VGND VPWR VPWR _1827_ sky130_fd_sc_hd__inv_2
XFILLER_0_34_3 VGND VGND VPWR VPWR sky130_fd_sc_hd__decap_4
XFILLER_0_79_334 VGND VGND VPWR VPWR sky130_fd_sc_hd__fill_2
XFILLER_0_79_312 VGND VGND VPWR VPWR sky130_fd_sc_hd__fill_1
X_4007_ _1228_ _1229_ VGND VGND VPWR VPWR _1230_ sky130_fd_sc_hd__xnor2_1
XFILLER_0_39_209 VPWR VGND VPWR VGND sky130_ef_sc_hd__decap_12
XFILLER_0_1_83 VPWR VGND VPWR VGND sky130_ef_sc_hd__decap_12
XFILLER_0_47_242 VPWR VGND VPWR VGND sky130_ef_sc_hd__decap_12
XFILLER_0_62_212 VGND VGND VPWR VPWR sky130_fd_sc_hd__fill_2
XFILLER_0_50_418 VGND VGND VPWR VPWR sky130_fd_sc_hd__fill_2
XFILLER_0_30_120 VGND VGND VPWR VPWR sky130_fd_sc_hd__decap_6
Xhold41 u_interface.u_compute_core.mac_accum\[6\] VGND VGND VPWR VPWR net105 sky130_fd_sc_hd__dlygate4sd3_1
Xhold30 u_interface.u_compute_core.scaled_data\[0\] VGND VGND VPWR VPWR net94 sky130_fd_sc_hd__dlygate4sd3_1
XFILLER_0_26_29 VPWR VGND VPWR VGND sky130_ef_sc_hd__decap_12
Xhold63 u_interface.u_compute_core.u_mac.product_reg\[13\] VGND VGND VPWR VPWR net127
+ sky130_fd_sc_hd__dlygate4sd3_1
Xhold52 u_interface.u_compute_core.mac_accum\[0\] VGND VGND VPWR VPWR net116 sky130_fd_sc_hd__dlygate4sd3_1
Xhold74 u_interface.u_compute_core.mac_accum\[16\] VGND VGND VPWR VPWR net138 sky130_fd_sc_hd__dlygate4sd3_1
Xhold85 u_interface.u_compute_core.mac_accum\[13\] VGND VGND VPWR VPWR net149 sky130_fd_sc_hd__dlygate4sd3_1
XTAP_TAPCELL_ROW_18_329 VGND VPWR sky130_fd_sc_hd__tapvpwrvgnd_1
XTAP_TAPCELL_ROW_26_395 VGND VPWR sky130_fd_sc_hd__tapvpwrvgnd_1
XFILLER_0_38_253 VPWR VGND VPWR VGND sky130_ef_sc_hd__decap_12
XPHY_EDGE_ROW_20_Left_102 VGND VGND VPWR VPWR sky130_fd_sc_hd__decap_3
XFILLER_0_53_256 VGND VGND VPWR VPWR sky130_fd_sc_hd__decap_8
XFILLER_0_21_175 VGND VGND VPWR VPWR sky130_fd_sc_hd__fill_1
X_3240_ _1967_ VGND VGND VPWR VPWR _0480_ sky130_fd_sc_hd__buf_2
X_3171_ _1812_ VGND VGND VPWR VPWR _0420_ sky130_fd_sc_hd__clkbuf_4
Xrebuffer17 _0792_ VGND VGND VPWR VPWR net81 sky130_fd_sc_hd__dlygate4sd1_1
XTAP_TAPCELL_ROW_52_619 VGND VPWR sky130_fd_sc_hd__tapvpwrvgnd_1
XFILLER_0_17_426 VGND VGND VPWR VPWR sky130_fd_sc_hd__decap_3
X_2955_ _0182_ _2303_ _0213_ VGND VGND VPWR VPWR _0214_ sky130_fd_sc_hd__a21oi_1
XFILLER_0_32_83 VGND VGND VPWR VPWR sky130_fd_sc_hd__fill_1
X_2886_ net12 net7 net9 VGND VGND VPWR VPWR _2281_ sky130_fd_sc_hd__a21o_1
XTAP_TAPCELL_ROW_60_685 VGND VPWR sky130_fd_sc_hd__tapvpwrvgnd_1
X_4625_ _1804_ VGND VGND VPWR VPWR _0178_ sky130_fd_sc_hd__clkbuf_1
X_4556_ _1757_ VGND VGND VPWR VPWR _0156_ sky130_fd_sc_hd__clkbuf_1
XFILLER_0_12_120 VGND VGND VPWR VPWR sky130_fd_sc_hd__decap_4
X_3507_ _0693_ _0695_ VGND VGND VPWR VPWR _0741_ sky130_fd_sc_hd__or2_1
XFILLER_0_40_451 VPWR VGND VPWR VGND sky130_ef_sc_hd__decap_12
X_4487_ _1691_ _1689_ _1695_ _1698_ _1699_ VGND VGND VPWR VPWR _1700_ sky130_fd_sc_hd__o221a_4
X_3438_ _0628_ _0671_ _0672_ VGND VGND VPWR VPWR _0673_ sky130_fd_sc_hd__a21o_1
X_3369_ _0590_ _0605_ VGND VGND VPWR VPWR _0606_ sky130_fd_sc_hd__xnor2_1
XTAP_TAPCELL_ROW_68_752 VGND VPWR sky130_fd_sc_hd__tapvpwrvgnd_1
XPHY_EDGE_ROW_11_Left_93 VGND VGND VPWR VPWR sky130_fd_sc_hd__decap_3
XFILLER_0_67_337 VPWR VGND VPWR VGND sky130_ef_sc_hd__decap_12
XFILLER_0_35_256 VPWR VGND VPWR VGND sky130_ef_sc_hd__decap_12
Xoutput31 net31 VGND VGND VPWR VPWR m_tdata[11] sky130_fd_sc_hd__buf_2
Xoutput42 net42 VGND VGND VPWR VPWR m_tdata[21] sky130_fd_sc_hd__buf_2
Xoutput53 net53 VGND VGND VPWR VPWR m_tdata[31] sky130_fd_sc_hd__buf_2
XFILLER_0_58_304 VGND VGND VPWR VPWR sky130_fd_sc_hd__decap_4
XFILLER_0_26_223 VGND VGND VPWR VPWR sky130_fd_sc_hd__decap_4
X_2740_ _2020_ _2144_ _2145_ _2100_ net106 VGND VGND VPWR VPWR _0087_ sky130_fd_sc_hd__a32o_1
XFILLER_0_81_373 VGND VGND VPWR VPWR sky130_fd_sc_hd__decap_8
X_2671_ _2085_ _2086_ VGND VGND VPWR VPWR _2087_ sky130_fd_sc_hd__nand2_1
X_4410_ _1623_ _1617_ VGND VGND VPWR VPWR _1625_ sky130_fd_sc_hd__and2b_1
X_4341_ _1556_ _1531_ VGND VGND VPWR VPWR _1558_ sky130_fd_sc_hd__or2b_1
X_4272_ _1431_ _1430_ VGND VGND VPWR VPWR _1490_ sky130_fd_sc_hd__and2b_1
X_3223_ _0461_ _0462_ _1824_ _0463_ VGND VGND VPWR VPWR _0464_ sky130_fd_sc_hd__and4bb_1
X_3154_ _0405_ _0406_ VGND VGND VPWR VPWR _0407_ sky130_fd_sc_hd__and2_1
X_3085_ _0299_ _0302_ _0338_ VGND VGND VPWR VPWR _0340_ sky130_fd_sc_hd__or3_1
XFILLER_0_49_337 VGND VGND VPWR VPWR sky130_fd_sc_hd__fill_2
XFILLER_0_9_423 VPWR VGND VPWR VGND sky130_ef_sc_hd__decap_12
X_3987_ _1158_ _1157_ VGND VGND VPWR VPWR _1211_ sky130_fd_sc_hd__or2b_1
XFILLER_0_57_381 VGND VGND VPWR VPWR sky130_fd_sc_hd__decap_8
X_2938_ _0191_ _0196_ VGND VGND VPWR VPWR _0197_ sky130_fd_sc_hd__or2_1
XTAP_TAPCELL_ROW_20_346 VGND VPWR sky130_fd_sc_hd__tapvpwrvgnd_1
XFILLER_0_72_395 VPWR VGND VPWR VGND sky130_ef_sc_hd__decap_12
X_2869_ _2223_ VGND VGND VPWR VPWR _2265_ sky130_fd_sc_hd__inv_2
X_4608_ net44 u_interface.core_attn_out\[23\] _1782_ VGND VGND VPWR VPWR _1793_ sky130_fd_sc_hd__mux2_1
X_4539_ _1742_ _0481_ _1879_ VGND VGND VPWR VPWR _1746_ sky130_fd_sc_hd__a21oi_1
XTAP_TAPCELL_ROW_28_413 VGND VPWR sky130_fd_sc_hd__tapvpwrvgnd_1
XFILLER_0_67_167 VGND VGND VPWR VPWR sky130_fd_sc_hd__fill_1
XFILLER_0_2_109 VPWR VGND VPWR VGND sky130_ef_sc_hd__decap_12
Xrebuffer8 _0500_ VGND VGND VPWR VPWR net72 sky130_fd_sc_hd__dlygate4sd1_1
XFILLER_0_31_281 VGND VGND VPWR VPWR sky130_fd_sc_hd__decap_6
XFILLER_0_48_27 VGND VGND VPWR VPWR sky130_fd_sc_hd__fill_1
XTAP_TAPCELL_ROW_79_847 VGND VPWR sky130_fd_sc_hd__tapvpwrvgnd_1
XFILLER_0_64_15 VPWR VGND VPWR VGND sky130_ef_sc_hd__decap_12
XTAP_TAPCELL_ROW_62_703 VGND VPWR sky130_fd_sc_hd__tapvpwrvgnd_1
X_3910_ _1133_ _1134_ VGND VGND VPWR VPWR _1135_ sky130_fd_sc_hd__xnor2_1
X_3841_ _1036_ _1037_ _1067_ VGND VGND VPWR VPWR _1068_ sky130_fd_sc_hd__and3_1
X_3772_ _0998_ _0999_ VGND VGND VPWR VPWR _1000_ sky130_fd_sc_hd__xnor2_2
X_2723_ _2067_ u_interface.u_compute_core.mac_accum\[26\] VGND VGND VPWR VPWR _2131_
+ sky130_fd_sc_hd__nand2_1
XFILLER_0_81_181 VPWR VGND VPWR VGND sky130_ef_sc_hd__decap_12
XFILLER_0_54_395 VPWR VGND VPWR VGND sky130_ef_sc_hd__decap_12
X_2654_ _2071_ _2072_ net145 _2006_ VGND VGND VPWR VPWR _0074_ sky130_fd_sc_hd__a2bb2o_1
X_2585_ _1999_ _2011_ _2008_ _2004_ VGND VGND VPWR VPWR _2013_ sky130_fd_sc_hd__a31o_1
X_4324_ _1539_ _1540_ VGND VGND VPWR VPWR _1541_ sky130_fd_sc_hd__nor2_1
XFILLER_0_22_292 VGND VGND VPWR VPWR sky130_fd_sc_hd__fill_2
X_4255_ _1453_ _1451_ VGND VGND VPWR VPWR _1473_ sky130_fd_sc_hd__or2b_1
X_3206_ u_interface.u_compute_core.u_av.v_extended\[6\] VGND VGND VPWR VPWR _0449_
+ sky130_fd_sc_hd__buf_2
X_4186_ _1404_ _1405_ VGND VGND VPWR VPWR _1406_ sky130_fd_sc_hd__nand2_1
X_3137_ _0360_ _0363_ _0389_ _2032_ VGND VGND VPWR VPWR _0391_ sky130_fd_sc_hd__o31ai_1
XFILLER_0_77_432 VGND VGND VPWR VPWR sky130_fd_sc_hd__fill_1
X_3068_ _0322_ _0323_ VGND VGND VPWR VPWR _0324_ sky130_fd_sc_hd__nand2_1
XFILLER_0_49_167 VGND VGND VPWR VPWR sky130_fd_sc_hd__fill_1
XTAP_TAPCELL_ROW_33_460 VGND VPWR sky130_fd_sc_hd__tapvpwrvgnd_1
XFILLER_0_72_192 VGND VGND VPWR VPWR sky130_fd_sc_hd__decap_4
XFILLER_0_60_332 VGND VGND VPWR VPWR sky130_fd_sc_hd__fill_1
XFILLER_0_13_281 VGND VGND VPWR VPWR sky130_fd_sc_hd__fill_1
XFILLER_0_34_29 VGND VGND VPWR VPWR sky130_fd_sc_hd__decap_4
XFILLER_0_55_137 VGND VGND VPWR VPWR sky130_fd_sc_hd__fill_2
XFILLER_0_70_107 VGND VGND VPWR VPWR sky130_fd_sc_hd__decap_4
XFILLER_0_3_429 VPWR VGND VPWR VGND sky130_ef_sc_hd__decap_12
XFILLER_0_59_15 VPWR VGND VPWR VGND sky130_ef_sc_hd__decap_12
X_2370_ _1848_ _1852_ VGND VGND VPWR VPWR _0010_ sky130_fd_sc_hd__nor2_1
XFILLER_0_75_69 VPWR VGND VPWR VGND sky130_ef_sc_hd__decap_12
XTAP_TAPCELL_ROW_39_508 VGND VPWR sky130_fd_sc_hd__tapvpwrvgnd_1
X_4040_ _1207_ _1209_ _1262_ VGND VGND VPWR VPWR _1263_ sky130_fd_sc_hd__o21a_1
XTAP_TAPCELL_ROW_47_574 VGND VPWR sky130_fd_sc_hd__tapvpwrvgnd_1
XFILLER_0_24_40 VGND VGND VPWR VPWR sky130_fd_sc_hd__fill_2
XFILLER_0_19_329 VGND VGND VPWR VPWR sky130_fd_sc_hd__decap_6
XFILLER_0_27_362 VPWR VGND VPWR VGND sky130_ef_sc_hd__decap_12
XTAP_TAPCELL_ROW_30_430 VGND VPWR sky130_fd_sc_hd__tapvpwrvgnd_1
X_3824_ _0484_ u_interface.u_compute_core.relu_data\[13\] _0998_ VGND VGND VPWR VPWR
+ _1051_ sky130_fd_sc_hd__and3_1
X_3755_ u_interface.core_attn_out\[12\] _0713_ VGND VGND VPWR VPWR _0984_ sky130_fd_sc_hd__or2_1
X_3686_ _0907_ _0915_ VGND VGND VPWR VPWR _0916_ sky130_fd_sc_hd__xnor2_2
X_2706_ _2094_ _2101_ _2107_ VGND VGND VPWR VPWR _2116_ sky130_fd_sc_hd__and3_1
XPHY_EDGE_ROW_12_Right_12 VGND VGND VPWR VPWR sky130_fd_sc_hd__decap_3
XFILLER_0_42_387 VGND VGND VPWR VPWR sky130_fd_sc_hd__decap_8
X_2637_ u_interface.u_compute_core.u_mac.product_reg\[14\] u_interface.u_compute_core.mac_accum\[14\]
+ VGND VGND VPWR VPWR _2057_ sky130_fd_sc_hd__nand2_1
XFILLER_0_64_3 VPWR VGND VPWR VGND sky130_ef_sc_hd__decap_12
X_2568_ _1994_ _1995_ _1996_ VGND VGND VPWR VPWR _1998_ sky130_fd_sc_hd__a21o_1
X_2499_ u_interface.u_compute_core.mac_last VGND VGND VPWR VPWR _1944_ sky130_fd_sc_hd__clkbuf_4
X_4307_ net125 _0715_ _0434_ _1524_ VGND VGND VPWR VPWR _0140_ sky130_fd_sc_hd__o211a_1
X_4238_ _1454_ _1455_ VGND VGND VPWR VPWR _1457_ sky130_fd_sc_hd__nand2_1
XFILLER_0_4_83 VGND VGND VPWR VPWR sky130_fd_sc_hd__fill_1
X_4169_ _1387_ _1388_ VGND VGND VPWR VPWR _1389_ sky130_fd_sc_hd__nor2_1
XPHY_EDGE_ROW_21_Right_21 VGND VGND VPWR VPWR sky130_fd_sc_hd__decap_3
XTAP_TAPCELL_ROW_81_875 VGND VPWR sky130_fd_sc_hd__tapvpwrvgnd_1
XTAP_TAPCELL_ROW_81_864 VGND VPWR sky130_fd_sc_hd__tapvpwrvgnd_1
XPHY_EDGE_ROW_67_Left_149 VGND VGND VPWR VPWR sky130_fd_sc_hd__decap_3
XFILLER_0_18_362 VGND VGND VPWR VPWR sky130_fd_sc_hd__fill_2
XPHY_EDGE_ROW_30_Right_30 VGND VGND VPWR VPWR sky130_fd_sc_hd__decap_3
XFILLER_0_33_343 VPWR VGND VPWR VGND sky130_ef_sc_hd__decap_12
XFILLER_0_60_195 VGND VGND VPWR VPWR sky130_fd_sc_hd__fill_1
XPHY_EDGE_ROW_76_Left_158 VGND VGND VPWR VPWR sky130_fd_sc_hd__decap_3
XFILLER_0_56_402 VGND VGND VPWR VPWR sky130_fd_sc_hd__decap_8
XFILLER_0_61_27 VPWR VGND VPWR VGND sky130_ef_sc_hd__decap_12
XFILLER_0_71_405 VGND VGND VPWR VPWR sky130_fd_sc_hd__decap_6
XFILLER_0_71_449 VGND VGND VPWR VPWR sky130_fd_sc_hd__decap_4
X_3540_ _0771_ _0772_ VGND VGND VPWR VPWR _0773_ sky130_fd_sc_hd__nor2_1
XFILLER_0_3_237 VPWR VGND VPWR VGND sky130_ef_sc_hd__decap_12
XFILLER_0_24_365 VGND VGND VPWR VPWR sky130_fd_sc_hd__decap_3
X_3471_ _0705_ _0704_ VGND VGND VPWR VPWR _0706_ sky130_fd_sc_hd__nor2_4
X_2422_ _1890_ VGND VGND VPWR VPWR _1891_ sky130_fd_sc_hd__inv_2
X_2353_ _1838_ VGND VGND VPWR VPWR _1839_ sky130_fd_sc_hd__inv_2
XFILLER_0_19_62 VPWR VGND VPWR VGND sky130_ef_sc_hd__decap_12
X_4023_ u_interface.u_compute_core.relu_data\[21\] VGND VGND VPWR VPWR _1246_ sky130_fd_sc_hd__buf_2
XFILLER_0_74_265 VGND VGND VPWR VPWR sky130_fd_sc_hd__fill_2
XFILLER_0_15_310 VPWR VGND VPWR VGND sky130_ef_sc_hd__decap_12
X_3807_ _0981_ _1028_ _1029_ VGND VGND VPWR VPWR _1034_ sky130_fd_sc_hd__or3_1
XFILLER_0_15_343 VGND VGND VPWR VPWR sky130_fd_sc_hd__fill_2
X_4787_ clknet_4_11_0_clk _0152_ VGND VGND VPWR VPWR net51 sky130_fd_sc_hd__dfxtp_1
XFILLER_0_27_181 VGND VGND VPWR VPWR sky130_fd_sc_hd__decap_4
XFILLER_0_15_365 VGND VGND VPWR VPWR sky130_fd_sc_hd__fill_1
XFILLER_0_30_302 VGND VGND VPWR VPWR sky130_fd_sc_hd__fill_1
X_3738_ _0907_ _0915_ _0966_ VGND VGND VPWR VPWR _0967_ sky130_fd_sc_hd__a21oi_1
X_3669_ _0459_ _0456_ u_interface.u_compute_core.relu_data\[14\] u_interface.u_compute_core.relu_data\[13\]
+ VGND VGND VPWR VPWR _0899_ sky130_fd_sc_hd__and4_1
XFILLER_0_42_195 VGND VGND VPWR VPWR sky130_fd_sc_hd__fill_1
XTAP_TAPCELL_ROW_7_236 VGND VPWR sky130_fd_sc_hd__tapvpwrvgnd_1
XTAP_TAPCELL_ROW_58_669 VGND VPWR sky130_fd_sc_hd__tapvpwrvgnd_1
XTAP_TAPCELL_ROW_41_525 VGND VPWR sky130_fd_sc_hd__tapvpwrvgnd_1
XFILLER_0_80_224 VPWR VGND VPWR VGND sky130_ef_sc_hd__decap_12
XFILLER_0_53_438 VGND VGND VPWR VPWR sky130_fd_sc_hd__decap_4
XFILLER_0_33_151 VGND VGND VPWR VPWR sky130_fd_sc_hd__fill_2
XFILLER_0_56_27 VGND VGND VPWR VPWR sky130_fd_sc_hd__fill_1
XFILLER_0_72_15 VPWR VGND VPWR VGND sky130_ef_sc_hd__decap_12
Xclkbuf_4_11_0_clk clknet_0_clk VGND VGND VPWR VPWR clknet_4_11_0_clk sky130_fd_sc_hd__clkbuf_8
XFILLER_0_8_307 VGND VGND VPWR VPWR sky130_fd_sc_hd__fill_1
X_2971_ _0225_ _0226_ _0227_ VGND VGND VPWR VPWR _0229_ sky130_fd_sc_hd__nor3_1
X_4710_ clknet_4_4_0_clk _0075_ VGND VGND VPWR VPWR u_interface.u_compute_core.mac_accum\[16\]
+ sky130_fd_sc_hd__dfxtp_1
XFILLER_0_16_118 VGND VGND VPWR VPWR sky130_fd_sc_hd__decap_8
X_4641_ clknet_4_2_0_clk _0006_ VGND VGND VPWR VPWR u_interface.u_compute_core.relu_data\[6\]
+ sky130_fd_sc_hd__dfxtp_2
XTAP_TAPCELL_ROW_12_282 VGND VPWR sky130_fd_sc_hd__tapvpwrvgnd_1
X_4572_ _1768_ VGND VGND VPWR VPWR _0161_ sky130_fd_sc_hd__clkbuf_1
X_3523_ _0754_ _0756_ VGND VGND VPWR VPWR _0757_ sky130_fd_sc_hd__xor2_1
XFILLER_0_24_195 VGND VGND VPWR VPWR sky130_fd_sc_hd__fill_1
XFILLER_0_12_379 VGND VGND VPWR VPWR sky130_fd_sc_hd__fill_1
X_3454_ _0441_ VGND VGND VPWR VPWR _0689_ sky130_fd_sc_hd__clkbuf_4
X_2405_ _1848_ _1878_ VGND VGND VPWR VPWR _0019_ sky130_fd_sc_hd__nor2_1
X_3385_ _0580_ _0613_ _0611_ VGND VGND VPWR VPWR _0621_ sky130_fd_sc_hd__a21o_1
XTAP_TAPCELL_ROW_4_206 VGND VPWR sky130_fd_sc_hd__tapvpwrvgnd_1
X_2336_ _1820_ _1826_ VGND VGND VPWR VPWR _0002_ sky130_fd_sc_hd__nor2_1
XFILLER_0_79_324 VGND VGND VPWR VPWR sky130_fd_sc_hd__decap_3
XFILLER_0_27_3 VPWR VGND VPWR VGND sky130_ef_sc_hd__decap_12
X_4006_ _0437_ u_interface.u_compute_core.relu_data\[18\] VGND VGND VPWR VPWR _1229_
+ sky130_fd_sc_hd__nand2_1
XFILLER_0_1_51 VGND VGND VPWR VPWR sky130_fd_sc_hd__decap_4
XFILLER_0_1_95 VPWR VGND VPWR VGND sky130_ef_sc_hd__decap_12
XFILLER_0_47_254 VPWR VGND VPWR VGND sky130_ef_sc_hd__decap_12
XFILLER_0_62_224 VPWR VGND VPWR VGND sky130_ef_sc_hd__decap_12
XFILLER_0_35_449 VPWR VGND VPWR VGND sky130_ef_sc_hd__decap_12
XFILLER_0_15_173 VPWR VGND VPWR VGND sky130_ef_sc_hd__decap_12
Xhold31 u_interface.u_compute_core.u_mac.product_reg\[8\] VGND VGND VPWR VPWR net95
+ sky130_fd_sc_hd__dlygate4sd3_1
Xhold64 u_interface.u_compute_core.mac_accum\[26\] VGND VGND VPWR VPWR net128 sky130_fd_sc_hd__dlygate4sd3_1
Xhold53 _1970_ VGND VGND VPWR VPWR net117 sky130_fd_sc_hd__dlygate4sd3_1
Xhold42 u_interface.u_compute_core.mac_accum\[28\] VGND VGND VPWR VPWR net106 sky130_fd_sc_hd__dlygate4sd3_1
Xhold86 u_interface.u_compute_core.scaled_data\[10\] VGND VGND VPWR VPWR net150 sky130_fd_sc_hd__dlygate4sd3_1
Xhold75 u_interface.u_compute_core.mac_accum\[24\] VGND VGND VPWR VPWR net139 sky130_fd_sc_hd__dlygate4sd3_1
XFILLER_0_42_29 VGND VGND VPWR VPWR sky130_fd_sc_hd__fill_1
XTAP_TAPCELL_ROW_26_396 VGND VPWR sky130_fd_sc_hd__tapvpwrvgnd_1
XFILLER_0_38_265 VGND VGND VPWR VPWR sky130_fd_sc_hd__decap_4
XFILLER_0_38_276 VPWR VGND VPWR VGND sky130_ef_sc_hd__decap_12
XFILLER_0_53_268 VGND VGND VPWR VPWR sky130_fd_sc_hd__decap_6
XFILLER_0_21_110 VGND VGND VPWR VPWR sky130_fd_sc_hd__fill_2
XFILLER_0_21_121 VPWR VGND VPWR VGND sky130_ef_sc_hd__decap_12
XFILLER_0_6_29 VGND VGND VPWR VPWR sky130_fd_sc_hd__decap_3
XFILLER_0_67_15 VPWR VGND VPWR VGND sky130_ef_sc_hd__decap_12
X_3170_ _0419_ VGND VGND VPWR VPWR _0108_ sky130_fd_sc_hd__clkbuf_1
Xrebuffer18 _0927_ VGND VGND VPWR VPWR net82 sky130_fd_sc_hd__dlygate4sd1_1
XFILLER_0_16_52 VPWR VGND VPWR VGND sky130_ef_sc_hd__decap_12
XFILLER_0_16_41 VGND VGND VPWR VPWR sky130_fd_sc_hd__decap_4
XFILLER_0_29_221 VGND VGND VPWR VPWR sky130_fd_sc_hd__decap_3
XFILLER_0_29_232 VGND VGND VPWR VPWR sky130_fd_sc_hd__decap_4
XFILLER_0_32_40 VGND VGND VPWR VPWR sky130_fd_sc_hd__fill_1
X_2954_ _0211_ _0212_ VGND VGND VPWR VPWR _0213_ sky130_fd_sc_hd__xnor2_1
X_2885_ _2278_ _2279_ VGND VGND VPWR VPWR _2280_ sky130_fd_sc_hd__xnor2_1
XFILLER_0_44_257 VGND VGND VPWR VPWR sky130_fd_sc_hd__fill_1
XTAP_TAPCELL_ROW_60_686 VGND VPWR sky130_fd_sc_hd__tapvpwrvgnd_1
X_4624_ _1901_ _1803_ VGND VGND VPWR VPWR _1804_ sky130_fd_sc_hd__and2_1
XPHY_EDGE_ROW_6_Right_6 VGND VGND VPWR VPWR sky130_fd_sc_hd__decap_3
XFILLER_0_4_321 VPWR VGND VPWR VGND sky130_ef_sc_hd__decap_12
X_4555_ _1753_ _1756_ VGND VGND VPWR VPWR _1757_ sky130_fd_sc_hd__and2_1
XFILLER_0_4_365 VPWR VGND VPWR VGND sky130_ef_sc_hd__decap_12
X_3506_ _0739_ _0722_ VGND VGND VPWR VPWR _0740_ sky130_fd_sc_hd__xor2_2
XFILLER_0_40_463 VPWR VGND VPWR VGND sky130_ef_sc_hd__decap_12
X_4486_ net84 VGND VGND VPWR VPWR _1699_ sky130_fd_sc_hd__inv_2
XFILLER_0_12_165 VPWR VGND VPWR VGND sky130_ef_sc_hd__decap_12
X_3437_ u_interface.u_compute_core.u_av.v_extended\[1\] u_interface.u_compute_core.u_av.v_extended\[0\]
+ u_interface.u_compute_core.relu_data\[9\] u_interface.u_compute_core.relu_data\[8\]
+ VGND VGND VPWR VPWR _0672_ sky130_fd_sc_hd__and4_1
X_3368_ _0603_ _0604_ VGND VGND VPWR VPWR _0605_ sky130_fd_sc_hd__xor2_1
X_2319_ _1812_ VGND VGND VPWR VPWR net62 sky130_fd_sc_hd__clkbuf_4
XFILLER_0_57_81 VPWR VGND VPWR VGND sky130_ef_sc_hd__decap_12
X_3299_ _0481_ _0501_ VGND VGND VPWR VPWR _0538_ sky130_fd_sc_hd__or2_1
XTAP_TAPCELL_ROW_68_753 VGND VPWR sky130_fd_sc_hd__tapvpwrvgnd_1
XFILLER_0_67_349 VGND VGND VPWR VPWR sky130_fd_sc_hd__fill_2
XFILLER_0_75_360 VGND VGND VPWR VPWR sky130_fd_sc_hd__decap_8
XFILLER_0_75_393 VGND VGND VPWR VPWR sky130_fd_sc_hd__decap_3
XFILLER_0_35_235 VGND VGND VPWR VPWR sky130_fd_sc_hd__decap_4
XFILLER_0_7_181 VPWR VGND VPWR VGND sky130_ef_sc_hd__decap_12
XFILLER_0_23_419 VGND VGND VPWR VPWR sky130_fd_sc_hd__decap_8
XFILLER_0_35_268 VGND VGND VPWR VPWR sky130_fd_sc_hd__fill_2
XFILLER_0_35_279 VGND VGND VPWR VPWR sky130_fd_sc_hd__fill_1
Xoutput32 net32 VGND VGND VPWR VPWR m_tdata[12] sky130_fd_sc_hd__buf_2
Xoutput43 net43 VGND VGND VPWR VPWR m_tdata[22] sky130_fd_sc_hd__buf_2
Xoutput54 net54 VGND VGND VPWR VPWR m_tdata[3] sky130_fd_sc_hd__buf_2
XFILLER_0_37_18 VGND VGND VPWR VPWR sky130_fd_sc_hd__decap_4
XFILLER_0_58_349 VPWR VGND VPWR VGND sky130_ef_sc_hd__decap_12
XFILLER_0_26_213 VGND VGND VPWR VPWR sky130_fd_sc_hd__fill_1
XFILLER_0_26_235 VGND VGND VPWR VPWR sky130_fd_sc_hd__fill_1
XPHY_EDGE_ROW_59_Right_59 VGND VGND VPWR VPWR sky130_fd_sc_hd__decap_3
XFILLER_0_14_419 VGND VGND VPWR VPWR sky130_fd_sc_hd__fill_1
X_2670_ _2066_ u_interface.u_compute_core.mac_accum\[18\] VGND VGND VPWR VPWR _2086_
+ sky130_fd_sc_hd__nand2_1
XFILLER_0_22_452 VGND VGND VPWR VPWR sky130_fd_sc_hd__decap_6
X_4340_ _1531_ _1556_ VGND VGND VPWR VPWR _1557_ sky130_fd_sc_hd__or2b_1
XFILLER_0_1_335 VGND VGND VPWR VPWR sky130_fd_sc_hd__fill_1
X_4271_ _1482_ _1488_ VGND VGND VPWR VPWR _1489_ sky130_fd_sc_hd__xnor2_1
X_3222_ _0426_ _0422_ _1821_ VGND VGND VPWR VPWR _0463_ sky130_fd_sc_hd__and3_1
X_3153_ _0403_ _0404_ VGND VGND VPWR VPWR _0406_ sky130_fd_sc_hd__or2_1
XPHY_EDGE_ROW_68_Right_68 VGND VGND VPWR VPWR sky130_fd_sc_hd__decap_3
XFILLER_0_27_40 VPWR VGND VPWR VGND sky130_ef_sc_hd__decap_12
X_3084_ _0299_ _0302_ _0338_ VGND VGND VPWR VPWR _0339_ sky130_fd_sc_hd__o21ai_1
XFILLER_0_49_305 VPWR VGND VPWR VGND sky130_ef_sc_hd__decap_12
XFILLER_0_9_435 VGND VGND VPWR VPWR sky130_fd_sc_hd__decap_6
XFILLER_0_9_413 VGND VGND VPWR VPWR sky130_fd_sc_hd__decap_4
XPHY_EDGE_ROW_77_Right_77 VGND VGND VPWR VPWR sky130_fd_sc_hd__decap_3
X_3986_ _1207_ _1209_ VGND VGND VPWR VPWR _1210_ sky130_fd_sc_hd__xnor2_1
X_2937_ _0192_ _0195_ VGND VGND VPWR VPWR _0196_ sky130_fd_sc_hd__xnor2_1
XFILLER_0_9_479 VGND VGND VPWR VPWR sky130_fd_sc_hd__fill_1
XFILLER_0_57_393 VPWR VGND VPWR VGND sky130_ef_sc_hd__decap_12
XFILLER_0_72_363 VGND VGND VPWR VPWR sky130_fd_sc_hd__fill_1
XTAP_TAPCELL_ROW_20_347 VGND VPWR sky130_fd_sc_hd__tapvpwrvgnd_1
X_2868_ _2233_ _2262_ VGND VGND VPWR VPWR _2264_ sky130_fd_sc_hd__or2_1
X_4607_ _1792_ VGND VGND VPWR VPWR _0172_ sky130_fd_sc_hd__clkbuf_1
X_2799_ _2181_ _2196_ VGND VGND VPWR VPWR _2197_ sky130_fd_sc_hd__xnor2_1
XFILLER_0_4_195 VGND VGND VPWR VPWR sky130_fd_sc_hd__fill_1
X_4538_ _1745_ VGND VGND VPWR VPWR _0150_ sky130_fd_sc_hd__clkbuf_1
X_4469_ _1645_ _1646_ _1643_ VGND VGND VPWR VPWR _1683_ sky130_fd_sc_hd__a21oi_1
XFILLER_0_68_91 VGND VGND VPWR VPWR sky130_fd_sc_hd__fill_1
XTAP_TAPCELL_ROW_28_414 VGND VPWR sky130_fd_sc_hd__tapvpwrvgnd_1
XFILLER_0_67_113 VGND VGND VPWR VPWR sky130_fd_sc_hd__decap_8
XTAP_TAPCELL_ROW_36_480 VGND VPWR sky130_fd_sc_hd__tapvpwrvgnd_1
XFILLER_0_67_135 VGND VGND VPWR VPWR sky130_fd_sc_hd__decap_6
XFILLER_0_48_371 VPWR VGND VPWR VGND sky130_ef_sc_hd__decap_12
Xrebuffer9 _0885_ VGND VGND VPWR VPWR net73 sky130_fd_sc_hd__dlygate4sd1_1
XTAP_TAPCELL_ROW_79_848 VGND VPWR sky130_fd_sc_hd__tapvpwrvgnd_1
XFILLER_0_64_27 VGND VGND VPWR VPWR sky130_fd_sc_hd__fill_1
XTAP_TAPCELL_ROW_62_704 VGND VPWR sky130_fd_sc_hd__tapvpwrvgnd_1
XFILLER_0_80_15 VPWR VGND VPWR VGND sky130_ef_sc_hd__decap_12
X_3840_ _1039_ _1066_ VGND VGND VPWR VPWR _1067_ sky130_fd_sc_hd__xnor2_1
XFILLER_0_39_393 VPWR VGND VPWR VGND sky130_ef_sc_hd__decap_12
X_3771_ _0436_ u_interface.u_compute_core.relu_data\[13\] VGND VGND VPWR VPWR _0999_
+ sky130_fd_sc_hd__nand2_1
XTAP_TAPCELL_ROW_70_770 VGND VPWR sky130_fd_sc_hd__tapvpwrvgnd_1
X_2722_ _2067_ u_interface.u_compute_core.mac_accum\[26\] VGND VGND VPWR VPWR _2130_
+ sky130_fd_sc_hd__or2_1
XFILLER_0_13_97 VGND VGND VPWR VPWR sky130_fd_sc_hd__decap_4
XFILLER_0_81_193 VGND VGND VPWR VPWR sky130_fd_sc_hd__decap_3
X_2653_ _2057_ _2062_ _2070_ _2004_ VGND VGND VPWR VPWR _2072_ sky130_fd_sc_hd__a31o_1
X_2584_ _1999_ _2008_ _2011_ VGND VGND VPWR VPWR _2012_ sky130_fd_sc_hd__a21oi_1
X_4323_ _0451_ _0447_ _1884_ _1246_ VGND VGND VPWR VPWR _1540_ sky130_fd_sc_hd__and4_1
XFILLER_0_10_477 VGND VGND VPWR VPWR sky130_fd_sc_hd__decap_6
X_4254_ _0938_ _1471_ _1472_ _0420_ VGND VGND VPWR VPWR _0139_ sky130_fd_sc_hd__o211a_1
X_3205_ _1968_ net22 _0434_ _0448_ VGND VGND VPWR VPWR _0114_ sky130_fd_sc_hd__o211a_1
X_4185_ _1403_ _1377_ VGND VGND VPWR VPWR _1405_ sky130_fd_sc_hd__or2b_1
X_3136_ _0360_ _0363_ _0389_ VGND VGND VPWR VPWR _0390_ sky130_fd_sc_hd__o21a_1
X_3067_ _0278_ _0284_ _0321_ VGND VGND VPWR VPWR _0323_ sky130_fd_sc_hd__nand3_1
XFILLER_0_49_113 VGND VGND VPWR VPWR sky130_fd_sc_hd__decap_8
XFILLER_0_77_455 VPWR VGND VPWR VGND sky130_ef_sc_hd__decap_12
XFILLER_0_9_221 VGND VGND VPWR VPWR sky130_fd_sc_hd__decap_3
XFILLER_0_45_330 VGND VGND VPWR VPWR sky130_fd_sc_hd__decap_6
X_3969_ _1135_ _1137_ VGND VGND VPWR VPWR _1193_ sky130_fd_sc_hd__nand2_1
XFILLER_0_70_81 VGND VGND VPWR VPWR sky130_fd_sc_hd__decap_3
XFILLER_0_13_260 VGND VGND VPWR VPWR sky130_fd_sc_hd__fill_2
XTAP_TAPCELL_ROW_76_818 VGND VPWR sky130_fd_sc_hd__tapvpwrvgnd_1
XFILLER_0_68_400 VGND VGND VPWR VPWR sky130_fd_sc_hd__decap_6
XFILLER_0_68_477 VGND VGND VPWR VPWR sky130_fd_sc_hd__decap_6
XFILLER_0_50_29 VGND VGND VPWR VPWR sky130_fd_sc_hd__fill_1
XFILLER_0_36_363 VGND VGND VPWR VPWR sky130_fd_sc_hd__fill_1
XFILLER_0_51_311 VPWR VGND VPWR VGND sky130_ef_sc_hd__decap_12
XFILLER_0_59_27 VGND VGND VPWR VPWR sky130_fd_sc_hd__decap_8
XFILLER_0_75_15 VPWR VGND VPWR VGND sky130_ef_sc_hd__decap_12
XTAP_TAPCELL_ROW_39_509 VGND VPWR sky130_fd_sc_hd__tapvpwrvgnd_1
XFILLER_0_59_422 VGND VGND VPWR VPWR sky130_fd_sc_hd__fill_2
XTAP_TAPCELL_ROW_47_575 VGND VPWR sky130_fd_sc_hd__tapvpwrvgnd_1
XFILLER_0_24_85 VGND VGND VPWR VPWR sky130_fd_sc_hd__decap_3
XFILLER_0_46_105 VGND VGND VPWR VPWR sky130_fd_sc_hd__fill_2
X_3823_ _1049_ _1048_ VGND VGND VPWR VPWR _1050_ sky130_fd_sc_hd__xnor2_2
XFILLER_0_27_374 VPWR VGND VPWR VGND sky130_ef_sc_hd__decap_12
XTAP_TAPCELL_ROW_30_431 VGND VPWR sky130_fd_sc_hd__tapvpwrvgnd_1
X_3754_ _0981_ _0982_ VGND VGND VPWR VPWR _0983_ sky130_fd_sc_hd__and2_1
X_3685_ _0912_ _0914_ VGND VGND VPWR VPWR _0915_ sky130_fd_sc_hd__xor2_2
X_2705_ _2004_ _2114_ _2115_ VGND VGND VPWR VPWR _0082_ sky130_fd_sc_hd__o21a_1
X_2636_ _2055_ _2056_ net149 _2006_ VGND VGND VPWR VPWR _0072_ sky130_fd_sc_hd__a2bb2o_1
X_2567_ _1994_ _1995_ _1996_ VGND VGND VPWR VPWR _1997_ sky130_fd_sc_hd__nand3_1
X_2498_ _1943_ VGND VGND VPWR VPWR _0047_ sky130_fd_sc_hd__clkbuf_1
X_4306_ _0421_ _1523_ VGND VGND VPWR VPWR _1524_ sky130_fd_sc_hd__nand2_1
X_4237_ _1454_ _1455_ VGND VGND VPWR VPWR _1456_ sky130_fd_sc_hd__or2_1
X_4168_ _0450_ _0446_ _1151_ _1874_ VGND VGND VPWR VPWR _1388_ sky130_fd_sc_hd__and4_1
XFILLER_0_65_81 VGND VGND VPWR VPWR sky130_fd_sc_hd__fill_1
X_3119_ _0371_ _0372_ VGND VGND VPWR VPWR _0373_ sky130_fd_sc_hd__and2_1
XTAP_TAPCELL_ROW_2_189 VGND VPWR sky130_fd_sc_hd__tapvpwrvgnd_1
X_4099_ _1318_ _1320_ VGND VGND VPWR VPWR _1321_ sky130_fd_sc_hd__xor2_1
XTAP_TAPCELL_ROW_81_865 VGND VPWR sky130_fd_sc_hd__tapvpwrvgnd_1
XTAP_TAPCELL_ROW_81_876 VGND VPWR sky130_fd_sc_hd__tapvpwrvgnd_1
XFILLER_0_77_285 VGND VGND VPWR VPWR sky130_fd_sc_hd__fill_1
XFILLER_0_18_330 VPWR VGND VPWR VGND sky130_ef_sc_hd__decap_12
XFILLER_0_33_355 VPWR VGND VPWR VGND sky130_ef_sc_hd__decap_12
XFILLER_0_61_39 VGND VGND VPWR VPWR sky130_fd_sc_hd__fill_2
XFILLER_0_28_116 VGND VGND VPWR VPWR sky130_fd_sc_hd__decap_8
XFILLER_0_43_108 VGND VGND VPWR VPWR sky130_fd_sc_hd__decap_4
XFILLER_0_3_205 VPWR VGND VPWR VGND sky130_ef_sc_hd__decap_12
XFILLER_0_3_249 VPWR VGND VPWR VGND sky130_ef_sc_hd__decap_12
XFILLER_0_24_377 VGND VGND VPWR VPWR sky130_fd_sc_hd__fill_2
X_3470_ _0703_ _0701_ VGND VGND VPWR VPWR _0705_ sky130_fd_sc_hd__and2b_1
X_2421_ u_interface.u_compute_core.relu_data\[24\] VGND VGND VPWR VPWR _1890_ sky130_fd_sc_hd__buf_2
X_2352_ u_interface.u_compute_core.relu_data\[7\] VGND VGND VPWR VPWR _1838_ sky130_fd_sc_hd__clkbuf_4
XFILLER_0_19_74 VGND VGND VPWR VPWR sky130_fd_sc_hd__decap_4
X_4022_ _0626_ _1874_ _1189_ _1188_ VGND VGND VPWR VPWR _1245_ sky130_fd_sc_hd__a31o_1
XFILLER_0_29_7 VGND VGND VPWR VPWR sky130_fd_sc_hd__fill_1
XFILLER_0_35_40 VPWR VGND VPWR VGND sky130_ef_sc_hd__decap_12
XFILLER_0_19_105 VGND VGND VPWR VPWR sky130_fd_sc_hd__decap_3
XFILLER_0_74_222 VPWR VGND VPWR VGND sky130_ef_sc_hd__decap_12
XFILLER_0_19_116 VGND VGND VPWR VPWR sky130_fd_sc_hd__decap_4
XFILLER_0_47_436 VGND VGND VPWR VPWR sky130_fd_sc_hd__fill_1
X_4786_ clknet_4_9_0_clk net92 VGND VGND VPWR VPWR net40 sky130_fd_sc_hd__dfxtp_1
X_3806_ _1967_ _1031_ _1032_ _1033_ _1813_ VGND VGND VPWR VPWR _0130_ sky130_fd_sc_hd__o311a_1
XFILLER_0_15_322 VPWR VGND VPWR VGND sky130_ef_sc_hd__decap_12
X_3737_ _0912_ _0914_ VGND VGND VPWR VPWR _0966_ sky130_fd_sc_hd__and2_1
XFILLER_0_70_483 VGND VGND VPWR VPWR sky130_fd_sc_hd__fill_1
X_3668_ _0422_ _1862_ _1859_ _0426_ VGND VGND VPWR VPWR _0898_ sky130_fd_sc_hd__a22oi_1
X_3599_ _0789_ _0787_ VGND VGND VPWR VPWR _0831_ sky130_fd_sc_hd__and2b_1
X_2619_ u_interface.u_compute_core.u_mac.product_reg\[11\] u_interface.u_compute_core.mac_accum\[11\]
+ VGND VGND VPWR VPWR _2042_ sky130_fd_sc_hd__nor2_1
XTAP_TAPCELL_ROW_7_237 VGND VPWR sky130_fd_sc_hd__tapvpwrvgnd_1
XFILLER_0_65_222 VGND VGND VPWR VPWR sky130_fd_sc_hd__fill_2
XTAP_TAPCELL_ROW_41_526 VGND VPWR sky130_fd_sc_hd__tapvpwrvgnd_1
XFILLER_0_65_299 VGND VGND VPWR VPWR sky130_fd_sc_hd__decap_8
XFILLER_0_80_236 VPWR VGND VPWR VGND sky130_ef_sc_hd__decap_12
XFILLER_0_21_303 VPWR VGND VPWR VGND sky130_ef_sc_hd__decap_12
XFILLER_0_72_27 VGND VGND VPWR VPWR sky130_fd_sc_hd__fill_1
X_2970_ _0225_ _0226_ _0227_ VGND VGND VPWR VPWR _0228_ sky130_fd_sc_hd__o21a_1
XFILLER_0_71_225 VGND VGND VPWR VPWR sky130_fd_sc_hd__fill_1
X_4640_ clknet_4_2_0_clk _0005_ VGND VGND VPWR VPWR u_interface.u_compute_core.relu_data\[5\]
+ sky130_fd_sc_hd__dfxtp_2
XFILLER_0_71_258 VGND VGND VPWR VPWR sky130_fd_sc_hd__fill_1
X_4571_ _1753_ _1767_ VGND VGND VPWR VPWR _1768_ sky130_fd_sc_hd__and2_1
X_3522_ _0711_ _0709_ _0755_ VGND VGND VPWR VPWR _0756_ sky130_fd_sc_hd__a21o_1
X_3453_ _0684_ _0687_ VGND VGND VPWR VPWR _0688_ sky130_fd_sc_hd__xnor2_1
X_2404_ u_interface.u_compute_core.scaled_data\[19\] _1849_ _1877_ _1816_ VGND VGND
+ VPWR VPWR _1878_ sky130_fd_sc_hd__o2bb2a_1
X_3384_ _0480_ _0619_ _0620_ net62 VGND VGND VPWR VPWR _0121_ sky130_fd_sc_hd__o211a_1
XTAP_TAPCELL_ROW_4_207 VGND VPWR sky130_fd_sc_hd__tapvpwrvgnd_1
X_2335_ u_interface.u_compute_core.scaled_data\[2\] _1815_ _1825_ _1817_ VGND VGND
+ VPWR VPWR _1826_ sky130_fd_sc_hd__o2bb2a_1
XFILLER_0_46_61 VGND VGND VPWR VPWR sky130_fd_sc_hd__decap_3
X_4005_ u_interface.u_compute_core.relu_data\[14\] _0453_ VGND VGND VPWR VPWR _1228_
+ sky130_fd_sc_hd__and2b_1
XFILLER_0_47_266 VGND VGND VPWR VPWR sky130_fd_sc_hd__decap_6
XFILLER_0_62_236 VPWR VGND VPWR VGND sky130_ef_sc_hd__decap_12
X_4769_ clknet_4_14_0_clk _0134_ VGND VGND VPWR VPWR u_interface.core_attn_out\[17\]
+ sky130_fd_sc_hd__dfxtp_1
XFILLER_0_15_185 VPWR VGND VPWR VGND sky130_ef_sc_hd__decap_12
XFILLER_0_30_133 VGND VGND VPWR VPWR sky130_fd_sc_hd__decap_6
XFILLER_0_30_177 VGND VGND VPWR VPWR sky130_fd_sc_hd__decap_8
Xhold32 u_interface.u_compute_core.mac_accum\[2\] VGND VGND VPWR VPWR net96 sky130_fd_sc_hd__dlygate4sd3_1
Xhold65 u_interface.u_compute_core.mac_accum\[27\] VGND VGND VPWR VPWR net129 sky130_fd_sc_hd__dlygate4sd3_1
Xhold43 u_interface.u_compute_core.u_mac.product_reg\[2\] VGND VGND VPWR VPWR net107
+ sky130_fd_sc_hd__dlygate4sd3_1
Xhold54 u_interface.u_compute_core.u_mac.product_reg\[11\] VGND VGND VPWR VPWR net118
+ sky130_fd_sc_hd__dlygate4sd3_1
Xhold76 net61 VGND VGND VPWR VPWR net140 sky130_fd_sc_hd__dlygate4sd3_1
Xhold87 u_interface.u_compute_core.scaled_data\[5\] VGND VGND VPWR VPWR net151 sky130_fd_sc_hd__dlygate4sd3_1
XFILLER_0_38_200 VGND VGND VPWR VPWR sky130_fd_sc_hd__decap_8
XTAP_TAPCELL_ROW_26_397 VGND VPWR sky130_fd_sc_hd__tapvpwrvgnd_1
XFILLER_0_38_288 VGND VGND VPWR VPWR sky130_fd_sc_hd__fill_2
XFILLER_0_53_203 VGND VGND VPWR VPWR sky130_fd_sc_hd__fill_2
XFILLER_0_41_409 VGND VGND VPWR VPWR sky130_fd_sc_hd__fill_1
XFILLER_0_21_133 VGND VGND VPWR VPWR sky130_fd_sc_hd__decap_8
XFILLER_0_21_166 VGND VGND VPWR VPWR sky130_fd_sc_hd__fill_2
XFILLER_0_67_27 VPWR VGND VPWR VGND sky130_ef_sc_hd__decap_12
XFILLER_0_21_199 VGND VGND VPWR VPWR sky130_fd_sc_hd__fill_1
XTAP_TAPCELL_ROW_17_320 VGND VPWR sky130_fd_sc_hd__tapvpwrvgnd_1
XFILLER_0_16_64 VGND VGND VPWR VPWR sky130_fd_sc_hd__decap_8
X_2953_ _2292_ _2304_ _2291_ VGND VGND VPWR VPWR _0212_ sky130_fd_sc_hd__o21ai_1
X_2884_ _2178_ _2193_ VGND VGND VPWR VPWR _2279_ sky130_fd_sc_hd__nand2_1
XTAP_TAPCELL_ROW_60_687 VGND VPWR sky130_fd_sc_hd__tapvpwrvgnd_1
X_4623_ net49 u_interface.core_attn_out\[28\] u_interface.core_valid_out VGND VGND
+ VPWR VPWR _1803_ sky130_fd_sc_hd__mux2_1
XFILLER_0_4_333 VPWR VGND VPWR VGND sky130_ef_sc_hd__decap_12
X_4554_ net57 u_interface.core_attn_out\[6\] _1742_ VGND VGND VPWR VPWR _1756_ sky130_fd_sc_hd__mux2_1
XFILLER_0_4_377 VPWR VGND VPWR VGND sky130_ef_sc_hd__decap_12
X_3505_ _0738_ _0736_ VGND VGND VPWR VPWR _0739_ sky130_fd_sc_hd__xnor2_2
X_4485_ _1611_ _1657_ VGND VGND VPWR VPWR _1698_ sky130_fd_sc_hd__nand2_1
XFILLER_0_12_177 VPWR VGND VPWR VGND sky130_ef_sc_hd__decap_12
XFILLER_0_40_475 VGND VGND VPWR VPWR sky130_fd_sc_hd__fill_1
X_3436_ _0456_ _1845_ VGND VGND VPWR VPWR _0671_ sky130_fd_sc_hd__nand2_1
X_3367_ _0556_ _0561_ _0559_ VGND VGND VPWR VPWR _0604_ sky130_fd_sc_hd__o21bai_1
X_2318_ _1811_ VGND VGND VPWR VPWR _1812_ sky130_fd_sc_hd__clkbuf_4
XFILLER_0_57_93 VPWR VGND VPWR VGND sky130_ef_sc_hd__decap_12
X_3298_ _0535_ _0536_ VGND VGND VPWR VPWR _0537_ sky130_fd_sc_hd__or2b_1
XTAP_TAPCELL_ROW_68_754 VGND VPWR sky130_fd_sc_hd__tapvpwrvgnd_1
XFILLER_0_79_111 VGND VGND VPWR VPWR sky130_fd_sc_hd__fill_1
XTAP_TAPCELL_ROW_51_610 VGND VPWR sky130_fd_sc_hd__tapvpwrvgnd_1
XFILLER_0_35_225 VGND VGND VPWR VPWR sky130_fd_sc_hd__decap_3
XFILLER_0_7_193 VPWR VGND VPWR VGND sky130_ef_sc_hd__decap_12
XFILLER_0_50_206 VPWR VGND VPWR VGND sky130_ef_sc_hd__decap_12
Xclkbuf_4_10_0_clk clknet_0_clk VGND VGND VPWR VPWR clknet_4_10_0_clk sky130_fd_sc_hd__clkbuf_8
Xoutput33 net33 VGND VGND VPWR VPWR m_tdata[13] sky130_fd_sc_hd__buf_2
XFILLER_0_9_3 VGND VGND VPWR VPWR sky130_fd_sc_hd__fill_2
Xoutput55 net55 VGND VGND VPWR VPWR m_tdata[4] sky130_fd_sc_hd__buf_2
Xoutput44 net44 VGND VGND VPWR VPWR m_tdata[23] sky130_fd_sc_hd__buf_2
XFILLER_0_73_309 VGND VGND VPWR VPWR sky130_fd_sc_hd__decap_4
XFILLER_0_66_361 VGND VGND VPWR VPWR sky130_fd_sc_hd__decap_3
XFILLER_0_66_372 VGND VGND VPWR VPWR sky130_fd_sc_hd__fill_1
XFILLER_0_78_15 VPWR VGND VPWR VGND sky130_ef_sc_hd__decap_12
X_4270_ _1486_ _1487_ VGND VGND VPWR VPWR _1488_ sky130_fd_sc_hd__nor2_1
X_3221_ _0459_ _0456_ _0458_ _1824_ VGND VGND VPWR VPWR _0462_ sky130_fd_sc_hd__and4_1
X_3152_ _0403_ _0404_ VGND VGND VPWR VPWR _0405_ sky130_fd_sc_hd__nand2_1
X_3083_ _0336_ _0337_ VGND VGND VPWR VPWR _0338_ sky130_fd_sc_hd__nor2_1
XFILLER_0_43_51 VGND VGND VPWR VPWR sky130_fd_sc_hd__fill_1
XFILLER_0_9_447 VGND VGND VPWR VPWR sky130_fd_sc_hd__fill_1
X_3985_ _1108_ _1155_ _1208_ VGND VGND VPWR VPWR _1209_ sky130_fd_sc_hd__a21oi_1
XFILLER_0_64_309 VGND VGND VPWR VPWR sky130_fd_sc_hd__fill_1
X_2936_ _0193_ _0194_ VGND VGND VPWR VPWR _0195_ sky130_fd_sc_hd__or2_1
XTAP_TAPCELL_ROW_20_348 VGND VPWR sky130_fd_sc_hd__tapvpwrvgnd_1
X_2867_ _2233_ _2262_ VGND VGND VPWR VPWR _2263_ sky130_fd_sc_hd__nand2_1
XFILLER_0_4_141 VPWR VGND VPWR VGND sky130_ef_sc_hd__decap_12
X_4606_ _1775_ _1791_ VGND VGND VPWR VPWR _1792_ sky130_fd_sc_hd__and2_1
XFILLER_0_13_431 VGND VGND VPWR VPWR sky130_fd_sc_hd__fill_1
X_2798_ _2194_ _2195_ VGND VGND VPWR VPWR _2196_ sky130_fd_sc_hd__or2_1
X_4537_ _1953_ _1744_ VGND VGND VPWR VPWR _1745_ sky130_fd_sc_hd__and2_1
X_4468_ _1680_ _1681_ VGND VGND VPWR VPWR _1682_ sky130_fd_sc_hd__nand2_1
X_3419_ _0652_ _0654_ VGND VGND VPWR VPWR _0655_ sky130_fd_sc_hd__xor2_1
X_4399_ _0421_ _1614_ VGND VGND VPWR VPWR _1615_ sky130_fd_sc_hd__nand2_1
XTAP_TAPCELL_ROW_28_415 VGND VPWR sky130_fd_sc_hd__tapvpwrvgnd_1
XTAP_TAPCELL_ROW_36_481 VGND VPWR sky130_fd_sc_hd__tapvpwrvgnd_1
XFILLER_0_67_169 VGND VGND VPWR VPWR sky130_fd_sc_hd__decap_6
XFILLER_0_75_180 VPWR VGND VPWR VGND sky130_ef_sc_hd__decap_12
XFILLER_0_48_383 VGND VGND VPWR VPWR sky130_fd_sc_hd__decap_8
XFILLER_0_63_331 VGND VGND VPWR VPWR sky130_fd_sc_hd__decap_4
XFILLER_0_16_280 VGND VGND VPWR VPWR sky130_fd_sc_hd__decap_8
XFILLER_0_48_29 VGND VGND VPWR VPWR sky130_fd_sc_hd__decap_6
XTAP_TAPCELL_ROW_79_849 VGND VPWR sky130_fd_sc_hd__tapvpwrvgnd_1
XTAP_TAPCELL_ROW_62_705 VGND VPWR sky130_fd_sc_hd__tapvpwrvgnd_1
XFILLER_0_80_27 VGND VGND VPWR VPWR sky130_fd_sc_hd__fill_1
XFILLER_0_39_361 VGND VGND VPWR VPWR sky130_fd_sc_hd__fill_1
XFILLER_0_46_309 VGND VGND VPWR VPWR sky130_fd_sc_hd__fill_2
XFILLER_0_13_54 VGND VGND VPWR VPWR sky130_fd_sc_hd__fill_2
X_3770_ u_interface.u_compute_core.relu_data\[9\] u_interface.u_compute_core.u_av.v_extended\[10\]
+ VGND VGND VPWR VPWR _0998_ sky130_fd_sc_hd__nor2b_2
XTAP_TAPCELL_ROW_70_771 VGND VPWR sky130_fd_sc_hd__tapvpwrvgnd_1
XFILLER_0_13_87 VGND VGND VPWR VPWR sky130_fd_sc_hd__decap_6
X_2721_ u_interface.u_compute_core.mac_accum\[25\] u_interface.u_compute_core.mac_accum\[24\]
+ _2067_ VGND VGND VPWR VPWR _2129_ sky130_fd_sc_hd__o21a_1
XFILLER_0_54_375 VGND VGND VPWR VPWR sky130_fd_sc_hd__decap_3
X_2652_ _2057_ _2062_ _2070_ VGND VGND VPWR VPWR _2071_ sky130_fd_sc_hd__a21oi_1
XFILLER_0_1_111 VGND VGND VPWR VPWR sky130_fd_sc_hd__fill_1
XFILLER_0_22_250 VGND VGND VPWR VPWR sky130_fd_sc_hd__fill_2
XFILLER_0_22_261 VGND VGND VPWR VPWR sky130_fd_sc_hd__fill_2
X_2583_ _2009_ _2010_ VGND VGND VPWR VPWR _2011_ sky130_fd_sc_hd__and2b_1
X_4322_ _0447_ _1884_ _1246_ _0451_ VGND VGND VPWR VPWR _1539_ sky130_fd_sc_hd__a22oi_1
X_4253_ u_interface.core_attn_out\[22\] _1966_ VGND VGND VPWR VPWR _1472_ sky130_fd_sc_hd__or2_1
X_3204_ _0435_ _0447_ VGND VGND VPWR VPWR _0448_ sky130_fd_sc_hd__or2_1
XFILLER_0_38_51 VGND VGND VPWR VPWR sky130_fd_sc_hd__decap_3
X_4184_ _1377_ _1403_ VGND VGND VPWR VPWR _1404_ sky130_fd_sc_hd__or2b_1
X_3135_ _0387_ _0388_ VGND VGND VPWR VPWR _0389_ sky130_fd_sc_hd__and2b_1
X_3066_ _0278_ _0284_ _0321_ VGND VGND VPWR VPWR _0322_ sky130_fd_sc_hd__a21o_1
XFILLER_0_49_136 VGND VGND VPWR VPWR sky130_fd_sc_hd__fill_2
XFILLER_0_77_467 VPWR VGND VPWR VGND sky130_ef_sc_hd__decap_12
XFILLER_0_9_233 VGND VGND VPWR VPWR sky130_fd_sc_hd__decap_3
XFILLER_0_49_169 VGND VGND VPWR VPWR sky130_fd_sc_hd__decap_8
XFILLER_0_64_106 VPWR VGND VPWR VGND sky130_ef_sc_hd__decap_12
X_3968_ _1186_ _1191_ VGND VGND VPWR VPWR _1192_ sky130_fd_sc_hd__xnor2_1
XFILLER_0_64_139 VGND VGND VPWR VPWR sky130_fd_sc_hd__fill_1
X_2919_ _2312_ _2313_ VGND VGND VPWR VPWR _2314_ sky130_fd_sc_hd__or2_1
X_3899_ u_interface.core_attn_out\[14\] _1073_ VGND VGND VPWR VPWR _1125_ sky130_fd_sc_hd__nand2_1
XFILLER_0_60_312 VPWR VGND VPWR VGND sky130_ef_sc_hd__decap_12
XFILLER_0_5_472 VGND VGND VPWR VPWR sky130_fd_sc_hd__decap_8
XTAP_TAPCELL_ROW_76_819 VGND VPWR sky130_fd_sc_hd__tapvpwrvgnd_1
XFILLER_0_68_434 VGND VGND VPWR VPWR sky130_fd_sc_hd__fill_1
XFILLER_0_28_309 VPWR VGND VPWR VGND sky130_ef_sc_hd__decap_12
XFILLER_0_36_331 VPWR VGND VPWR VGND sky130_ef_sc_hd__decap_12
XFILLER_0_51_323 VPWR VGND VPWR VGND sky130_ef_sc_hd__decap_12
XFILLER_0_63_183 VPWR VGND VPWR VGND sky130_ef_sc_hd__decap_12
XFILLER_0_75_27 VPWR VGND VPWR VGND sky130_ef_sc_hd__decap_12
XTAP_TAPCELL_ROW_47_576 VGND VPWR sky130_fd_sc_hd__tapvpwrvgnd_1
XFILLER_0_74_415 VGND VGND VPWR VPWR sky130_fd_sc_hd__decap_4
XFILLER_0_74_448 VGND VGND VPWR VPWR sky130_fd_sc_hd__fill_1
XFILLER_0_27_320 VPWR VGND VPWR VGND sky130_ef_sc_hd__decap_12
X_3822_ _0441_ u_interface.u_compute_core.relu_data\[13\] VGND VGND VPWR VPWR _1049_
+ sky130_fd_sc_hd__nand2_1
XFILLER_0_27_342 VGND VGND VPWR VPWR sky130_fd_sc_hd__fill_2
XFILLER_0_6_236 VGND VGND VPWR VPWR sky130_fd_sc_hd__decap_6
XFILLER_0_27_386 VGND VGND VPWR VPWR sky130_fd_sc_hd__decap_6
XTAP_TAPCELL_ROW_30_432 VGND VPWR sky130_fd_sc_hd__tapvpwrvgnd_1
X_3753_ _0940_ _0941_ _0980_ VGND VGND VPWR VPWR _0982_ sky130_fd_sc_hd__o21ai_1
X_3684_ _0689_ _1845_ _0862_ _0913_ VGND VGND VPWR VPWR _0914_ sky130_fd_sc_hd__a31o_1
X_2704_ u_interface.u_compute_core.mac_accum\[23\] _1969_ _1813_ VGND VGND VPWR VPWR
+ _2115_ sky130_fd_sc_hd__o21a_1
X_2635_ _2046_ _2049_ _2054_ _2004_ VGND VGND VPWR VPWR _2056_ sky130_fd_sc_hd__a31o_1
XFILLER_0_2_475 VGND VGND VPWR VPWR sky130_fd_sc_hd__fill_1
X_2566_ _1989_ _1990_ _1988_ VGND VGND VPWR VPWR _1996_ sky130_fd_sc_hd__a21bo_1
X_4305_ _1519_ _1522_ VGND VGND VPWR VPWR _1523_ sky130_fd_sc_hd__xnor2_1
XFILLER_0_10_286 VGND VGND VPWR VPWR sky130_fd_sc_hd__fill_1
X_2497_ _1931_ _1942_ VGND VGND VPWR VPWR _1943_ sky130_fd_sc_hd__and2_1
XFILLER_0_4_41 VPWR VGND VPWR VGND sky130_ef_sc_hd__decap_12
X_4236_ _1345_ _1401_ _1399_ VGND VGND VPWR VPWR _1455_ sky130_fd_sc_hd__a21oi_1
XFILLER_0_4_85 VPWR VGND VPWR VGND sky130_ef_sc_hd__decap_12
X_4167_ _0446_ _1151_ _1874_ _0450_ VGND VGND VPWR VPWR _1387_ sky130_fd_sc_hd__a22oi_1
X_3118_ _0334_ _0337_ _0370_ VGND VGND VPWR VPWR _0372_ sky130_fd_sc_hd__or3_1
X_4098_ _1269_ _1271_ _1319_ VGND VGND VPWR VPWR _1320_ sky130_fd_sc_hd__o21ba_1
XFILLER_0_77_231 VGND VGND VPWR VPWR sky130_fd_sc_hd__decap_8
XFILLER_0_77_220 VGND VGND VPWR VPWR sky130_fd_sc_hd__decap_4
X_3049_ _0303_ _0304_ VGND VGND VPWR VPWR _0305_ sky130_fd_sc_hd__xnor2_1
XTAP_TAPCELL_ROW_81_866 VGND VPWR sky130_fd_sc_hd__tapvpwrvgnd_1
XFILLER_0_81_81 VGND VGND VPWR VPWR sky130_fd_sc_hd__decap_3
XTAP_TAPCELL_ROW_81_877 VGND VPWR sky130_fd_sc_hd__tapvpwrvgnd_1
XFILLER_0_18_342 VPWR VGND VPWR VGND sky130_ef_sc_hd__decap_12
XFILLER_0_80_418 VGND VGND VPWR VPWR sky130_fd_sc_hd__fill_2
XFILLER_0_18_386 VPWR VGND VPWR VGND sky130_ef_sc_hd__decap_12
XFILLER_0_33_367 VPWR VGND VPWR VGND sky130_ef_sc_hd__decap_12
XTAP_TAPCELL_ROW_44_546 VGND VPWR sky130_fd_sc_hd__tapvpwrvgnd_1
XFILLER_0_68_253 VGND VGND VPWR VPWR sky130_fd_sc_hd__decap_4
XFILLER_0_56_426 VGND VGND VPWR VPWR sky130_fd_sc_hd__decap_4
XFILLER_0_68_275 VGND VGND VPWR VPWR sky130_fd_sc_hd__decap_8
XFILLER_0_3_217 VGND VGND VPWR VPWR sky130_fd_sc_hd__decap_6
XFILLER_0_36_194 VGND VGND VPWR VPWR sky130_fd_sc_hd__fill_2
XFILLER_0_51_164 VGND VGND VPWR VPWR sky130_fd_sc_hd__decap_4
XFILLER_0_10_77 VGND VGND VPWR VPWR sky130_fd_sc_hd__decap_3
X_2420_ _1879_ _1889_ VGND VGND VPWR VPWR _0023_ sky130_fd_sc_hd__nor2_1
X_2351_ _1820_ _1837_ VGND VGND VPWR VPWR _0006_ sky130_fd_sc_hd__nor2_1
X_4021_ _1241_ _1243_ VGND VGND VPWR VPWR _1244_ sky130_fd_sc_hd__xnor2_1
XFILLER_0_35_52 VGND VGND VPWR VPWR sky130_fd_sc_hd__decap_4
XFILLER_0_59_231 VGND VGND VPWR VPWR sky130_fd_sc_hd__fill_1
XFILLER_0_74_212 VGND VGND VPWR VPWR sky130_fd_sc_hd__decap_3
XFILLER_0_74_234 VPWR VGND VPWR VGND sky130_ef_sc_hd__decap_12
X_4785_ clknet_4_11_0_clk _0150_ VGND VGND VPWR VPWR net29 sky130_fd_sc_hd__dfxtp_1
X_3805_ u_interface.core_attn_out\[13\] _1966_ VGND VGND VPWR VPWR _1033_ sky130_fd_sc_hd__or2_1
XFILLER_0_15_334 VGND VGND VPWR VPWR sky130_fd_sc_hd__fill_2
X_3736_ _0956_ _0964_ VGND VGND VPWR VPWR _0965_ sky130_fd_sc_hd__xnor2_1
X_3667_ _0430_ _1853_ _0857_ _0855_ VGND VGND VPWR VPWR _0897_ sky130_fd_sc_hd__a31o_1
XFILLER_0_42_197 VGND VGND VPWR VPWR sky130_fd_sc_hd__decap_4
X_3598_ _0802_ net79 VGND VGND VPWR VPWR _0830_ sky130_fd_sc_hd__xnor2_4
X_2618_ u_interface.u_compute_core.u_mac.product_reg\[11\] u_interface.u_compute_core.mac_accum\[11\]
+ VGND VGND VPWR VPWR _2041_ sky130_fd_sc_hd__and2_1
XTAP_TAPCELL_ROW_7_238 VGND VPWR sky130_fd_sc_hd__tapvpwrvgnd_1
X_2549_ u_interface.u_compute_core.u_mac.product_reg\[2\] u_interface.u_compute_core.mac_accum\[2\]
+ VGND VGND VPWR VPWR _1981_ sky130_fd_sc_hd__nand2_1
X_4219_ _1436_ _1437_ VGND VGND VPWR VPWR _1438_ sky130_fd_sc_hd__nor2_1
XFILLER_0_65_212 VGND VGND VPWR VPWR sky130_fd_sc_hd__fill_1
XTAP_TAPCELL_ROW_41_527 VGND VPWR sky130_fd_sc_hd__tapvpwrvgnd_1
XFILLER_0_65_234 VPWR VGND VPWR VGND sky130_ef_sc_hd__decap_12
XFILLER_0_80_259 VGND VGND VPWR VPWR sky130_fd_sc_hd__decap_4
XFILLER_0_80_248 VGND VGND VPWR VPWR sky130_fd_sc_hd__decap_4
XFILLER_0_18_172 VGND VGND VPWR VPWR sky130_fd_sc_hd__fill_2
XFILLER_0_0_209 VGND VGND VPWR VPWR sky130_fd_sc_hd__decap_4
XFILLER_0_21_315 VGND VGND VPWR VPWR sky130_fd_sc_hd__fill_2
XFILLER_0_56_29 VGND VGND VPWR VPWR sky130_fd_sc_hd__decap_8
XTAP_TAPCELL_ROW_57_660 VGND VPWR sky130_fd_sc_hd__tapvpwrvgnd_1
XFILLER_0_8_309 VPWR VGND VPWR VGND sky130_ef_sc_hd__decap_12
XFILLER_0_56_212 VGND VGND VPWR VPWR sky130_fd_sc_hd__decap_8
XFILLER_0_71_204 VPWR VGND VPWR VGND sky130_ef_sc_hd__decap_12
XFILLER_0_44_429 VGND VGND VPWR VPWR sky130_fd_sc_hd__fill_2
XFILLER_0_56_289 VGND VGND VPWR VPWR sky130_fd_sc_hd__fill_1
X_4570_ net31 u_interface.core_attn_out\[11\] _1760_ VGND VGND VPWR VPWR _1767_ sky130_fd_sc_hd__mux2_1
XFILLER_0_21_54 VGND VGND VPWR VPWR sky130_fd_sc_hd__fill_2
X_3521_ u_interface.core_attn_out\[6\] _0708_ VGND VGND VPWR VPWR _0755_ sky130_fd_sc_hd__and2_1
X_3452_ _0685_ _0686_ VGND VGND VPWR VPWR _0687_ sky130_fd_sc_hd__xnor2_2
X_3383_ u_interface.core_attn_out\[4\] _0435_ VGND VGND VPWR VPWR _0620_ sky130_fd_sc_hd__or2_1
X_2403_ u_interface.u_compute_core.relu_data\[19\] VGND VGND VPWR VPWR _1877_ sky130_fd_sc_hd__inv_2
XFILLER_0_20_381 VGND VGND VPWR VPWR sky130_fd_sc_hd__fill_1
X_2334_ _1824_ VGND VGND VPWR VPWR _1825_ sky130_fd_sc_hd__inv_2
XTAP_TAPCELL_ROW_4_208 VGND VPWR sky130_fd_sc_hd__tapvpwrvgnd_1
X_4004_ _1080_ _1217_ _1218_ _1215_ VGND VGND VPWR VPWR _1227_ sky130_fd_sc_hd__a211o_1
XFILLER_0_79_359 VGND VGND VPWR VPWR sky130_fd_sc_hd__fill_1
XFILLER_0_47_201 VGND VGND VPWR VPWR sky130_fd_sc_hd__decap_8
XFILLER_0_47_223 VGND VGND VPWR VPWR sky130_fd_sc_hd__fill_1
XFILLER_0_62_61 VGND VGND VPWR VPWR sky130_fd_sc_hd__fill_2
XFILLER_0_7_353 VGND VGND VPWR VPWR sky130_fd_sc_hd__fill_1
XFILLER_0_62_248 VGND VGND VPWR VPWR sky130_fd_sc_hd__decap_4
XFILLER_0_43_440 VGND VGND VPWR VPWR sky130_fd_sc_hd__fill_2
X_4768_ clknet_4_14_0_clk _0133_ VGND VGND VPWR VPWR u_interface.core_attn_out\[16\]
+ sky130_fd_sc_hd__dfxtp_1
X_4699_ clknet_4_1_0_clk _0064_ VGND VGND VPWR VPWR u_interface.u_compute_core.mac_accum\[5\]
+ sky130_fd_sc_hd__dfxtp_1
X_3719_ _0459_ _0422_ u_interface.u_compute_core.relu_data\[15\] _1862_ VGND VGND
+ VPWR VPWR _0948_ sky130_fd_sc_hd__and4_1
Xhold55 u_interface.core_attn_out\[30\] VGND VGND VPWR VPWR net119 sky130_fd_sc_hd__dlygate4sd3_1
Xhold33 u_interface.u_compute_core.u_mac.product_reg\[7\] VGND VGND VPWR VPWR net97
+ sky130_fd_sc_hd__dlygate4sd3_1
Xhold44 u_interface.u_compute_core.mac_accum\[7\] VGND VGND VPWR VPWR net108 sky130_fd_sc_hd__dlygate4sd3_1
Xhold77 u_interface.core_attn_out\[27\] VGND VGND VPWR VPWR net141 sky130_fd_sc_hd__dlygate4sd3_1
Xhold66 u_interface.u_compute_core.mac_accum\[5\] VGND VGND VPWR VPWR net130 sky130_fd_sc_hd__dlygate4sd3_1
Xhold88 u_interface.u_compute_core.scaled_data\[8\] VGND VGND VPWR VPWR net152 sky130_fd_sc_hd__dlygate4sd3_1
XTAP_TAPCELL_ROW_26_398 VGND VPWR sky130_fd_sc_hd__tapvpwrvgnd_1
XFILLER_0_26_429 VGND VGND VPWR VPWR sky130_fd_sc_hd__fill_1
XFILLER_0_53_215 VGND VGND VPWR VPWR sky130_fd_sc_hd__fill_2
XFILLER_0_61_281 VGND VGND VPWR VPWR sky130_fd_sc_hd__fill_2
XFILLER_0_67_39 VPWR VGND VPWR VGND sky130_ef_sc_hd__decap_12
XFILLER_0_16_10 VGND VGND VPWR VPWR sky130_fd_sc_hd__fill_1
XTAP_TAPCELL_ROW_17_321 VGND VPWR sky130_fd_sc_hd__tapvpwrvgnd_1
XFILLER_0_69_381 VGND VGND VPWR VPWR sky130_fd_sc_hd__fill_1
XFILLER_0_8_106 VGND VGND VPWR VPWR sky130_fd_sc_hd__fill_1
X_2952_ _0209_ _0210_ VGND VGND VPWR VPWR _0211_ sky130_fd_sc_hd__nor2_1
XFILLER_0_17_418 VGND VGND VPWR VPWR sky130_fd_sc_hd__decap_8
XFILLER_0_29_278 VGND VGND VPWR VPWR sky130_fd_sc_hd__fill_2
XFILLER_0_32_53 VGND VGND VPWR VPWR sky130_fd_sc_hd__decap_3
XFILLER_0_44_204 VPWR VGND VPWR VGND sky130_ef_sc_hd__decap_12
X_2883_ _2276_ _2277_ VGND VGND VPWR VPWR _2278_ sky130_fd_sc_hd__or2_1
XFILLER_0_32_97 VGND VGND VPWR VPWR sky130_fd_sc_hd__fill_1
XFILLER_0_44_226 VGND VGND VPWR VPWR sky130_fd_sc_hd__fill_1
XTAP_TAPCELL_ROW_60_688 VGND VPWR sky130_fd_sc_hd__tapvpwrvgnd_1
X_4622_ _1802_ VGND VGND VPWR VPWR _0177_ sky130_fd_sc_hd__clkbuf_1
XFILLER_0_4_301 VGND VGND VPWR VPWR sky130_fd_sc_hd__decap_6
X_4553_ _1755_ VGND VGND VPWR VPWR _0155_ sky130_fd_sc_hd__clkbuf_1
XFILLER_0_4_345 VPWR VGND VPWR VGND sky130_ef_sc_hd__decap_12
X_4484_ _1529_ _1696_ _1695_ VGND VGND VPWR VPWR _1697_ sky130_fd_sc_hd__or3_4
XFILLER_0_4_389 VPWR VGND VPWR VGND sky130_ef_sc_hd__decap_12
X_3504_ _0683_ _0692_ _0737_ VGND VGND VPWR VPWR _0738_ sky130_fd_sc_hd__a21oi_2
X_3435_ _0586_ _0628_ VGND VGND VPWR VPWR _0670_ sky130_fd_sc_hd__nor2_1
XFILLER_0_12_189 VGND VGND VPWR VPWR sky130_fd_sc_hd__decap_6
X_3366_ _0595_ _0602_ VGND VGND VPWR VPWR _0603_ sky130_fd_sc_hd__xnor2_1
X_3297_ _0533_ _0534_ u_interface.core_attn_out\[2\] VGND VGND VPWR VPWR _0536_ sky130_fd_sc_hd__a21o_1
X_2317_ net2 VGND VGND VPWR VPWR _1811_ sky130_fd_sc_hd__inv_2
XFILLER_0_32_3 VGND VGND VPWR VPWR sky130_fd_sc_hd__decap_6
XTAP_TAPCELL_ROW_68_755 VGND VPWR sky130_fd_sc_hd__tapvpwrvgnd_1
XTAP_TAPCELL_ROW_51_611 VGND VPWR sky130_fd_sc_hd__tapvpwrvgnd_1
XTAP_TAPCELL_ROW_23_368 VGND VPWR sky130_fd_sc_hd__tapvpwrvgnd_1
XFILLER_0_50_218 VGND VGND VPWR VPWR sky130_fd_sc_hd__decap_3
XFILLER_0_31_443 VGND VGND VPWR VPWR sky130_fd_sc_hd__decap_4
XFILLER_0_43_281 VPWR VGND VPWR VGND sky130_ef_sc_hd__decap_12
Xoutput34 net34 VGND VGND VPWR VPWR m_tdata[14] sky130_fd_sc_hd__buf_2
Xoutput56 net56 VGND VGND VPWR VPWR m_tdata[5] sky130_fd_sc_hd__buf_2
Xoutput45 net45 VGND VGND VPWR VPWR m_tdata[24] sky130_fd_sc_hd__buf_2
XFILLER_0_58_329 VGND VGND VPWR VPWR sky130_fd_sc_hd__fill_1
XFILLER_0_81_321 VPWR VGND VPWR VGND sky130_ef_sc_hd__decap_12
XFILLER_0_5_109 VGND VGND VPWR VPWR sky130_fd_sc_hd__decap_3
XFILLER_0_81_365 VGND VGND VPWR VPWR sky130_fd_sc_hd__fill_2
XFILLER_0_81_387 VGND VGND VPWR VPWR sky130_fd_sc_hd__decap_4
XFILLER_0_78_27 VGND VGND VPWR VPWR sky130_fd_sc_hd__fill_1
XFILLER_0_22_421 VGND VGND VPWR VPWR sky130_fd_sc_hd__decap_6
XFILLER_0_1_337 VPWR VGND VPWR VGND sky130_ef_sc_hd__decap_12
X_3220_ _0457_ _0458_ _1824_ _0460_ VGND VGND VPWR VPWR _0461_ sky130_fd_sc_hd__a22oi_1
X_3151_ _0348_ _0385_ _0383_ VGND VGND VPWR VPWR _0404_ sky130_fd_sc_hd__o21ai_1
X_3082_ _0333_ _0334_ _0335_ VGND VGND VPWR VPWR _0337_ sky130_fd_sc_hd__nor3_1
XTAP_TAPCELL_ROW_65_725 VGND VPWR sky130_fd_sc_hd__tapvpwrvgnd_1
XFILLER_0_49_329 VGND VGND VPWR VPWR sky130_fd_sc_hd__fill_1
XFILLER_0_43_96 VPWR VGND VPWR VGND sky130_ef_sc_hd__decap_12
X_3984_ _1154_ _1150_ VGND VGND VPWR VPWR _1208_ sky130_fd_sc_hd__and2b_1
XFILLER_0_72_321 VPWR VGND VPWR VGND sky130_ef_sc_hd__decap_12
X_2935_ net5 net6 net15 net16 VGND VGND VPWR VPWR _0194_ sky130_fd_sc_hd__and4_1
X_2866_ _2261_ VGND VGND VPWR VPWR _2262_ sky130_fd_sc_hd__inv_2
XFILLER_0_72_376 VPWR VGND VPWR VGND sky130_ef_sc_hd__decap_12
XTAP_TAPCELL_ROW_20_349 VGND VPWR sky130_fd_sc_hd__tapvpwrvgnd_1
X_4605_ net43 u_interface.core_attn_out\[22\] _1782_ VGND VGND VPWR VPWR _1791_ sky130_fd_sc_hd__mux2_1
XFILLER_0_4_153 VPWR VGND VPWR VGND sky130_ef_sc_hd__decap_12
X_2797_ _2163_ _2182_ _2193_ net25 VGND VGND VPWR VPWR _2195_ sky130_fd_sc_hd__a22oi_1
XFILLER_0_25_281 VGND VGND VPWR VPWR sky130_fd_sc_hd__fill_1
XPHY_EDGE_ROW_15_Left_97 VGND VGND VPWR VPWR sky130_fd_sc_hd__decap_3
XFILLER_0_4_197 VPWR VGND VPWR VGND sky130_ef_sc_hd__decap_12
X_4536_ net29 u_interface.core_attn_out\[0\] _1742_ VGND VGND VPWR VPWR _1744_ sky130_fd_sc_hd__mux2_1
X_4467_ _1662_ _1679_ VGND VGND VPWR VPWR _1681_ sky130_fd_sc_hd__or2_1
X_3418_ _0603_ _0604_ _0653_ VGND VGND VPWR VPWR _0654_ sky130_fd_sc_hd__a21oi_1
X_4398_ _1572_ _1613_ VGND VGND VPWR VPWR _1614_ sky130_fd_sc_hd__xnor2_1
X_3349_ u_interface.u_compute_core.u_av.v_extended\[0\] u_interface.u_compute_core.relu_data\[7\]
+ VGND VGND VPWR VPWR _0586_ sky130_fd_sc_hd__nand2_1
XTAP_TAPCELL_ROW_28_416 VGND VPWR sky130_fd_sc_hd__tapvpwrvgnd_1
XTAP_TAPCELL_ROW_36_482 VGND VPWR sky130_fd_sc_hd__tapvpwrvgnd_1
XFILLER_0_63_365 VGND VGND VPWR VPWR sky130_fd_sc_hd__fill_2
XFILLER_0_31_251 VGND VGND VPWR VPWR sky130_fd_sc_hd__fill_1
XFILLER_0_64_29 VPWR VGND VPWR VGND sky130_ef_sc_hd__decap_12
XTAP_TAPCELL_ROW_62_706 VGND VPWR sky130_fd_sc_hd__tapvpwrvgnd_1
XFILLER_0_58_148 VGND VGND VPWR VPWR sky130_fd_sc_hd__decap_6
XTAP_TAPCELL_ROW_70_772 VGND VPWR sky130_fd_sc_hd__tapvpwrvgnd_1
X_2720_ _2121_ _2125_ VGND VGND VPWR VPWR _2128_ sky130_fd_sc_hd__and2_1
XFILLER_0_14_207 VPWR VGND VPWR VGND sky130_ef_sc_hd__decap_12
X_2651_ _2065_ _2069_ VGND VGND VPWR VPWR _2070_ sky130_fd_sc_hd__nand2_1
X_2582_ u_interface.u_compute_core.u_mac.product_reg\[6\] u_interface.u_compute_core.mac_accum\[6\]
+ VGND VGND VPWR VPWR _2010_ sky130_fd_sc_hd__or2_1
X_4321_ _1536_ _1537_ VGND VGND VPWR VPWR _1538_ sky130_fd_sc_hd__xnor2_1
XFILLER_0_1_167 VGND VGND VPWR VPWR sky130_fd_sc_hd__fill_1
X_4252_ _1467_ _1470_ VGND VGND VPWR VPWR _1471_ sky130_fd_sc_hd__xnor2_1
X_3203_ _0446_ VGND VGND VPWR VPWR _0447_ sky130_fd_sc_hd__clkbuf_4
X_4183_ _1394_ _1402_ VGND VGND VPWR VPWR _1403_ sky130_fd_sc_hd__xor2_1
X_3134_ _0353_ _0356_ _0386_ VGND VGND VPWR VPWR _0388_ sky130_fd_sc_hd__or3_1
X_3065_ _0319_ _0320_ VGND VGND VPWR VPWR _0321_ sky130_fd_sc_hd__or2_1
XFILLER_0_54_51 VGND VGND VPWR VPWR sky130_fd_sc_hd__fill_1
XFILLER_0_49_126 VGND VGND VPWR VPWR sky130_fd_sc_hd__fill_1
XFILLER_0_77_479 VGND VGND VPWR VPWR sky130_fd_sc_hd__decap_4
X_3967_ _1189_ _1190_ VGND VGND VPWR VPWR _1191_ sky130_fd_sc_hd__xnor2_1
X_2918_ _2263_ _2267_ _2311_ VGND VGND VPWR VPWR _2313_ sky130_fd_sc_hd__and3_1
XFILLER_0_5_440 VGND VGND VPWR VPWR sky130_fd_sc_hd__decap_8
X_3898_ _1122_ _1123_ VGND VGND VPWR VPWR _1124_ sky130_fd_sc_hd__or2_1
XFILLER_0_45_387 VGND VGND VPWR VPWR sky130_fd_sc_hd__decap_4
X_2849_ _2164_ _2220_ _2244_ _2162_ VGND VGND VPWR VPWR _2245_ sky130_fd_sc_hd__a22oi_1
XFILLER_0_60_324 VGND VGND VPWR VPWR sky130_fd_sc_hd__decap_3
XFILLER_0_79_81 VPWR VGND VPWR VGND sky130_ef_sc_hd__decap_12
X_4519_ _1697_ _1700_ _1729_ VGND VGND VPWR VPWR _1730_ sky130_fd_sc_hd__a21oi_4
XFILLER_0_55_129 VGND VGND VPWR VPWR sky130_fd_sc_hd__decap_8
XFILLER_0_36_343 VPWR VGND VPWR VGND sky130_ef_sc_hd__decap_12
XFILLER_0_36_365 VPWR VGND VPWR VGND sky130_ef_sc_hd__decap_12
XFILLER_0_63_151 VGND VGND VPWR VPWR sky130_fd_sc_hd__decap_6
XFILLER_0_51_335 VGND VGND VPWR VPWR sky130_fd_sc_hd__fill_1
XFILLER_0_63_195 VGND VGND VPWR VPWR sky130_fd_sc_hd__decap_8
XFILLER_0_51_368 VGND VGND VPWR VPWR sky130_fd_sc_hd__decap_4
XFILLER_0_75_39 VPWR VGND VPWR VGND sky130_ef_sc_hd__decap_12
XFILLER_0_24_32 VGND VGND VPWR VPWR sky130_fd_sc_hd__decap_8
XTAP_TAPCELL_ROW_47_577 VGND VPWR sky130_fd_sc_hd__tapvpwrvgnd_1
XFILLER_0_24_76 VGND VGND VPWR VPWR sky130_fd_sc_hd__fill_1
X_3821_ _1047_ _1046_ VGND VGND VPWR VPWR _1048_ sky130_fd_sc_hd__xnor2_2
XFILLER_0_27_332 VGND VGND VPWR VPWR sky130_fd_sc_hd__decap_4
XTAP_TAPCELL_ROW_30_433 VGND VPWR sky130_fd_sc_hd__tapvpwrvgnd_1
X_3752_ _0940_ _0941_ _0980_ VGND VGND VPWR VPWR _0981_ sky130_fd_sc_hd__or3_1
XFILLER_0_42_302 VGND VGND VPWR VPWR sky130_fd_sc_hd__decap_6
X_3683_ _0437_ u_interface.u_compute_core.relu_data\[10\] _0860_ VGND VGND VPWR VPWR
+ _0913_ sky130_fd_sc_hd__and3_1
XFILLER_0_42_335 VPWR VGND VPWR VGND sky130_ef_sc_hd__decap_12
XFILLER_0_54_195 VGND VGND VPWR VPWR sky130_fd_sc_hd__fill_1
X_2703_ _2112_ _2113_ VGND VGND VPWR VPWR _2114_ sky130_fd_sc_hd__xnor2_1
XFILLER_0_2_421 VPWR VGND VPWR VGND sky130_ef_sc_hd__decap_12
X_2634_ _2046_ _2049_ _2054_ VGND VGND VPWR VPWR _2055_ sky130_fd_sc_hd__a21oi_1
X_2565_ u_interface.u_compute_core.u_mac.product_reg\[4\] u_interface.u_compute_core.mac_accum\[4\]
+ VGND VGND VPWR VPWR _1995_ sky130_fd_sc_hd__or2_1
X_4304_ _1520_ _1470_ _1521_ VGND VGND VPWR VPWR _1522_ sky130_fd_sc_hd__a21o_1
X_2496_ u_interface.u_compute_core.scaled_data\[18\] u_interface.u_compute_core.mac_accum\[21\]
+ _1922_ VGND VGND VPWR VPWR _1942_ sky130_fd_sc_hd__mux2_1
X_4235_ _1451_ _1453_ VGND VGND VPWR VPWR _1454_ sky130_fd_sc_hd__xor2_1
XFILLER_0_4_53 VPWR VGND VPWR VGND sky130_ef_sc_hd__decap_12
X_4166_ _1383_ _1385_ VGND VGND VPWR VPWR _1386_ sky130_fd_sc_hd__xnor2_1
X_3117_ _0334_ _0337_ _0370_ VGND VGND VPWR VPWR _0371_ sky130_fd_sc_hd__o21ai_1
XFILLER_0_4_97 VPWR VGND VPWR VGND sky130_ef_sc_hd__decap_12
XPHY_EDGE_ROW_27_Left_109 VGND VGND VPWR VPWR sky130_fd_sc_hd__decap_3
XTAP_TAPCELL_ROW_38_500 VGND VPWR sky130_fd_sc_hd__tapvpwrvgnd_1
X_4097_ u_interface.core_attn_out\[18\] _1268_ VGND VGND VPWR VPWR _1319_ sky130_fd_sc_hd__and2_1
X_3048_ _0264_ _0266_ VGND VGND VPWR VPWR _0304_ sky130_fd_sc_hd__or2_1
XTAP_TAPCELL_ROW_81_867 VGND VPWR sky130_fd_sc_hd__tapvpwrvgnd_1
XFILLER_0_18_354 VGND VGND VPWR VPWR sky130_fd_sc_hd__fill_1
XFILLER_0_18_365 VPWR VGND VPWR VGND sky130_ef_sc_hd__decap_12
XFILLER_0_18_398 VGND VGND VPWR VPWR sky130_fd_sc_hd__decap_6
XFILLER_0_33_335 VGND VGND VPWR VPWR sky130_fd_sc_hd__fill_1
XPHY_EDGE_ROW_36_Left_118 VGND VGND VPWR VPWR sky130_fd_sc_hd__decap_3
XFILLER_0_60_132 VGND VGND VPWR VPWR sky130_fd_sc_hd__decap_8
XFILLER_0_5_281 VPWR VGND VPWR VGND sky130_ef_sc_hd__decap_12
XFILLER_0_33_379 VPWR VGND VPWR VGND sky130_ef_sc_hd__decap_12
XFILLER_0_41_390 VGND VGND VPWR VPWR sky130_fd_sc_hd__fill_2
XPHY_EDGE_ROW_45_Left_127 VGND VGND VPWR VPWR sky130_fd_sc_hd__decap_3
XFILLER_0_68_210 VPWR VGND VPWR VGND sky130_ef_sc_hd__decap_12
XTAP_TAPCELL_ROW_44_547 VGND VPWR sky130_fd_sc_hd__tapvpwrvgnd_1
XPHY_EDGE_ROW_54_Left_136 VGND VGND VPWR VPWR sky130_fd_sc_hd__decap_3
XFILLER_0_51_121 VGND VGND VPWR VPWR sky130_fd_sc_hd__fill_1
XFILLER_0_10_45 VPWR VGND VPWR VGND sky130_ef_sc_hd__decap_12
XFILLER_0_19_21 VPWR VGND VPWR VGND sky130_ef_sc_hd__decap_12
X_2350_ u_interface.u_compute_core.scaled_data\[6\] _1815_ _1836_ _1817_ VGND VGND
+ VPWR VPWR _1837_ sky130_fd_sc_hd__o2bb2a_1
XPHY_EDGE_ROW_63_Left_145 VGND VGND VPWR VPWR sky130_fd_sc_hd__decap_3
X_4020_ _1186_ _1191_ _1242_ VGND VGND VPWR VPWR _1243_ sky130_fd_sc_hd__a21boi_1
XFILLER_0_47_405 VGND VGND VPWR VPWR sky130_fd_sc_hd__decap_6
XPHY_EDGE_ROW_72_Left_154 VGND VGND VPWR VPWR sky130_fd_sc_hd__decap_3
XFILLER_0_51_30 VGND VGND VPWR VPWR sky130_fd_sc_hd__decap_3
XFILLER_0_74_246 VGND VGND VPWR VPWR sky130_fd_sc_hd__decap_6
X_4784_ clknet_4_9_0_clk _0149_ VGND VGND VPWR VPWR net61 sky130_fd_sc_hd__dfxtp_1
X_3804_ _0978_ _0981_ _1030_ VGND VGND VPWR VPWR _1032_ sky130_fd_sc_hd__a21oi_1
XFILLER_0_51_74 VPWR VGND VPWR VGND sky130_ef_sc_hd__decap_12
XFILLER_0_62_419 VGND VGND VPWR VPWR sky130_fd_sc_hd__fill_1
X_3735_ _0963_ _0961_ VGND VGND VPWR VPWR _0964_ sky130_fd_sc_hd__xor2_1
X_3666_ _0805_ _0852_ _0895_ VGND VGND VPWR VPWR _0896_ sky130_fd_sc_hd__a21o_1
XFILLER_0_42_187 VGND VGND VPWR VPWR sky130_fd_sc_hd__decap_8
XFILLER_0_2_251 VGND VGND VPWR VPWR sky130_fd_sc_hd__fill_1
X_3597_ _0828_ _0826_ VGND VGND VPWR VPWR _0829_ sky130_fd_sc_hd__xnor2_2
X_2617_ _2034_ _2037_ _2033_ VGND VGND VPWR VPWR _2040_ sky130_fd_sc_hd__a21boi_2
XFILLER_0_62_3 VPWR VGND VPWR VGND sky130_ef_sc_hd__decap_12
XPHY_EDGE_ROW_81_Left_163 VGND VGND VPWR VPWR sky130_fd_sc_hd__decap_3
XTAP_TAPCELL_ROW_7_239 VGND VPWR sky130_fd_sc_hd__tapvpwrvgnd_1
X_2548_ _1973_ _1977_ _1978_ _1980_ net99 VGND VGND VPWR VPWR _0060_ sky130_fd_sc_hd__a32o_1
X_2479_ _1930_ VGND VGND VPWR VPWR _0041_ sky130_fd_sc_hd__clkbuf_1
X_4218_ _1433_ _1434_ _1435_ VGND VGND VPWR VPWR _1437_ sky130_fd_sc_hd__nor3_1
X_4149_ _1363_ _1369_ VGND VGND VPWR VPWR _1370_ sky130_fd_sc_hd__xor2_1
XFILLER_0_38_449 VGND VGND VPWR VPWR sky130_fd_sc_hd__fill_1
XTAP_TAPCELL_ROW_41_528 VGND VPWR sky130_fd_sc_hd__tapvpwrvgnd_1
XFILLER_0_65_246 VGND VGND VPWR VPWR sky130_fd_sc_hd__decap_4
XFILLER_0_80_216 VGND VGND VPWR VPWR sky130_fd_sc_hd__fill_1
XFILLER_0_46_471 VGND VGND VPWR VPWR sky130_fd_sc_hd__decap_4
XFILLER_0_18_195 VGND VGND VPWR VPWR sky130_fd_sc_hd__fill_1
Xclkload0 clknet_4_0_0_clk VGND VGND VPWR VPWR clkload0/Y sky130_fd_sc_hd__clkinv_4
XFILLER_0_33_143 VGND VGND VPWR VPWR sky130_fd_sc_hd__decap_8
XFILLER_0_33_187 VGND VGND VPWR VPWR sky130_fd_sc_hd__fill_1
XPHY_EDGE_ROW_3_Left_85 VGND VGND VPWR VPWR sky130_fd_sc_hd__decap_3
XFILLER_0_72_29 VPWR VGND VPWR VGND sky130_ef_sc_hd__decap_12
XTAP_TAPCELL_ROW_57_661 VGND VPWR sky130_fd_sc_hd__tapvpwrvgnd_1
XFILLER_0_29_449 VGND VGND VPWR VPWR sky130_fd_sc_hd__decap_8
XFILLER_0_56_257 VGND VGND VPWR VPWR sky130_fd_sc_hd__decap_3
XFILLER_0_71_216 VGND VGND VPWR VPWR sky130_fd_sc_hd__decap_8
XFILLER_0_44_419 VGND VGND VPWR VPWR sky130_fd_sc_hd__fill_1
XFILLER_0_37_482 VGND VGND VPWR VPWR sky130_fd_sc_hd__fill_2
XTAP_TAPCELL_ROW_12_274 VGND VPWR sky130_fd_sc_hd__tapvpwrvgnd_1
X_3520_ _0752_ _0753_ VGND VGND VPWR VPWR _0754_ sky130_fd_sc_hd__or2b_1
XFILLER_0_52_441 VGND VGND VPWR VPWR sky130_fd_sc_hd__decap_3
XFILLER_0_12_316 VPWR VGND VPWR VGND sky130_ef_sc_hd__decap_12
XFILLER_0_24_165 VGND VGND VPWR VPWR sky130_fd_sc_hd__decap_3
X_3451_ net83 u_interface.u_compute_core.relu_data\[6\] VGND VGND VPWR VPWR _0686_
+ sky130_fd_sc_hd__nand2_1
X_3382_ _0617_ _0618_ VGND VGND VPWR VPWR _0619_ sky130_fd_sc_hd__xnor2_1
X_2402_ _1848_ _1876_ VGND VGND VPWR VPWR _0018_ sky130_fd_sc_hd__nor2_1
X_2333_ u_interface.u_compute_core.relu_data\[2\] VGND VGND VPWR VPWR _1824_ sky130_fd_sc_hd__clkbuf_4
XTAP_TAPCELL_ROW_4_209 VGND VPWR sky130_fd_sc_hd__tapvpwrvgnd_1
XFILLER_0_46_85 VPWR VGND VPWR VGND sky130_ef_sc_hd__decap_12
X_4003_ _0938_ _1225_ _1226_ _0667_ VGND VGND VPWR VPWR _0134_ sky130_fd_sc_hd__o211a_1
XFILLER_0_28_471 VGND VGND VPWR VPWR sky130_fd_sc_hd__decap_4
X_4767_ clknet_4_9_0_clk _0132_ VGND VGND VPWR VPWR u_interface.core_attn_out\[15\]
+ sky130_fd_sc_hd__dfxtp_1
X_4698_ clknet_4_1_0_clk _0063_ VGND VGND VPWR VPWR u_interface.u_compute_core.mac_accum\[4\]
+ sky130_fd_sc_hd__dfxtp_1
X_3718_ _0457_ _1865_ _1862_ _0460_ VGND VGND VPWR VPWR _0947_ sky130_fd_sc_hd__a22oi_1
X_3649_ net65 _0661_ _0706_ _0749_ _0838_ VGND VGND VPWR VPWR _0880_ sky130_fd_sc_hd__a311o_1
Xhold34 u_interface.u_compute_core.u_mac.product_reg\[3\] VGND VGND VPWR VPWR net98
+ sky130_fd_sc_hd__dlygate4sd3_1
Xhold56 u_interface.u_compute_core.u_mac.product_reg\[9\] VGND VGND VPWR VPWR net120
+ sky130_fd_sc_hd__dlygate4sd3_1
Xhold45 u_interface.u_compute_core.u_mac.product_reg\[5\] VGND VGND VPWR VPWR net109
+ sky130_fd_sc_hd__dlygate4sd3_1
Xhold67 u_interface.core_attn_out\[0\] VGND VGND VPWR VPWR net131 sky130_fd_sc_hd__dlygate4sd3_1
Xhold89 u_interface.u_compute_core.mac_accum\[20\] VGND VGND VPWR VPWR net153 sky130_fd_sc_hd__dlygate4sd3_1
Xhold78 u_interface.u_compute_core.mac_accum\[21\] VGND VGND VPWR VPWR net142 sky130_fd_sc_hd__dlygate4sd3_1
XFILLER_0_38_213 VGND VGND VPWR VPWR sky130_fd_sc_hd__fill_2
XTAP_TAPCELL_ROW_54_631 VGND VPWR sky130_fd_sc_hd__tapvpwrvgnd_1
XTAP_TAPCELL_ROW_26_399 VGND VPWR sky130_fd_sc_hd__tapvpwrvgnd_1
XFILLER_0_26_408 VGND VGND VPWR VPWR sky130_fd_sc_hd__decap_6
XFILLER_0_21_113 VGND VGND VPWR VPWR sky130_fd_sc_hd__fill_1
XTAP_TAPCELL_ROW_17_322 VGND VPWR sky130_fd_sc_hd__tapvpwrvgnd_1
XFILLER_0_16_99 VGND VGND VPWR VPWR sky130_fd_sc_hd__fill_2
XFILLER_0_29_213 VGND VGND VPWR VPWR sky130_fd_sc_hd__fill_2
X_2951_ _0202_ _0208_ VGND VGND VPWR VPWR _0210_ sky130_fd_sc_hd__nor2_1
X_4621_ _1901_ _1801_ VGND VGND VPWR VPWR _1802_ sky130_fd_sc_hd__and2_1
X_2882_ net10 net13 net6 net9 VGND VGND VPWR VPWR _2277_ sky130_fd_sc_hd__and4b_1
XFILLER_0_32_76 VGND VGND VPWR VPWR sky130_fd_sc_hd__fill_2
XFILLER_0_44_216 VGND VGND VPWR VPWR sky130_fd_sc_hd__fill_1
XTAP_TAPCELL_ROW_60_689 VGND VPWR sky130_fd_sc_hd__tapvpwrvgnd_1
XFILLER_0_4_357 VGND VGND VPWR VPWR sky130_fd_sc_hd__decap_6
X_4552_ _1753_ _1754_ VGND VGND VPWR VPWR _1755_ sky130_fd_sc_hd__and2_1
X_4483_ _1567_ _1613_ VGND VGND VPWR VPWR _1696_ sky130_fd_sc_hd__nand2_1
XFILLER_0_12_124 VGND VGND VPWR VPWR sky130_fd_sc_hd__fill_1
X_3503_ _0688_ _0691_ VGND VGND VPWR VPWR _0737_ sky130_fd_sc_hd__and2_1
X_3434_ _0625_ _0631_ _0668_ VGND VGND VPWR VPWR _0669_ sky130_fd_sc_hd__a21bo_1
XFILLER_0_40_477 VGND VGND VPWR VPWR sky130_fd_sc_hd__decap_6
X_3365_ _0599_ _0601_ VGND VGND VPWR VPWR _0602_ sky130_fd_sc_hd__xor2_1
X_3296_ u_interface.core_attn_out\[2\] _0533_ _0534_ VGND VGND VPWR VPWR _0535_ sky130_fd_sc_hd__and3_1
XTAP_TAPCELL_ROW_68_756 VGND VPWR sky130_fd_sc_hd__tapvpwrvgnd_1
XFILLER_0_79_113 VPWR VGND VPWR VGND sky130_ef_sc_hd__decap_12
XFILLER_0_25_3 VGND VGND VPWR VPWR sky130_fd_sc_hd__decap_8
XFILLER_0_79_179 VGND VGND VPWR VPWR sky130_fd_sc_hd__decap_3
XFILLER_0_67_308 VGND VGND VPWR VPWR sky130_fd_sc_hd__decap_6
XTAP_TAPCELL_ROW_51_612 VGND VPWR sky130_fd_sc_hd__tapvpwrvgnd_1
XTAP_TAPCELL_ROW_23_369 VGND VPWR sky130_fd_sc_hd__tapvpwrvgnd_1
XFILLER_0_43_293 VGND VGND VPWR VPWR sky130_fd_sc_hd__decap_4
Xoutput57 net57 VGND VGND VPWR VPWR m_tdata[6] sky130_fd_sc_hd__buf_2
Xoutput35 net35 VGND VGND VPWR VPWR m_tdata[15] sky130_fd_sc_hd__buf_2
Xoutput46 net46 VGND VGND VPWR VPWR m_tdata[25] sky130_fd_sc_hd__buf_2
XPHY_EDGE_ROW_19_Right_19 VGND VGND VPWR VPWR sky130_fd_sc_hd__decap_3
XFILLER_0_26_227 VGND VGND VPWR VPWR sky130_fd_sc_hd__fill_1
XFILLER_0_81_333 VGND VGND VPWR VPWR sky130_fd_sc_hd__decap_3
XFILLER_0_1_305 VPWR VGND VPWR VGND sky130_ef_sc_hd__decap_12
XFILLER_0_1_349 VPWR VGND VPWR VGND sky130_ef_sc_hd__decap_12
XFILLER_0_22_477 VGND VGND VPWR VPWR sky130_fd_sc_hd__decap_3
XPHY_EDGE_ROW_28_Right_28 VGND VGND VPWR VPWR sky130_fd_sc_hd__decap_3
X_3150_ _0348_ _0402_ VGND VGND VPWR VPWR _0403_ sky130_fd_sc_hd__xnor2_1
X_3081_ _0333_ _0334_ _0335_ VGND VGND VPWR VPWR _0336_ sky130_fd_sc_hd__o21a_1
XPHY_EDGE_ROW_37_Right_37 VGND VGND VPWR VPWR sky130_fd_sc_hd__decap_3
XTAP_TAPCELL_ROW_65_726 VGND VPWR sky130_fd_sc_hd__tapvpwrvgnd_1
XFILLER_0_9_405 VGND VGND VPWR VPWR sky130_fd_sc_hd__fill_1
XFILLER_0_57_330 VGND VGND VPWR VPWR sky130_fd_sc_hd__decap_6
XFILLER_0_9_449 VPWR VGND VPWR VGND sky130_ef_sc_hd__decap_12
X_3983_ _1205_ _1206_ VGND VGND VPWR VPWR _1207_ sky130_fd_sc_hd__xor2_1
X_2934_ net6 net15 _2226_ net5 VGND VGND VPWR VPWR _0193_ sky130_fd_sc_hd__a22oi_1
XFILLER_0_72_333 VGND VGND VPWR VPWR sky130_fd_sc_hd__decap_4
XFILLER_0_17_249 VGND VGND VPWR VPWR sky130_fd_sc_hd__decap_4
X_2865_ _2253_ _2260_ VGND VGND VPWR VPWR _2261_ sky130_fd_sc_hd__xnor2_1
XFILLER_0_72_388 VGND VGND VPWR VPWR sky130_fd_sc_hd__decap_4
XFILLER_0_4_121 VPWR VGND VPWR VGND sky130_ef_sc_hd__decap_12
XPHY_EDGE_ROW_46_Right_46 VGND VGND VPWR VPWR sky130_fd_sc_hd__decap_3
X_4604_ _1790_ VGND VGND VPWR VPWR _0171_ sky130_fd_sc_hd__clkbuf_1
XFILLER_0_4_165 VPWR VGND VPWR VGND sky130_ef_sc_hd__decap_12
X_2796_ net25 _2163_ _2182_ _2193_ VGND VGND VPWR VPWR _2194_ sky130_fd_sc_hd__and4_1
X_4535_ _1742_ _1743_ net62 VGND VGND VPWR VPWR _0149_ sky130_fd_sc_hd__o21a_1
X_4466_ _1662_ _1679_ VGND VGND VPWR VPWR _1680_ sky130_fd_sc_hd__nand2_1
XFILLER_0_7_75 VGND VGND VPWR VPWR sky130_fd_sc_hd__fill_1
XFILLER_0_7_64 VGND VGND VPWR VPWR sky130_fd_sc_hd__fill_2
X_4397_ _1611_ _1612_ VGND VGND VPWR VPWR _1613_ sky130_fd_sc_hd__and2_1
X_3417_ _0590_ _0605_ VGND VGND VPWR VPWR _0653_ sky130_fd_sc_hd__nor2b_1
XFILLER_0_7_97 VGND VGND VPWR VPWR sky130_fd_sc_hd__fill_1
X_3348_ u_interface.u_compute_core.u_av.v_extended\[1\] u_interface.u_compute_core.relu_data\[6\]
+ VGND VGND VPWR VPWR _0585_ sky130_fd_sc_hd__nand2_1
XFILLER_0_0_393 VPWR VGND VPWR VGND sky130_ef_sc_hd__decap_12
X_3279_ _0515_ _0516_ _0486_ VGND VGND VPWR VPWR _0518_ sky130_fd_sc_hd__a21bo_1
XPHY_EDGE_ROW_55_Right_55 VGND VGND VPWR VPWR sky130_fd_sc_hd__decap_3
XTAP_TAPCELL_ROW_28_417 VGND VPWR sky130_fd_sc_hd__tapvpwrvgnd_1
XTAP_TAPCELL_ROW_36_483 VGND VPWR sky130_fd_sc_hd__tapvpwrvgnd_1
XFILLER_0_48_363 VGND VGND VPWR VPWR sky130_fd_sc_hd__fill_1
XPHY_EDGE_ROW_64_Right_64 VGND VGND VPWR VPWR sky130_fd_sc_hd__decap_3
XFILLER_0_63_377 VPWR VGND VPWR VGND sky130_ef_sc_hd__decap_12
XPHY_EDGE_ROW_73_Right_73 VGND VGND VPWR VPWR sky130_fd_sc_hd__decap_3
XFILLER_0_58_105 VPWR VGND VPWR VGND sky130_ef_sc_hd__decap_12
XFILLER_0_80_29 VPWR VGND VPWR VGND sky130_ef_sc_hd__decap_12
XTAP_TAPCELL_ROW_62_707 VGND VPWR sky130_fd_sc_hd__tapvpwrvgnd_1
XTAP_TAPCELL_ROW_70_773 VGND VPWR sky130_fd_sc_hd__tapvpwrvgnd_1
XFILLER_0_13_45 VGND VGND VPWR VPWR sky130_fd_sc_hd__fill_2
XFILLER_0_81_141 VPWR VGND VPWR VGND sky130_ef_sc_hd__decap_12
XFILLER_0_13_78 VGND VGND VPWR VPWR sky130_fd_sc_hd__decap_3
XFILLER_0_6_419 VGND VGND VPWR VPWR sky130_fd_sc_hd__fill_1
XFILLER_0_54_333 VPWR VGND VPWR VGND sky130_ef_sc_hd__decap_12
XFILLER_0_14_219 VGND VGND VPWR VPWR sky130_fd_sc_hd__decap_3
X_2650_ _2068_ u_interface.u_compute_core.mac_accum\[15\] VGND VGND VPWR VPWR _2069_
+ sky130_fd_sc_hd__or2_1
XFILLER_0_1_113 VPWR VGND VPWR VGND sky130_ef_sc_hd__decap_12
XFILLER_0_22_230 VPWR VGND VPWR VGND sky130_ef_sc_hd__decap_12
X_2581_ u_interface.u_compute_core.u_mac.product_reg\[6\] u_interface.u_compute_core.mac_accum\[6\]
+ VGND VGND VPWR VPWR _2009_ sky130_fd_sc_hd__and2_1
XFILLER_0_22_285 VGND VGND VPWR VPWR sky130_fd_sc_hd__decap_4
X_4320_ _1477_ _1479_ _1476_ VGND VGND VPWR VPWR _1537_ sky130_fd_sc_hd__o21ba_1
X_4251_ _1363_ _1369_ _1468_ _1469_ VGND VGND VPWR VPWR _1470_ sky130_fd_sc_hd__a31o_1
X_3202_ _0445_ VGND VGND VPWR VPWR _0446_ sky130_fd_sc_hd__clkbuf_2
X_4182_ _1345_ _1401_ VGND VGND VPWR VPWR _1402_ sky130_fd_sc_hd__xnor2_1
XTAP_TAPCELL_ROW_78_840 VGND VPWR sky130_fd_sc_hd__tapvpwrvgnd_1
X_3133_ _0353_ _0356_ _0386_ VGND VGND VPWR VPWR _0387_ sky130_fd_sc_hd__o21a_1
X_3064_ _0314_ _0318_ VGND VGND VPWR VPWR _0320_ sky130_fd_sc_hd__nor2_1
XFILLER_0_77_447 VGND VGND VPWR VPWR sky130_fd_sc_hd__fill_1
XFILLER_0_54_85 VGND VGND VPWR VPWR sky130_fd_sc_hd__fill_2
XFILLER_0_9_213 VGND VGND VPWR VPWR sky130_fd_sc_hd__decap_8
XFILLER_0_9_268 VPWR VGND VPWR VGND sky130_ef_sc_hd__decap_12
XTAP_TAPCELL_ROW_33_453 VGND VPWR sky130_fd_sc_hd__tapvpwrvgnd_1
X_3966_ _0431_ _1874_ VGND VGND VPWR VPWR _1190_ sky130_fd_sc_hd__nand2_1
X_2917_ _2263_ _2267_ _2311_ VGND VGND VPWR VPWR _2312_ sky130_fd_sc_hd__a21oi_1
XFILLER_0_70_95 VPWR VGND VPWR VGND sky130_ef_sc_hd__decap_12
X_3897_ _1120_ _1121_ u_interface.core_attn_out\[15\] VGND VGND VPWR VPWR _1123_ sky130_fd_sc_hd__a21oi_1
X_2848_ net8 VGND VGND VPWR VPWR _2244_ sky130_fd_sc_hd__buf_2
XFILLER_0_60_347 VGND VGND VPWR VPWR sky130_fd_sc_hd__fill_2
X_2779_ net5 VGND VGND VPWR VPWR _2178_ sky130_fd_sc_hd__buf_2
XFILLER_0_79_93 VPWR VGND VPWR VGND sky130_ef_sc_hd__decap_12
X_4518_ _1720_ _1723_ VGND VGND VPWR VPWR _1729_ sky130_fd_sc_hd__nand2_1
XFILLER_0_13_285 VPWR VGND VPWR VGND sky130_ef_sc_hd__decap_12
X_4449_ _0439_ u_interface.u_compute_core.relu_data\[27\] VGND VGND VPWR VPWR _1663_
+ sky130_fd_sc_hd__and2_1
XFILLER_0_68_469 VGND VGND VPWR VPWR sky130_fd_sc_hd__decap_6
XFILLER_0_36_355 VGND VGND VPWR VPWR sky130_fd_sc_hd__decap_8
XTAP_TAPCELL_ROW_75_810 VGND VPWR sky130_fd_sc_hd__tapvpwrvgnd_1
XTAP_TAPCELL_ROW_47_578 VGND VPWR sky130_fd_sc_hd__tapvpwrvgnd_1
X_3820_ _0436_ u_interface.u_compute_core.relu_data\[14\] VGND VGND VPWR VPWR _1047_
+ sky130_fd_sc_hd__nand2_1
X_3751_ _0978_ _0979_ VGND VGND VPWR VPWR _0980_ sky130_fd_sc_hd__nand2_1
XFILLER_0_6_249 VGND VGND VPWR VPWR sky130_fd_sc_hd__decap_3
XTAP_TAPCELL_ROW_30_434 VGND VPWR sky130_fd_sc_hd__tapvpwrvgnd_1
XFILLER_0_40_43 VPWR VGND VPWR VGND sky130_ef_sc_hd__decap_12
XFILLER_0_54_141 VGND VGND VPWR VPWR sky130_fd_sc_hd__fill_2
X_2702_ _2105_ _2109_ _2106_ VGND VGND VPWR VPWR _2113_ sky130_fd_sc_hd__o21a_1
X_3682_ _0908_ _0911_ VGND VGND VPWR VPWR _0912_ sky130_fd_sc_hd__xnor2_2
XFILLER_0_40_76 VGND VGND VPWR VPWR sky130_fd_sc_hd__decap_8
XFILLER_0_42_347 VPWR VGND VPWR VGND sky130_ef_sc_hd__decap_12
X_2633_ _2052_ _2053_ VGND VGND VPWR VPWR _2054_ sky130_fd_sc_hd__nand2_1
XFILLER_0_2_433 VPWR VGND VPWR VGND sky130_ef_sc_hd__decap_12
X_2564_ u_interface.u_compute_core.u_mac.product_reg\[4\] u_interface.u_compute_core.mac_accum\[4\]
+ VGND VGND VPWR VPWR _1994_ sky130_fd_sc_hd__nand2_1
XFILLER_0_49_30 VGND VGND VPWR VPWR sky130_fd_sc_hd__fill_1
XFILLER_0_2_477 VGND VGND VPWR VPWR sky130_fd_sc_hd__decap_6
X_4303_ u_interface.core_attn_out\[22\] _1466_ VGND VGND VPWR VPWR _1521_ sky130_fd_sc_hd__and2_1
XFILLER_0_57_6 VPWR VGND VPWR VGND sky130_ef_sc_hd__decap_12
X_2495_ _1941_ VGND VGND VPWR VPWR _0046_ sky130_fd_sc_hd__clkbuf_1
X_4234_ _1394_ _1402_ _1452_ VGND VGND VPWR VPWR _1453_ sky130_fd_sc_hd__o21a_1
XFILLER_0_4_65 VPWR VGND VPWR VGND sky130_ef_sc_hd__decap_12
X_4165_ _0443_ _1151_ _1328_ _1384_ VGND VGND VPWR VPWR _1385_ sky130_fd_sc_hd__a31oi_1
XFILLER_0_65_51 VGND VGND VPWR VPWR sky130_fd_sc_hd__decap_4
X_3116_ _0368_ _0369_ VGND VGND VPWR VPWR _0370_ sky130_fd_sc_hd__and2_1
XTAP_TAPCELL_ROW_38_501 VGND VPWR sky130_fd_sc_hd__tapvpwrvgnd_1
X_4096_ _1316_ _1317_ VGND VGND VPWR VPWR _1318_ sky130_fd_sc_hd__nand2_1
X_3047_ _0301_ _0302_ VGND VGND VPWR VPWR _0303_ sky130_fd_sc_hd__nor2_1
XTAP_TAPCELL_ROW_81_868 VGND VPWR sky130_fd_sc_hd__tapvpwrvgnd_1
XFILLER_0_77_299 VPWR VGND VPWR VGND sky130_ef_sc_hd__decap_12
XFILLER_0_45_130 VGND VGND VPWR VPWR sky130_fd_sc_hd__decap_8
X_3949_ _1028_ _1029_ _1074_ _1124_ VGND VGND VPWR VPWR _1174_ sky130_fd_sc_hd__nor4_1
XFILLER_0_73_483 VGND VGND VPWR VPWR sky130_fd_sc_hd__fill_1
XFILLER_0_45_196 VGND VGND VPWR VPWR sky130_fd_sc_hd__decap_6
XFILLER_0_5_260 VPWR VGND VPWR VGND sky130_ef_sc_hd__decap_12
XFILLER_0_5_293 VPWR VGND VPWR VGND sky130_ef_sc_hd__decap_12
XFILLER_0_60_166 VGND VGND VPWR VPWR sky130_fd_sc_hd__fill_2
XFILLER_0_68_222 VPWR VGND VPWR VGND sky130_ef_sc_hd__decap_12
XTAP_TAPCELL_ROW_1_181 VGND VPWR sky130_fd_sc_hd__tapvpwrvgnd_1
XTAP_TAPCELL_ROW_44_548 VGND VPWR sky130_fd_sc_hd__tapvpwrvgnd_1
XFILLER_0_56_417 VGND VGND VPWR VPWR sky130_fd_sc_hd__decap_3
XFILLER_0_51_111 VGND VGND VPWR VPWR sky130_fd_sc_hd__fill_1
XFILLER_0_10_57 VPWR VGND VPWR VGND sky130_ef_sc_hd__decap_12
XFILLER_0_51_177 VGND VGND VPWR VPWR sky130_fd_sc_hd__fill_1
XFILLER_0_32_391 VPWR VGND VPWR VGND sky130_ef_sc_hd__decap_12
XFILLER_0_51_199 VGND VGND VPWR VPWR sky130_fd_sc_hd__fill_2
XFILLER_0_19_33 VGND VGND VPWR VPWR sky130_fd_sc_hd__fill_2
XFILLER_0_35_65 VGND VGND VPWR VPWR sky130_fd_sc_hd__fill_1
XFILLER_0_35_98 VPWR VGND VPWR VGND sky130_ef_sc_hd__decap_12
X_3803_ _0978_ _0981_ _1030_ VGND VGND VPWR VPWR _1031_ sky130_fd_sc_hd__and3_1
X_4783_ clknet_4_13_0_clk _0148_ VGND VGND VPWR VPWR u_interface.core_attn_out\[31\]
+ sky130_fd_sc_hd__dfxtp_1
XFILLER_0_51_86 VPWR VGND VPWR VGND sky130_ef_sc_hd__decap_12
XFILLER_0_27_185 VGND VGND VPWR VPWR sky130_fd_sc_hd__fill_1
X_3734_ _0911_ _1850_ _0689_ _0962_ VGND VGND VPWR VPWR _0963_ sky130_fd_sc_hd__a31o_1
X_3665_ _0851_ _0848_ VGND VGND VPWR VPWR _0895_ sky130_fd_sc_hd__and2b_1
X_2616_ net132 _1969_ _2039_ net62 VGND VGND VPWR VPWR _0069_ sky130_fd_sc_hd__o211a_1
X_3596_ _0769_ _0786_ _0827_ VGND VGND VPWR VPWR _0828_ sky130_fd_sc_hd__o21a_1
X_2547_ _1979_ VGND VGND VPWR VPWR _1980_ sky130_fd_sc_hd__clkbuf_4
X_2478_ _1909_ _1929_ VGND VGND VPWR VPWR _1930_ sky130_fd_sc_hd__and2_1
XFILLER_0_55_3 VPWR VGND VPWR VGND sky130_ef_sc_hd__decap_12
XFILLER_0_76_83 VGND VGND VPWR VPWR sky130_fd_sc_hd__fill_1
X_4217_ _1433_ _1434_ _1435_ VGND VGND VPWR VPWR _1436_ sky130_fd_sc_hd__o21a_1
X_4148_ _1366_ _1368_ VGND VGND VPWR VPWR _1369_ sky130_fd_sc_hd__nand2b_1
X_4079_ _1299_ _1300_ VGND VGND VPWR VPWR _1301_ sky130_fd_sc_hd__nor2_1
XFILLER_0_65_225 VGND VGND VPWR VPWR sky130_fd_sc_hd__fill_1
XFILLER_0_18_141 VPWR VGND VPWR VGND sky130_ef_sc_hd__decap_12
XFILLER_0_33_111 VGND VGND VPWR VPWR sky130_fd_sc_hd__fill_1
Xclkload1 clknet_4_1_0_clk VGND VGND VPWR VPWR clkload1/Y sky130_fd_sc_hd__clkinvlp_2
XFILLER_0_46_483 VGND VGND VPWR VPWR sky130_fd_sc_hd__fill_1
XTAP_TAPCELL_ROW_57_662 VGND VPWR sky130_fd_sc_hd__tapvpwrvgnd_1
XFILLER_0_24_100 VGND VGND VPWR VPWR sky130_fd_sc_hd__decap_8
XTAP_TAPCELL_ROW_12_275 VGND VPWR sky130_fd_sc_hd__tapvpwrvgnd_1
XFILLER_0_24_133 VGND VGND VPWR VPWR sky130_fd_sc_hd__decap_6
XFILLER_0_12_328 VPWR VGND VPWR VGND sky130_ef_sc_hd__decap_12
XFILLER_0_52_475 VGND VGND VPWR VPWR sky130_fd_sc_hd__fill_1
X_3450_ u_interface.u_compute_core.relu_data\[2\] _0596_ VGND VGND VPWR VPWR _0685_
+ sky130_fd_sc_hd__and2b_1
X_3381_ _0574_ _0576_ _0573_ VGND VGND VPWR VPWR _0618_ sky130_fd_sc_hd__a21o_1
X_2401_ u_interface.u_compute_core.scaled_data\[18\] _1849_ _1875_ _1816_ VGND VGND
+ VPWR VPWR _1876_ sky130_fd_sc_hd__o2bb2a_1
X_2332_ _1820_ _1823_ VGND VGND VPWR VPWR _0001_ sky130_fd_sc_hd__nor2_1
X_4002_ u_interface.core_attn_out\[17\] _0713_ VGND VGND VPWR VPWR _1226_ sky130_fd_sc_hd__or2_1
XFILLER_0_46_97 VGND VGND VPWR VPWR sky130_fd_sc_hd__decap_8
XFILLER_0_1_55 VGND VGND VPWR VPWR sky130_fd_sc_hd__fill_1
XFILLER_0_1_77 VGND VGND VPWR VPWR sky130_fd_sc_hd__decap_3
XFILLER_0_62_41 VGND VGND VPWR VPWR sky130_fd_sc_hd__decap_8
XFILLER_0_62_85 VPWR VGND VPWR VGND sky130_ef_sc_hd__decap_12
XFILLER_0_28_450 VGND VGND VPWR VPWR sky130_fd_sc_hd__fill_2
XFILLER_0_15_111 VGND VGND VPWR VPWR sky130_fd_sc_hd__fill_1
XFILLER_0_28_483 VGND VGND VPWR VPWR sky130_fd_sc_hd__fill_1
X_4766_ clknet_4_9_0_clk _0131_ VGND VGND VPWR VPWR u_interface.core_attn_out\[14\]
+ sky130_fd_sc_hd__dfxtp_1
X_3717_ _0626_ _1856_ _0905_ _0904_ VGND VGND VPWR VPWR _0946_ sky130_fd_sc_hd__a31o_1
XFILLER_0_15_166 VGND VGND VPWR VPWR sky130_fd_sc_hd__fill_2
X_4697_ clknet_4_1_0_clk _0062_ VGND VGND VPWR VPWR u_interface.u_compute_core.mac_accum\[3\]
+ sky130_fd_sc_hd__dfxtp_1
X_3648_ _0834_ _0838_ VGND VGND VPWR VPWR _0879_ sky130_fd_sc_hd__or2_1
X_3579_ _0445_ _1838_ _1835_ _0449_ VGND VGND VPWR VPWR _0811_ sky130_fd_sc_hd__a22oi_1
XFILLER_0_11_361 VGND VGND VPWR VPWR sky130_fd_sc_hd__decap_8
Xhold46 u_interface.u_compute_core.u_mac.product_reg\[10\] VGND VGND VPWR VPWR net110
+ sky130_fd_sc_hd__dlygate4sd3_1
Xhold35 u_interface.u_compute_core.mac_accum\[1\] VGND VGND VPWR VPWR net99 sky130_fd_sc_hd__dlygate4sd3_1
Xhold79 u_interface.core_attn_out\[1\] VGND VGND VPWR VPWR net143 sky130_fd_sc_hd__dlygate4sd3_1
Xhold68 u_interface.u_compute_core.mac_accum\[10\] VGND VGND VPWR VPWR net132 sky130_fd_sc_hd__dlygate4sd3_1
Xhold57 u_interface.u_compute_core.mac_accum\[18\] VGND VGND VPWR VPWR net121 sky130_fd_sc_hd__dlygate4sd3_1
XTAP_TAPCELL_ROW_54_632 VGND VPWR sky130_fd_sc_hd__tapvpwrvgnd_1
XFILLER_0_19_461 VGND VGND VPWR VPWR sky130_fd_sc_hd__fill_2
XFILLER_0_19_472 VGND VGND VPWR VPWR sky130_fd_sc_hd__decap_8
XFILLER_0_21_169 VGND VGND VPWR VPWR sky130_fd_sc_hd__decap_6
XFILLER_0_76_309 VPWR VGND VPWR VGND sky130_ef_sc_hd__decap_12
XTAP_TAPCELL_ROW_17_323 VGND VPWR sky130_fd_sc_hd__tapvpwrvgnd_1
X_2950_ _0202_ _0208_ VGND VGND VPWR VPWR _0209_ sky130_fd_sc_hd__and2_1
XFILLER_0_29_225 VGND VGND VPWR VPWR sky130_fd_sc_hd__fill_1
XFILLER_0_29_236 VGND VGND VPWR VPWR sky130_fd_sc_hd__fill_1
X_2881_ net13 net6 _2275_ net10 VGND VGND VPWR VPWR _2276_ sky130_fd_sc_hd__o2bb2a_1
X_4620_ net48 u_interface.core_attn_out\[27\] _1782_ VGND VGND VPWR VPWR _1801_ sky130_fd_sc_hd__mux2_1
X_4551_ net56 u_interface.core_attn_out\[5\] _1742_ VGND VGND VPWR VPWR _1754_ sky130_fd_sc_hd__mux2_1
XFILLER_0_52_250 VGND VGND VPWR VPWR sky130_fd_sc_hd__fill_2
X_4482_ _1656_ _1690_ VGND VGND VPWR VPWR _1695_ sky130_fd_sc_hd__or2_4
XFILLER_0_12_114 VGND VGND VPWR VPWR sky130_fd_sc_hd__decap_3
X_3502_ _0727_ _0735_ VGND VGND VPWR VPWR _0736_ sky130_fd_sc_hd__xnor2_2
X_3433_ _0627_ _0630_ VGND VGND VPWR VPWR _0668_ sky130_fd_sc_hd__nand2_1
X_3364_ _1824_ _0468_ _1827_ _0600_ VGND VGND VPWR VPWR _0601_ sky130_fd_sc_hd__a211o_1
XFILLER_0_57_30 VPWR VGND VPWR VGND sky130_ef_sc_hd__decap_12
X_3295_ _0531_ _0532_ _0505_ VGND VGND VPWR VPWR _0534_ sky130_fd_sc_hd__a21o_1
XFILLER_0_79_125 VPWR VGND VPWR VGND sky130_ef_sc_hd__decap_12
XTAP_TAPCELL_ROW_68_757 VGND VPWR sky130_fd_sc_hd__tapvpwrvgnd_1
XFILLER_0_73_51 VGND VGND VPWR VPWR sky130_fd_sc_hd__decap_4
XFILLER_0_18_3 VGND VGND VPWR VPWR sky130_fd_sc_hd__decap_6
XFILLER_0_79_169 VGND VGND VPWR VPWR sky130_fd_sc_hd__decap_3
XFILLER_0_75_331 VGND VGND VPWR VPWR sky130_fd_sc_hd__decap_4
XTAP_TAPCELL_ROW_51_613 VGND VPWR sky130_fd_sc_hd__tapvpwrvgnd_1
X_4749_ clknet_4_2_0_clk _0114_ VGND VGND VPWR VPWR u_interface.u_compute_core.u_av.v_extended\[5\]
+ sky130_fd_sc_hd__dfxtp_2
XFILLER_0_31_478 VGND VGND VPWR VPWR sky130_fd_sc_hd__fill_2
Xoutput47 net47 VGND VGND VPWR VPWR m_tdata[26] sky130_fd_sc_hd__clkbuf_4
XFILLER_0_3_391 VGND VGND VPWR VPWR sky130_fd_sc_hd__fill_1
Xoutput58 net58 VGND VGND VPWR VPWR m_tdata[7] sky130_fd_sc_hd__buf_2
Xoutput36 net36 VGND VGND VPWR VPWR m_tdata[16] sky130_fd_sc_hd__buf_2
XFILLER_0_58_309 VPWR VGND VPWR VGND sky130_ef_sc_hd__decap_12
XFILLER_0_78_29 VPWR VGND VPWR VGND sky130_ef_sc_hd__decap_12
XFILLER_0_1_317 VPWR VGND VPWR VGND sky130_ef_sc_hd__decap_12
X_3080_ _2226_ _2275_ VGND VGND VPWR VPWR _0335_ sky130_fd_sc_hd__or2_1
XTAP_TAPCELL_ROW_65_727 VGND VPWR sky130_fd_sc_hd__tapvpwrvgnd_1
XFILLER_0_76_139 VGND VGND VPWR VPWR sky130_fd_sc_hd__fill_1
X_3982_ _1148_ _1156_ _1147_ VGND VGND VPWR VPWR _1206_ sky130_fd_sc_hd__a21oi_1
XTAP_TAPCELL_ROW_73_793 VGND VPWR sky130_fd_sc_hd__tapvpwrvgnd_1
X_2933_ net4 net17 VGND VGND VPWR VPWR _0192_ sky130_fd_sc_hd__nand2_1
XFILLER_0_43_76 VPWR VGND VPWR VGND sky130_ef_sc_hd__decap_12
XFILLER_0_57_353 VGND VGND VPWR VPWR sky130_fd_sc_hd__fill_1
XFILLER_0_72_345 VPWR VGND VPWR VGND sky130_ef_sc_hd__decap_12
X_2864_ _2225_ _2259_ VGND VGND VPWR VPWR _2260_ sky130_fd_sc_hd__xnor2_1
X_2795_ net15 VGND VGND VPWR VPWR _2193_ sky130_fd_sc_hd__buf_2
XFILLER_0_4_133 VGND VGND VPWR VPWR sky130_fd_sc_hd__decap_6
XFILLER_0_25_250 VGND VGND VPWR VPWR sky130_fd_sc_hd__decap_8
X_4603_ _1775_ _1789_ VGND VGND VPWR VPWR _1790_ sky130_fd_sc_hd__and2_1
XFILLER_0_25_294 VGND VGND VPWR VPWR sky130_fd_sc_hd__fill_2
X_4534_ net1 net140 VGND VGND VPWR VPWR _1743_ sky130_fd_sc_hd__and2b_1
XFILLER_0_4_177 VPWR VGND VPWR VGND sky130_ef_sc_hd__decap_12
XFILLER_0_40_253 VGND VGND VPWR VPWR sky130_fd_sc_hd__decap_4
X_4465_ _1677_ _1678_ VGND VGND VPWR VPWR _1679_ sky130_fd_sc_hd__xnor2_1
X_3416_ _0632_ _0651_ VGND VGND VPWR VPWR _0652_ sky130_fd_sc_hd__xnor2_1
XFILLER_0_0_361 VGND VGND VPWR VPWR sky130_fd_sc_hd__decap_3
X_4396_ u_interface.core_attn_out\[25\] _1610_ VGND VGND VPWR VPWR _1612_ sky130_fd_sc_hd__nand2_1
X_3347_ _0552_ _0554_ VGND VGND VPWR VPWR _0584_ sky130_fd_sc_hd__nand2_1
X_3278_ _0486_ _0515_ _0516_ VGND VGND VPWR VPWR _0517_ sky130_fd_sc_hd__nand3b_1
XTAP_TAPCELL_ROW_28_418 VGND VPWR sky130_fd_sc_hd__tapvpwrvgnd_1
XTAP_TAPCELL_ROW_36_484 VGND VPWR sky130_fd_sc_hd__tapvpwrvgnd_1
XFILLER_0_8_472 VGND VGND VPWR VPWR sky130_fd_sc_hd__decap_4
XFILLER_0_63_323 VGND VGND VPWR VPWR sky130_fd_sc_hd__fill_2
XFILLER_0_8_483 VGND VGND VPWR VPWR sky130_fd_sc_hd__fill_1
XFILLER_0_63_389 VGND VGND VPWR VPWR sky130_fd_sc_hd__decap_3
XFILLER_0_7_3 VPWR VGND VPWR VGND sky130_ef_sc_hd__decap_12
XFILLER_0_58_117 VGND VGND VPWR VPWR sky130_fd_sc_hd__fill_2
XFILLER_0_13_57 VGND VGND VPWR VPWR sky130_fd_sc_hd__fill_1
XFILLER_0_39_375 VGND VGND VPWR VPWR sky130_fd_sc_hd__decap_6
XTAP_TAPCELL_ROW_70_774 VGND VPWR sky130_fd_sc_hd__tapvpwrvgnd_1
XFILLER_0_54_345 VGND VGND VPWR VPWR sky130_fd_sc_hd__decap_3
XFILLER_0_81_153 VPWR VGND VPWR VGND sky130_ef_sc_hd__decap_12
XFILLER_0_81_197 VPWR VGND VPWR VGND sky130_ef_sc_hd__decap_12
XFILLER_0_1_125 VPWR VGND VPWR VGND sky130_ef_sc_hd__decap_12
XFILLER_0_22_242 VGND VGND VPWR VPWR sky130_fd_sc_hd__decap_8
XFILLER_0_22_253 VGND VGND VPWR VPWR sky130_fd_sc_hd__decap_8
X_2580_ u_interface.u_compute_core.u_mac.product_reg\[5\] u_interface.u_compute_core.mac_accum\[5\]
+ _1995_ _1996_ _2007_ VGND VGND VPWR VPWR _2008_ sky130_fd_sc_hd__a221o_1
XFILLER_0_1_169 VPWR VGND VPWR VGND sky130_ef_sc_hd__decap_12
X_4250_ u_interface.core_attn_out\[20\] _1362_ _1419_ _1418_ VGND VGND VPWR VPWR _1469_
+ sky130_fd_sc_hd__a31o_1
X_3201_ u_interface.u_compute_core.u_av.v_extended\[5\] VGND VGND VPWR VPWR _0445_
+ sky130_fd_sc_hd__buf_2
X_4181_ _1399_ _1400_ VGND VGND VPWR VPWR _1401_ sky130_fd_sc_hd__nor2_1
X_3132_ _0348_ _0385_ VGND VGND VPWR VPWR _0386_ sky130_fd_sc_hd__xor2_1
XTAP_TAPCELL_ROW_78_841 VGND VPWR sky130_fd_sc_hd__tapvpwrvgnd_1
X_3063_ _0314_ _0318_ VGND VGND VPWR VPWR _0319_ sky130_fd_sc_hd__and2_1
XFILLER_0_9_225 VGND VGND VPWR VPWR sky130_fd_sc_hd__decap_8
XTAP_TAPCELL_ROW_33_454 VGND VPWR sky130_fd_sc_hd__tapvpwrvgnd_1
X_3965_ _1187_ _1188_ VGND VGND VPWR VPWR _1189_ sky130_fd_sc_hd__nor2_1
XFILLER_0_70_41 VPWR VGND VPWR VGND sky130_ef_sc_hd__decap_12
X_2916_ _2308_ _2310_ VGND VGND VPWR VPWR _2311_ sky130_fd_sc_hd__xor2_1
X_3896_ u_interface.core_attn_out\[15\] _1120_ _1121_ VGND VGND VPWR VPWR _1122_ sky130_fd_sc_hd__and3_1
XFILLER_0_70_85 VGND VGND VPWR VPWR sky130_fd_sc_hd__fill_1
X_2847_ net11 net8 VGND VGND VPWR VPWR _2243_ sky130_fd_sc_hd__and2_1
XFILLER_0_72_197 VPWR VGND VPWR VGND sky130_ef_sc_hd__decap_12
X_2778_ _2161_ _2162_ _2166_ _2171_ VGND VGND VPWR VPWR _2177_ sky130_fd_sc_hd__and4_1
X_4517_ _1719_ u_interface.core_attn_out\[29\] VGND VGND VPWR VPWR _1728_ sky130_fd_sc_hd__and2b_1
XFILLER_0_13_253 VGND VGND VPWR VPWR sky130_fd_sc_hd__fill_1
X_4448_ _1633_ _1635_ _1637_ VGND VGND VPWR VPWR _1662_ sky130_fd_sc_hd__o21ai_1
XFILLER_0_13_297 VGND VGND VPWR VPWR sky130_fd_sc_hd__decap_4
X_4379_ _0432_ _1893_ _1541_ _1540_ VGND VGND VPWR VPWR _1595_ sky130_fd_sc_hd__a31o_1
XFILLER_0_68_415 VGND VGND VPWR VPWR sky130_fd_sc_hd__decap_4
XFILLER_0_68_426 VGND VGND VPWR VPWR sky130_fd_sc_hd__decap_8
XFILLER_0_48_150 VGND VGND VPWR VPWR sky130_fd_sc_hd__fill_2
XFILLER_0_55_109 VGND VGND VPWR VPWR sky130_fd_sc_hd__decap_3
XFILLER_0_48_194 VGND VGND VPWR VPWR sky130_fd_sc_hd__fill_2
XFILLER_0_63_164 VGND VGND VPWR VPWR sky130_fd_sc_hd__decap_4
XFILLER_0_51_337 VPWR VGND VPWR VGND sky130_ef_sc_hd__decap_12
XFILLER_0_63_175 VGND VGND VPWR VPWR sky130_fd_sc_hd__fill_1
XTAP_TAPCELL_ROW_75_811 VGND VPWR sky130_fd_sc_hd__tapvpwrvgnd_1
XTAP_TAPCELL_ROW_47_579 VGND VPWR sky130_fd_sc_hd__tapvpwrvgnd_1
X_3750_ u_interface.core_attn_out\[12\] _0977_ VGND VGND VPWR VPWR _0979_ sky130_fd_sc_hd__or2_1
XTAP_TAPCELL_ROW_30_435 VGND VPWR sky130_fd_sc_hd__tapvpwrvgnd_1
XFILLER_0_40_22 VGND VGND VPWR VPWR sky130_fd_sc_hd__fill_1
XFILLER_0_54_131 VGND VGND VPWR VPWR sky130_fd_sc_hd__decap_8
X_2701_ _2066_ u_interface.u_compute_core.mac_accum\[23\] VGND VGND VPWR VPWR _2112_
+ sky130_fd_sc_hd__xor2_1
X_3681_ _0909_ _0910_ VGND VGND VPWR VPWR _0911_ sky130_fd_sc_hd__xnor2_2
XFILLER_0_40_55 VPWR VGND VPWR VGND sky130_ef_sc_hd__decap_12
XFILLER_0_42_315 VGND VGND VPWR VPWR sky130_fd_sc_hd__fill_1
XFILLER_0_54_197 VGND VGND VPWR VPWR sky130_fd_sc_hd__decap_4
XFILLER_0_2_401 VPWR VGND VPWR VGND sky130_ef_sc_hd__decap_12
XFILLER_0_42_359 VGND VGND VPWR VPWR sky130_fd_sc_hd__decap_4
X_2632_ u_interface.u_compute_core.u_mac.product_reg\[13\] u_interface.u_compute_core.mac_accum\[13\]
+ VGND VGND VPWR VPWR _2053_ sky130_fd_sc_hd__or2_1
XFILLER_0_2_445 VPWR VGND VPWR VGND sky130_ef_sc_hd__decap_12
X_2563_ _1973_ _1991_ _1993_ _1980_ net104 VGND VGND VPWR VPWR _0062_ sky130_fd_sc_hd__a32o_1
X_4302_ _1467_ VGND VGND VPWR VPWR _1520_ sky130_fd_sc_hd__inv_2
XFILLER_0_10_278 VGND VGND VPWR VPWR sky130_fd_sc_hd__fill_2
X_2494_ _1931_ _1940_ VGND VGND VPWR VPWR _1941_ sky130_fd_sc_hd__and2_1
X_4233_ _1392_ _1393_ VGND VGND VPWR VPWR _1452_ sky130_fd_sc_hd__or2_1
X_4164_ _0439_ _1197_ _1326_ VGND VGND VPWR VPWR _1384_ sky130_fd_sc_hd__and3_1
X_3115_ _2256_ _2275_ _0367_ VGND VGND VPWR VPWR _0369_ sky130_fd_sc_hd__or3_1
XFILLER_0_4_77 VGND VGND VPWR VPWR sky130_fd_sc_hd__decap_6
XTAP_TAPCELL_ROW_38_502 VGND VPWR sky130_fd_sc_hd__tapvpwrvgnd_1
X_4095_ _1314_ _1315_ u_interface.core_attn_out\[19\] VGND VGND VPWR VPWR _1317_ sky130_fd_sc_hd__a21o_1
X_3046_ _0298_ _0299_ _0300_ VGND VGND VPWR VPWR _0302_ sky130_fd_sc_hd__nor3_1
XFILLER_0_77_256 VPWR VGND VPWR VGND sky130_ef_sc_hd__decap_12
XTAP_TAPCELL_ROW_81_869 VGND VPWR sky130_fd_sc_hd__tapvpwrvgnd_1
X_3948_ _1074_ _1035_ _1123_ _1171_ _1172_ VGND VGND VPWR VPWR _1173_ sky130_fd_sc_hd__o311a_1
X_3879_ _1103_ _1104_ VGND VGND VPWR VPWR _1105_ sky130_fd_sc_hd__nor2b_1
XFILLER_0_5_272 VGND VGND VPWR VPWR sky130_fd_sc_hd__decap_8
XFILLER_0_41_370 VGND VGND VPWR VPWR sky130_fd_sc_hd__fill_1
XTAP_TAPCELL_ROW_1_182 VGND VPWR sky130_fd_sc_hd__tapvpwrvgnd_1
XFILLER_0_68_234 VPWR VGND VPWR VGND sky130_ef_sc_hd__decap_12
XTAP_TAPCELL_ROW_44_549 VGND VPWR sky130_fd_sc_hd__tapvpwrvgnd_1
XFILLER_0_49_470 VPWR VGND VPWR VGND sky130_ef_sc_hd__decap_12
XFILLER_0_36_131 VGND VGND VPWR VPWR sky130_fd_sc_hd__fill_1
XFILLER_0_24_315 VGND VGND VPWR VPWR sky130_fd_sc_hd__decap_8
XFILLER_0_36_197 VPWR VGND VPWR VGND sky130_ef_sc_hd__decap_12
XFILLER_0_10_69 VGND VGND VPWR VPWR sky130_fd_sc_hd__decap_8
XFILLER_0_59_223 VGND VGND VPWR VPWR sky130_fd_sc_hd__fill_1
XFILLER_0_74_204 VGND VGND VPWR VPWR sky130_fd_sc_hd__decap_8
X_3802_ _1028_ _1029_ VGND VGND VPWR VPWR _1030_ sky130_fd_sc_hd__nor2_1
X_4782_ clknet_4_15_0_clk _0147_ VGND VGND VPWR VPWR u_interface.core_attn_out\[30\]
+ sky130_fd_sc_hd__dfxtp_1
X_3733_ _0468_ u_interface.u_compute_core.relu_data\[11\] _0909_ VGND VGND VPWR VPWR
+ _0962_ sky130_fd_sc_hd__and3_1
XFILLER_0_51_98 VGND VGND VPWR VPWR sky130_fd_sc_hd__decap_6
XFILLER_0_70_432 VGND VGND VPWR VPWR sky130_fd_sc_hd__decap_6
X_3664_ _0480_ _0893_ _0894_ _0667_ VGND VGND VPWR VPWR _0127_ sky130_fd_sc_hd__o211a_1
X_2615_ _2032_ _2038_ VGND VGND VPWR VPWR _2039_ sky130_fd_sc_hd__nand2_1
XFILLER_0_2_253 VPWR VGND VPWR VGND sky130_ef_sc_hd__decap_12
X_3595_ _0783_ _0785_ VGND VGND VPWR VPWR _0827_ sky130_fd_sc_hd__or2_1
XFILLER_0_23_381 VGND VGND VPWR VPWR sky130_fd_sc_hd__fill_1
X_2546_ net2 _1969_ VGND VGND VPWR VPWR _1979_ sky130_fd_sc_hd__nor2_1
X_2477_ u_interface.u_compute_core.scaled_data\[12\] u_interface.u_compute_core.mac_accum\[15\]
+ _1922_ VGND VGND VPWR VPWR _1929_ sky130_fd_sc_hd__mux2_1
XFILLER_0_48_3 VPWR VGND VPWR VGND sky130_ef_sc_hd__decap_12
X_4216_ _0431_ _1887_ VGND VGND VPWR VPWR _1435_ sky130_fd_sc_hd__nand2_1
X_4147_ _1173_ _1175_ _1367_ VGND VGND VPWR VPWR _1368_ sky130_fd_sc_hd__a21bo_1
X_4078_ _1296_ _1298_ _1295_ VGND VGND VPWR VPWR _1300_ sky130_fd_sc_hd__a21oi_1
X_3029_ _0284_ _0285_ VGND VGND VPWR VPWR _0286_ sky130_fd_sc_hd__nand2_1
XFILLER_0_18_153 VGND VGND VPWR VPWR sky130_fd_sc_hd__decap_3
Xclkload2 clknet_4_2_0_clk VGND VGND VPWR VPWR clkload2/Y sky130_fd_sc_hd__bufinv_16
XFILLER_0_61_421 VGND VGND VPWR VPWR sky130_fd_sc_hd__decap_8
XFILLER_0_61_454 VPWR VGND VPWR VGND sky130_ef_sc_hd__decap_12
XFILLER_0_33_167 VGND VGND VPWR VPWR sky130_fd_sc_hd__fill_1
XTAP_TAPCELL_ROW_6_230 VGND VPWR sky130_fd_sc_hd__tapvpwrvgnd_1
XTAP_TAPCELL_ROW_57_663 VGND VPWR sky130_fd_sc_hd__tapvpwrvgnd_1
XFILLER_0_21_46 VGND VGND VPWR VPWR sky130_fd_sc_hd__decap_8
XTAP_TAPCELL_ROW_12_276 VGND VPWR sky130_fd_sc_hd__tapvpwrvgnd_1
XFILLER_0_21_57 VGND VGND VPWR VPWR sky130_fd_sc_hd__decap_3
XFILLER_0_52_432 VGND VGND VPWR VPWR sky130_fd_sc_hd__fill_1
XFILLER_0_64_281 VPWR VGND VPWR VGND sky130_ef_sc_hd__decap_12
X_2400_ _1874_ VGND VGND VPWR VPWR _1875_ sky130_fd_sc_hd__inv_2
X_3380_ _0615_ _0616_ VGND VGND VPWR VPWR _0617_ sky130_fd_sc_hd__or2b_1
XFILLER_0_20_351 VGND VGND VPWR VPWR sky130_fd_sc_hd__fill_1
X_2331_ u_interface.u_compute_core.scaled_data\[1\] _1815_ _1822_ _1817_ VGND VGND
+ VPWR VPWR _1823_ sky130_fd_sc_hd__o2bb2a_1
X_4001_ _1223_ _1224_ VGND VGND VPWR VPWR _1225_ sky130_fd_sc_hd__xnor2_1
XFILLER_0_62_97 VPWR VGND VPWR VGND sky130_ef_sc_hd__decap_12
X_4765_ clknet_4_9_0_clk _0130_ VGND VGND VPWR VPWR u_interface.core_attn_out\[13\]
+ sky130_fd_sc_hd__dfxtp_1
XFILLER_0_55_270 VGND VGND VPWR VPWR sky130_fd_sc_hd__fill_1
X_3716_ _0850_ _0901_ _0944_ VGND VGND VPWR VPWR _0945_ sky130_fd_sc_hd__a21oi_1
XFILLER_0_15_156 VGND VGND VPWR VPWR sky130_fd_sc_hd__decap_3
XFILLER_0_43_476 VGND VGND VPWR VPWR sky130_fd_sc_hd__decap_4
X_4696_ clknet_4_1_0_clk _0061_ VGND VGND VPWR VPWR u_interface.u_compute_core.mac_accum\[2\]
+ sky130_fd_sc_hd__dfxtp_1
XFILLER_0_70_295 VPWR VGND VPWR VGND sky130_ef_sc_hd__decap_12
X_3647_ _0875_ _0877_ VGND VGND VPWR VPWR _0878_ sky130_fd_sc_hd__xor2_1
XFILLER_0_30_126 VGND VGND VPWR VPWR sky130_fd_sc_hd__fill_1
X_3578_ _0551_ _0634_ _1838_ _1835_ VGND VGND VPWR VPWR _0810_ sky130_fd_sc_hd__and4_1
X_2529_ _1953_ _1964_ VGND VGND VPWR VPWR _1965_ sky130_fd_sc_hd__and2_1
XTAP_TAPCELL_ROW_3_200 VGND VPWR sky130_fd_sc_hd__tapvpwrvgnd_1
Xhold36 u_interface.u_compute_core.u_mac.product_reg\[4\] VGND VGND VPWR VPWR net100
+ sky130_fd_sc_hd__dlygate4sd3_1
Xhold47 u_interface.u_compute_core.mac_accum\[31\] VGND VGND VPWR VPWR net111 sky130_fd_sc_hd__dlygate4sd3_1
Xhold69 u_interface.core_attn_out\[18\] VGND VGND VPWR VPWR net133 sky130_fd_sc_hd__dlygate4sd3_1
Xhold58 u_interface.core_attn_out\[21\] VGND VGND VPWR VPWR net122 sky130_fd_sc_hd__dlygate4sd3_1
XTAP_TAPCELL_ROW_54_633 VGND VPWR sky130_fd_sc_hd__tapvpwrvgnd_1
XFILLER_0_34_421 VGND VGND VPWR VPWR sky130_fd_sc_hd__fill_1
XFILLER_0_21_159 VGND VGND VPWR VPWR sky130_fd_sc_hd__decap_4
XFILLER_0_16_24 VGND VGND VPWR VPWR sky130_fd_sc_hd__decap_4
XTAP_TAPCELL_ROW_17_324 VGND VPWR sky130_fd_sc_hd__tapvpwrvgnd_1
XFILLER_0_32_12 VPWR VGND VPWR VGND sky130_ef_sc_hd__decap_12
XFILLER_0_69_373 VGND VGND VPWR VPWR sky130_fd_sc_hd__decap_8
X_2880_ net9 VGND VGND VPWR VPWR _2275_ sky130_fd_sc_hd__inv_2
XFILLER_0_32_34 VGND VGND VPWR VPWR sky130_fd_sc_hd__decap_6
XTAP_TAPCELL_ROW_25_390 VGND VPWR sky130_fd_sc_hd__tapvpwrvgnd_1
XFILLER_0_25_421 VGND VGND VPWR VPWR sky130_fd_sc_hd__decap_4
XFILLER_0_37_281 VPWR VGND VPWR VGND sky130_ef_sc_hd__decap_12
XFILLER_0_25_465 VGND VGND VPWR VPWR sky130_fd_sc_hd__decap_8
X_4550_ _1812_ VGND VGND VPWR VPWR _1753_ sky130_fd_sc_hd__clkbuf_2
X_4481_ _0715_ _1693_ _1694_ _1879_ VGND VGND VPWR VPWR _0144_ sky130_fd_sc_hd__a211oi_1
X_3501_ _0732_ _0734_ VGND VGND VPWR VPWR _0735_ sky130_fd_sc_hd__xor2_2
X_3432_ _0480_ _0665_ _0666_ _0667_ VGND VGND VPWR VPWR _0122_ sky130_fd_sc_hd__o211a_1
X_3363_ u_interface.u_compute_core.u_av.v_extended\[4\] VGND VGND VPWR VPWR _0600_
+ sky130_fd_sc_hd__inv_2
XFILLER_0_57_42 VPWR VGND VPWR VGND sky130_ef_sc_hd__decap_12
X_3294_ _0505_ _0531_ _0532_ VGND VGND VPWR VPWR _0533_ sky130_fd_sc_hd__nand3_1
XTAP_TAPCELL_ROW_68_758 VGND VPWR sky130_fd_sc_hd__tapvpwrvgnd_1
XPHY_EDGE_ROW_69_Left_151 VGND VGND VPWR VPWR sky130_fd_sc_hd__decap_3
XFILLER_0_79_137 VPWR VGND VPWR VGND sky130_ef_sc_hd__decap_12
XFILLER_0_7_131 VPWR VGND VPWR VGND sky130_ef_sc_hd__decap_12
XFILLER_0_35_207 VGND VGND VPWR VPWR sky130_fd_sc_hd__decap_8
XFILLER_0_35_218 VGND VGND VPWR VPWR sky130_fd_sc_hd__fill_1
XFILLER_0_16_421 VGND VGND VPWR VPWR sky130_fd_sc_hd__decap_8
XPHY_EDGE_ROW_78_Left_160 VGND VGND VPWR VPWR sky130_fd_sc_hd__decap_3
XFILLER_0_16_454 VGND VGND VPWR VPWR sky130_fd_sc_hd__fill_1
X_4748_ clknet_4_2_0_clk _0113_ VGND VGND VPWR VPWR u_interface.u_compute_core.u_av.v_extended\[4\]
+ sky130_fd_sc_hd__dfxtp_1
XFILLER_0_31_413 VPWR VGND VPWR VGND sky130_ef_sc_hd__decap_12
X_4679_ clknet_4_6_0_clk _0044_ VGND VGND VPWR VPWR u_interface.u_compute_core.scaled_data\[15\]
+ sky130_fd_sc_hd__dfxtp_1
XPHY_EDGE_ROW_1_Right_1 VGND VGND VPWR VPWR sky130_fd_sc_hd__decap_3
XFILLER_0_31_457 VGND VGND VPWR VPWR sky130_fd_sc_hd__decap_6
Xoutput48 net48 VGND VGND VPWR VPWR m_tdata[27] sky130_fd_sc_hd__clkbuf_4
Xoutput37 net37 VGND VGND VPWR VPWR m_tdata[17] sky130_fd_sc_hd__buf_2
XFILLER_0_11_181 VPWR VGND VPWR VGND sky130_ef_sc_hd__decap_12
Xoutput59 net59 VGND VGND VPWR VPWR m_tdata[8] sky130_fd_sc_hd__buf_2
XFILLER_0_66_321 VPWR VGND VPWR VGND sky130_ef_sc_hd__decap_12
XFILLER_0_66_365 VGND VGND VPWR VPWR sky130_fd_sc_hd__fill_1
XFILLER_0_19_270 VGND VGND VPWR VPWR sky130_fd_sc_hd__decap_8
XFILLER_0_19_281 VPWR VGND VPWR VGND sky130_ef_sc_hd__decap_12
XTAP_TAPCELL_ROW_22_360 VGND VPWR sky130_fd_sc_hd__tapvpwrvgnd_1
XFILLER_0_22_413 VGND VGND VPWR VPWR sky130_fd_sc_hd__decap_6
XFILLER_0_1_329 VGND VGND VPWR VPWR sky130_fd_sc_hd__decap_6
XFILLER_0_27_67 VGND VGND VPWR VPWR sky130_fd_sc_hd__decap_6
XTAP_TAPCELL_ROW_65_728 VGND VPWR sky130_fd_sc_hd__tapvpwrvgnd_1
X_3981_ _1195_ _1204_ VGND VGND VPWR VPWR _1205_ sky130_fd_sc_hd__xor2_1
XTAP_TAPCELL_ROW_73_794 VGND VPWR sky130_fd_sc_hd__tapvpwrvgnd_1
X_2932_ _0189_ _0190_ VGND VGND VPWR VPWR _0191_ sky130_fd_sc_hd__xnor2_1
XFILLER_0_43_88 VGND VGND VPWR VPWR sky130_fd_sc_hd__fill_1
XFILLER_0_17_218 VGND VGND VPWR VPWR sky130_fd_sc_hd__decap_6
X_2863_ _2254_ _2258_ VGND VGND VPWR VPWR _2259_ sky130_fd_sc_hd__xnor2_1
XFILLER_0_72_357 VGND VGND VPWR VPWR sky130_fd_sc_hd__decap_6
X_2794_ _2032_ _2191_ _2192_ _2100_ net98 VGND VGND VPWR VPWR _0094_ sky130_fd_sc_hd__a32o_1
X_4602_ net42 u_interface.core_attn_out\[21\] _1782_ VGND VGND VPWR VPWR _1789_ sky130_fd_sc_hd__mux2_1
XFILLER_0_13_435 VPWR VGND VPWR VGND sky130_ef_sc_hd__decap_12
XFILLER_0_13_413 VPWR VGND VPWR VGND sky130_ef_sc_hd__decap_12
X_4533_ u_interface.core_valid_out VGND VGND VPWR VPWR _1742_ sky130_fd_sc_hd__clkbuf_4
XFILLER_0_7_33 VGND VGND VPWR VPWR sky130_fd_sc_hd__decap_4
XFILLER_0_4_189 VGND VGND VPWR VPWR sky130_fd_sc_hd__decap_6
XFILLER_0_40_221 VGND VGND VPWR VPWR sky130_fd_sc_hd__decap_8
X_4464_ _1630_ _1631_ _1629_ VGND VGND VPWR VPWR _1678_ sky130_fd_sc_hd__o21ba_1
XFILLER_0_7_55 VGND VGND VPWR VPWR sky130_fd_sc_hd__fill_1
XFILLER_0_68_41 VGND VGND VPWR VPWR sky130_fd_sc_hd__fill_1
X_4395_ u_interface.core_attn_out\[25\] _1610_ VGND VGND VPWR VPWR _1611_ sky130_fd_sc_hd__or2_1
X_3415_ _0648_ _0650_ VGND VGND VPWR VPWR _0651_ sky130_fd_sc_hd__xnor2_2
X_3346_ _0513_ _0546_ _0548_ VGND VGND VPWR VPWR _0583_ sky130_fd_sc_hd__a21oi_1
X_3277_ _0441_ _0484_ u_interface.u_compute_core.relu_data\[2\] u_interface.u_compute_core.relu_data\[1\]
+ VGND VGND VPWR VPWR _0516_ sky130_fd_sc_hd__nand4_2
XFILLER_0_30_3 VPWR VGND VPWR VGND sky130_ef_sc_hd__decap_12
XTAP_TAPCELL_ROW_36_485 VGND VPWR sky130_fd_sc_hd__tapvpwrvgnd_1
XFILLER_0_48_321 VPWR VGND VPWR VGND sky130_ef_sc_hd__decap_12
XFILLER_0_48_343 VPWR VGND VPWR VGND sky130_ef_sc_hd__decap_12
XFILLER_0_75_195 VPWR VGND VPWR VGND sky130_ef_sc_hd__decap_12
XFILLER_0_63_335 VGND VGND VPWR VPWR sky130_fd_sc_hd__fill_1
XFILLER_0_31_243 VGND VGND VPWR VPWR sky130_fd_sc_hd__decap_8
XFILLER_0_31_287 VGND VGND VPWR VPWR sky130_fd_sc_hd__fill_1
XFILLER_0_13_25 VPWR VGND VPWR VGND sky130_ef_sc_hd__decap_12
XFILLER_0_66_151 VGND VGND VPWR VPWR sky130_fd_sc_hd__decap_6
XTAP_TAPCELL_ROW_70_775 VGND VPWR sky130_fd_sc_hd__tapvpwrvgnd_1
XFILLER_0_81_165 VGND VGND VPWR VPWR sky130_fd_sc_hd__decap_3
XFILLER_0_10_416 VGND VGND VPWR VPWR sky130_fd_sc_hd__decap_4
XFILLER_0_1_137 VPWR VGND VPWR VGND sky130_ef_sc_hd__decap_12
X_3200_ _1968_ net21 _0434_ _0444_ VGND VGND VPWR VPWR _0113_ sky130_fd_sc_hd__o211a_1
X_4180_ _1396_ _1398_ _1395_ VGND VGND VPWR VPWR _1400_ sky130_fd_sc_hd__a21oi_1
X_3131_ _0383_ _0384_ VGND VGND VPWR VPWR _0385_ sky130_fd_sc_hd__nand2_1
XTAP_TAPCELL_ROW_78_842 VGND VPWR sky130_fd_sc_hd__tapvpwrvgnd_1
X_3062_ _0316_ _0317_ VGND VGND VPWR VPWR _0318_ sky130_fd_sc_hd__nor2_1
XFILLER_0_77_405 VGND VGND VPWR VPWR sky130_fd_sc_hd__decap_6
XFILLER_0_49_107 VGND VGND VPWR VPWR sky130_fd_sc_hd__decap_4
XFILLER_0_54_76 VGND VGND VPWR VPWR sky130_fd_sc_hd__fill_2
X_3964_ _0449_ _0445_ u_interface.u_compute_core.relu_data\[15\] u_interface.u_compute_core.relu_data\[14\]
+ VGND VGND VPWR VPWR _1188_ sky130_fd_sc_hd__and4_1
XFILLER_0_70_53 VGND VGND VPWR VPWR sky130_fd_sc_hd__decap_4
XFILLER_0_72_110 VPWR VGND VPWR VGND sky130_ef_sc_hd__decap_12
X_2915_ _2225_ _2259_ _2309_ VGND VGND VPWR VPWR _2310_ sky130_fd_sc_hd__a21bo_1
XTAP_TAPCELL_ROW_33_455 VGND VPWR sky130_fd_sc_hd__tapvpwrvgnd_1
X_3895_ _1119_ _1080_ _1082_ VGND VGND VPWR VPWR _1121_ sky130_fd_sc_hd__nand3_1
XFILLER_0_57_173 VGND VGND VPWR VPWR sky130_fd_sc_hd__fill_1
X_2846_ _2237_ _2236_ VGND VGND VPWR VPWR _2242_ sky130_fd_sc_hd__or2b_1
XFILLER_0_79_51 VGND VGND VPWR VPWR sky130_fd_sc_hd__decap_4
XFILLER_0_78_3 VPWR VGND VPWR VGND sky130_ef_sc_hd__decap_12
X_2777_ _2032_ _2174_ _2176_ _2100_ net107 VGND VGND VPWR VPWR _0093_ sky130_fd_sc_hd__a32o_1
X_4516_ _0938_ _1726_ _1727_ _0420_ VGND VGND VPWR VPWR _0146_ sky130_fd_sc_hd__o211a_1
X_4447_ _1648_ VGND VGND VPWR VPWR _1661_ sky130_fd_sc_hd__inv_2
XFILLER_0_0_181 VGND VGND VPWR VPWR sky130_fd_sc_hd__decap_4
X_4378_ _1591_ _1593_ VGND VGND VPWR VPWR _1594_ sky130_fd_sc_hd__xnor2_1
X_3329_ _0565_ _0566_ VGND VGND VPWR VPWR _0567_ sky130_fd_sc_hd__xor2_1
XFILLER_0_36_313 VGND VGND VPWR VPWR sky130_fd_sc_hd__fill_1
XTAP_TAPCELL_ROW_75_812 VGND VPWR sky130_fd_sc_hd__tapvpwrvgnd_1
XFILLER_0_59_449 VGND VGND VPWR VPWR sky130_fd_sc_hd__fill_2
XFILLER_0_74_419 VGND VGND VPWR VPWR sky130_fd_sc_hd__fill_1
XFILLER_0_39_140 VGND VGND VPWR VPWR sky130_fd_sc_hd__fill_1
X_2700_ _2004_ _2110_ _2111_ VGND VGND VPWR VPWR _0081_ sky130_fd_sc_hd__o21a_1
X_3680_ net83 u_interface.u_compute_core.relu_data\[11\] VGND VGND VPWR VPWR _0910_
+ sky130_fd_sc_hd__nand2_1
XFILLER_0_40_67 VGND VGND VPWR VPWR sky130_fd_sc_hd__fill_1
XFILLER_0_2_413 VGND VGND VPWR VPWR sky130_fd_sc_hd__decap_6
X_2631_ u_interface.u_compute_core.u_mac.product_reg\[13\] u_interface.u_compute_core.mac_accum\[13\]
+ VGND VGND VPWR VPWR _2052_ sky130_fd_sc_hd__nand2_1
XFILLER_0_2_457 VPWR VGND VPWR VGND sky130_ef_sc_hd__decap_12
X_2562_ _1992_ VGND VGND VPWR VPWR _1993_ sky130_fd_sc_hd__inv_2
XFILLER_0_10_224 VPWR VGND VPWR VGND sky130_ef_sc_hd__decap_12
X_4301_ _1517_ _1518_ VGND VGND VPWR VPWR _1519_ sky130_fd_sc_hd__and2b_1
XFILLER_0_49_76 VGND VGND VPWR VPWR sky130_fd_sc_hd__fill_1
X_2493_ u_interface.u_compute_core.scaled_data\[17\] u_interface.u_compute_core.mac_accum\[20\]
+ _1922_ VGND VGND VPWR VPWR _1940_ sky130_fd_sc_hd__mux2_1
X_4232_ _1442_ _1450_ VGND VGND VPWR VPWR _1451_ sky130_fd_sc_hd__xor2_1
X_4163_ _1381_ _1382_ VGND VGND VPWR VPWR _1383_ sky130_fd_sc_hd__xnor2_1
X_3114_ _2256_ _2275_ _0367_ VGND VGND VPWR VPWR _0368_ sky130_fd_sc_hd__o21ai_1
XTAP_TAPCELL_ROW_38_503 VGND VPWR sky130_fd_sc_hd__tapvpwrvgnd_1
X_4094_ u_interface.core_attn_out\[19\] _1314_ _1315_ VGND VGND VPWR VPWR _1316_ sky130_fd_sc_hd__nand3_1
X_3045_ _0298_ _0299_ _0300_ VGND VGND VPWR VPWR _0301_ sky130_fd_sc_hd__o21a_1
XFILLER_0_77_202 VGND VGND VPWR VPWR sky130_fd_sc_hd__fill_1
XFILLER_0_81_41 VPWR VGND VPWR VGND sky130_ef_sc_hd__decap_12
XFILLER_0_81_85 VPWR VGND VPWR VGND sky130_ef_sc_hd__decap_12
XFILLER_0_77_268 VPWR VGND VPWR VGND sky130_ef_sc_hd__decap_12
XFILLER_0_18_324 VGND VGND VPWR VPWR sky130_fd_sc_hd__fill_2
X_3947_ u_interface.core_attn_out\[15\] _1120_ _1121_ VGND VGND VPWR VPWR _1172_ sky130_fd_sc_hd__nand3_1
XFILLER_0_33_316 VGND VGND VPWR VPWR sky130_fd_sc_hd__decap_6
X_3878_ _1100_ _1102_ VGND VGND VPWR VPWR _1104_ sky130_fd_sc_hd__nand2_1
X_2829_ net16 VGND VGND VPWR VPWR _2226_ sky130_fd_sc_hd__buf_2
XFILLER_0_41_393 VPWR VGND VPWR VGND sky130_ef_sc_hd__decap_12
XTAP_TAPCELL_ROW_1_183 VGND VPWR sky130_fd_sc_hd__tapvpwrvgnd_1
XFILLER_0_68_257 VGND VGND VPWR VPWR sky130_fd_sc_hd__fill_1
XFILLER_0_49_482 VGND VGND VPWR VPWR sky130_fd_sc_hd__fill_2
XFILLER_0_64_430 VGND VGND VPWR VPWR sky130_fd_sc_hd__decap_4
XFILLER_0_24_305 VGND VGND VPWR VPWR sky130_fd_sc_hd__decap_3
XFILLER_0_51_113 VGND VGND VPWR VPWR sky130_fd_sc_hd__decap_8
XPHY_EDGE_ROW_23_Left_105 VGND VGND VPWR VPWR sky130_fd_sc_hd__decap_3
XTAP_TAPCELL_ROW_9_250 VGND VPWR sky130_fd_sc_hd__tapvpwrvgnd_1
XPHY_EDGE_ROW_32_Left_114 VGND VGND VPWR VPWR sky130_fd_sc_hd__decap_3
XFILLER_0_35_34 VGND VGND VPWR VPWR sky130_fd_sc_hd__decap_3
XFILLER_0_59_235 VPWR VGND VPWR VGND sky130_ef_sc_hd__decap_12
XFILLER_0_59_279 VGND VGND VPWR VPWR sky130_fd_sc_hd__fill_1
X_3801_ u_interface.core_attn_out\[13\] _1026_ VGND VGND VPWR VPWR _1029_ sky130_fd_sc_hd__nor2_1
XFILLER_0_51_22 VGND VGND VPWR VPWR sky130_fd_sc_hd__decap_8
X_4781_ clknet_4_13_0_clk _0146_ VGND VGND VPWR VPWR u_interface.core_attn_out\[29\]
+ sky130_fd_sc_hd__dfxtp_1
XFILLER_0_70_400 VGND VGND VPWR VPWR sky130_fd_sc_hd__fill_1
X_3732_ _0957_ _0960_ VGND VGND VPWR VPWR _0961_ sky130_fd_sc_hd__xnor2_1
XFILLER_0_70_444 VPWR VGND VPWR VGND sky130_ef_sc_hd__decap_12
X_3663_ u_interface.core_attn_out\[10\] _0713_ VGND VGND VPWR VPWR _0894_ sky130_fd_sc_hd__or2_1
XPHY_EDGE_ROW_41_Left_123 VGND VGND VPWR VPWR sky130_fd_sc_hd__decap_3
XFILLER_0_70_477 VGND VGND VPWR VPWR sky130_fd_sc_hd__decap_6
XFILLER_0_2_221 VPWR VGND VPWR VGND sky130_ef_sc_hd__decap_12
XFILLER_0_23_360 VGND VGND VPWR VPWR sky130_fd_sc_hd__decap_4
XFILLER_0_42_157 VGND VGND VPWR VPWR sky130_fd_sc_hd__fill_2
X_2614_ _2035_ _2037_ VGND VGND VPWR VPWR _2038_ sky130_fd_sc_hd__xor2_1
XFILLER_0_2_265 VPWR VGND VPWR VGND sky130_ef_sc_hd__decap_12
X_3594_ _0808_ _0825_ VGND VGND VPWR VPWR _0826_ sky130_fd_sc_hd__xor2_2
X_2545_ u_interface.u_compute_core.u_mac.product_reg\[0\] u_interface.u_compute_core.mac_accum\[0\]
+ _1974_ _1975_ VGND VGND VPWR VPWR _1978_ sky130_fd_sc_hd__a22o_1
XFILLER_0_76_41 VPWR VGND VPWR VGND sky130_ef_sc_hd__decap_12
X_2476_ _1928_ VGND VGND VPWR VPWR _0040_ sky130_fd_sc_hd__clkbuf_1
XFILLER_0_76_85 VPWR VGND VPWR VGND sky130_ef_sc_hd__decap_12
X_4215_ _0450_ _0446_ _1197_ _1151_ VGND VGND VPWR VPWR _1434_ sky130_fd_sc_hd__and4_1
X_4146_ _1170_ _1223_ _1364_ VGND VGND VPWR VPWR _1367_ sky130_fd_sc_hd__and3_1
XPHY_EDGE_ROW_50_Left_132 VGND VGND VPWR VPWR sky130_fd_sc_hd__decap_3
X_4077_ _1295_ _1296_ _1298_ VGND VGND VPWR VPWR _1299_ sky130_fd_sc_hd__and3_1
X_3028_ _0278_ _0279_ _0283_ VGND VGND VPWR VPWR _0285_ sky130_fd_sc_hd__a21o_1
Xclkload3 clknet_4_3_0_clk VGND VGND VPWR VPWR clkload3/Y sky130_fd_sc_hd__bufinv_16
XFILLER_0_33_113 VPWR VGND VPWR VGND sky130_ef_sc_hd__decap_12
XFILLER_0_61_466 VPWR VGND VPWR VGND sky130_ef_sc_hd__decap_12
XFILLER_0_14_382 VPWR VGND VPWR VGND sky130_ef_sc_hd__decap_12
XTAP_TAPCELL_ROW_6_231 VGND VPWR sky130_fd_sc_hd__tapvpwrvgnd_1
XTAP_TAPCELL_ROW_57_664 VGND VPWR sky130_fd_sc_hd__tapvpwrvgnd_1
XFILLER_0_56_205 VGND VGND VPWR VPWR sky130_fd_sc_hd__fill_2
XFILLER_0_56_238 VPWR VGND VPWR VGND sky130_ef_sc_hd__decap_12
XFILLER_0_37_430 VGND VGND VPWR VPWR sky130_fd_sc_hd__fill_1
XTAP_TAPCELL_ROW_40_520 VGND VPWR sky130_fd_sc_hd__tapvpwrvgnd_1
XFILLER_0_21_25 VPWR VGND VPWR VGND sky130_ef_sc_hd__decap_12
XTAP_TAPCELL_ROW_12_277 VGND VPWR sky130_fd_sc_hd__tapvpwrvgnd_1
XFILLER_0_64_293 VPWR VGND VPWR VGND sky130_ef_sc_hd__decap_12
XFILLER_0_52_477 VGND VGND VPWR VPWR sky130_fd_sc_hd__decap_3
XFILLER_0_20_363 VGND VGND VPWR VPWR sky130_fd_sc_hd__fill_1
X_2330_ _1821_ VGND VGND VPWR VPWR _1822_ sky130_fd_sc_hd__inv_2
XFILLER_0_20_396 VGND VGND VPWR VPWR sky130_fd_sc_hd__fill_1
X_4000_ _1170_ _1176_ _1168_ VGND VGND VPWR VPWR _1224_ sky130_fd_sc_hd__a21oi_1
XFILLER_0_1_57 VPWR VGND VPWR VGND sky130_ef_sc_hd__decap_12
XFILLER_0_62_76 VGND VGND VPWR VPWR sky130_fd_sc_hd__decap_8
X_4764_ clknet_4_9_0_clk _0129_ VGND VGND VPWR VPWR u_interface.core_attn_out\[12\]
+ sky130_fd_sc_hd__dfxtp_1
XFILLER_0_43_400 VPWR VGND VPWR VGND sky130_ef_sc_hd__decap_12
XFILLER_0_15_113 VPWR VGND VPWR VGND sky130_ef_sc_hd__decap_12
XFILLER_0_7_368 VGND VGND VPWR VPWR sky130_fd_sc_hd__fill_1
X_3715_ _0900_ _0897_ VGND VGND VPWR VPWR _0944_ sky130_fd_sc_hd__and2b_1
X_4695_ clknet_4_1_0_clk _0060_ VGND VGND VPWR VPWR u_interface.u_compute_core.mac_accum\[1\]
+ sky130_fd_sc_hd__dfxtp_1
X_3646_ _0802_ _0829_ _0876_ VGND VGND VPWR VPWR _0877_ sky130_fd_sc_hd__a21oi_1
XFILLER_0_30_149 VGND VGND VPWR VPWR sky130_fd_sc_hd__fill_2
X_3577_ _0430_ _1850_ VGND VGND VPWR VPWR _0809_ sky130_fd_sc_hd__nand2_1
XFILLER_0_60_3 VPWR VGND VPWR VGND sky130_ef_sc_hd__decap_12
X_2528_ u_interface.u_compute_core.scaled_data\[28\] u_interface.u_compute_core.mac_accum\[31\]
+ _1944_ VGND VGND VPWR VPWR _1964_ sky130_fd_sc_hd__mux2_1
XTAP_TAPCELL_ROW_3_201 VGND VPWR sky130_fd_sc_hd__tapvpwrvgnd_1
X_2459_ _1909_ _1916_ VGND VGND VPWR VPWR _1917_ sky130_fd_sc_hd__and2_1
Xhold37 u_interface.u_compute_core.u_mac.product_reg\[12\] VGND VGND VPWR VPWR net101
+ sky130_fd_sc_hd__dlygate4sd3_1
Xhold48 u_interface.u_compute_core.mac_accum\[8\] VGND VGND VPWR VPWR net112 sky130_fd_sc_hd__dlygate4sd3_1
Xhold59 u_interface.u_compute_core.mac_accum\[25\] VGND VGND VPWR VPWR net123 sky130_fd_sc_hd__dlygate4sd3_1
X_4129_ _1297_ _1349_ VGND VGND VPWR VPWR _1350_ sky130_fd_sc_hd__xnor2_1
XFILLER_0_78_363 VGND VGND VPWR VPWR sky130_fd_sc_hd__fill_1
XTAP_TAPCELL_ROW_54_634 VGND VPWR sky130_fd_sc_hd__tapvpwrvgnd_1
XFILLER_0_38_227 VPWR VGND VPWR VGND sky130_ef_sc_hd__decap_12
XFILLER_0_34_400 VPWR VGND VPWR VGND sky130_ef_sc_hd__decap_12
XPHY_EDGE_ROW_7_Left_89 VGND VGND VPWR VPWR sky130_fd_sc_hd__decap_3
XFILLER_0_34_433 VGND VGND VPWR VPWR sky130_fd_sc_hd__decap_6
XFILLER_0_34_444 VPWR VGND VPWR VGND sky130_ef_sc_hd__decap_12
XFILLER_0_46_293 VPWR VGND VPWR VGND sky130_ef_sc_hd__decap_12
XFILLER_0_34_477 VGND VGND VPWR VPWR sky130_fd_sc_hd__decap_3
XFILLER_0_32_24 VGND VGND VPWR VPWR sky130_fd_sc_hd__fill_1
XTAP_TAPCELL_ROW_25_391 VGND VPWR sky130_fd_sc_hd__tapvpwrvgnd_1
X_3500_ _0687_ _1832_ _0689_ _0733_ VGND VGND VPWR VPWR _0734_ sky130_fd_sc_hd__a31o_1
X_4480_ net141 _0421_ VGND VGND VPWR VPWR _1694_ sky130_fd_sc_hd__nor2_1
XFILLER_0_12_138 VGND VGND VPWR VPWR sky130_fd_sc_hd__fill_2
X_3431_ _1812_ VGND VGND VPWR VPWR _0667_ sky130_fd_sc_hd__buf_2
X_3362_ _0597_ _0598_ VGND VGND VPWR VPWR _0599_ sky130_fd_sc_hd__xor2_1
XFILLER_0_20_160 VPWR VGND VPWR VGND sky130_ef_sc_hd__decap_12
X_3293_ _0528_ _0529_ _0530_ VGND VGND VPWR VPWR _0532_ sky130_fd_sc_hd__a21o_1
XFILLER_0_57_54 VGND VGND VPWR VPWR sky130_fd_sc_hd__fill_2
XFILLER_0_79_105 VGND VGND VPWR VPWR sky130_fd_sc_hd__decap_6
XFILLER_0_79_149 VPWR VGND VPWR VGND sky130_ef_sc_hd__decap_12
X_4816_ clknet_4_13_0_clk _0181_ VGND VGND VPWR VPWR net53 sky130_fd_sc_hd__dfxtp_1
XFILLER_0_16_400 VGND VGND VPWR VPWR sky130_fd_sc_hd__decap_8
XFILLER_0_7_143 VPWR VGND VPWR VGND sky130_ef_sc_hd__decap_12
X_4747_ clknet_4_2_0_clk _0112_ VGND VGND VPWR VPWR u_interface.u_compute_core.u_av.v_extended\[3\]
+ sky130_fd_sc_hd__dfxtp_2
XFILLER_0_31_425 VGND VGND VPWR VPWR sky130_fd_sc_hd__decap_4
X_4678_ clknet_4_4_0_clk _0043_ VGND VGND VPWR VPWR u_interface.u_compute_core.scaled_data\[14\]
+ sky130_fd_sc_hd__dfxtp_1
XFILLER_0_31_447 VGND VGND VPWR VPWR sky130_fd_sc_hd__fill_1
X_3629_ u_interface.u_compute_core.relu_data\[6\] _0596_ VGND VGND VPWR VPWR _0860_
+ sky130_fd_sc_hd__and2b_1
Xoutput49 net49 VGND VGND VPWR VPWR m_tdata[28] sky130_fd_sc_hd__clkbuf_4
XFILLER_0_3_393 VPWR VGND VPWR VGND sky130_ef_sc_hd__decap_12
Xoutput38 net38 VGND VGND VPWR VPWR m_tdata[18] sky130_fd_sc_hd__buf_2
XFILLER_0_11_193 VGND VGND VPWR VPWR sky130_fd_sc_hd__decap_8
XFILLER_0_66_333 VGND VGND VPWR VPWR sky130_fd_sc_hd__decap_3
XFILLER_0_19_293 VGND VGND VPWR VPWR sky130_fd_sc_hd__decap_6
XTAP_TAPCELL_ROW_22_361 VGND VPWR sky130_fd_sc_hd__tapvpwrvgnd_1
XFILLER_0_34_274 VPWR VGND VPWR VGND sky130_ef_sc_hd__decap_12
XFILLER_0_22_458 VGND VGND VPWR VPWR sky130_fd_sc_hd__fill_1
XTAP_TAPCELL_ROW_65_729 VGND VPWR sky130_fd_sc_hd__tapvpwrvgnd_1
X_3980_ _1153_ _1203_ VGND VGND VPWR VPWR _1204_ sky130_fd_sc_hd__xnor2_1
XTAP_TAPCELL_ROW_73_795 VGND VPWR sky130_fd_sc_hd__tapvpwrvgnd_1
X_2931_ _2243_ _2282_ _2281_ VGND VGND VPWR VPWR _0190_ sky130_fd_sc_hd__o21a_1
Xclkbuf_0_clk clk VGND VGND VPWR VPWR clknet_0_clk sky130_fd_sc_hd__clkbuf_16
X_2862_ _2255_ _2257_ VGND VGND VPWR VPWR _2258_ sky130_fd_sc_hd__or2_1
X_4601_ _1788_ VGND VGND VPWR VPWR _0170_ sky130_fd_sc_hd__clkbuf_1
X_2793_ _2188_ _2189_ _2177_ _2175_ VGND VGND VPWR VPWR _2192_ sky130_fd_sc_hd__a211o_1
XFILLER_0_80_380 VPWR VGND VPWR VGND sky130_ef_sc_hd__decap_12
X_4532_ _1967_ _1739_ _1740_ _1741_ _1813_ VGND VGND VPWR VPWR _0148_ sky130_fd_sc_hd__o311a_1
XFILLER_0_13_425 VGND VGND VPWR VPWR sky130_fd_sc_hd__decap_6
XFILLER_0_40_200 VPWR VGND VPWR VGND sky130_ef_sc_hd__decap_12
X_4463_ _1675_ _1676_ VGND VGND VPWR VPWR _1677_ sky130_fd_sc_hd__xor2_1
XFILLER_0_13_447 VGND VGND VPWR VPWR sky130_fd_sc_hd__fill_1
X_3414_ _0557_ _0599_ _0649_ VGND VGND VPWR VPWR _0650_ sky130_fd_sc_hd__o21a_1
XPHY_EDGE_ROW_15_Right_15 VGND VGND VPWR VPWR sky130_fd_sc_hd__decap_3
X_4394_ _1576_ _1609_ VGND VGND VPWR VPWR _1610_ sky130_fd_sc_hd__xnor2_1
X_3345_ _0543_ _0567_ VGND VGND VPWR VPWR _0582_ sky130_fd_sc_hd__and2_1
X_3276_ _0437_ u_interface.u_compute_core.relu_data\[2\] _1821_ _0441_ VGND VGND VPWR
+ VPWR _0515_ sky130_fd_sc_hd__a22o_1
XFILLER_0_23_3 VGND VGND VPWR VPWR sky130_fd_sc_hd__decap_8
XFILLER_0_17_90 VGND VGND VPWR VPWR sky130_fd_sc_hd__fill_2
XPHY_EDGE_ROW_24_Right_24 VGND VGND VPWR VPWR sky130_fd_sc_hd__decap_3
XTAP_TAPCELL_ROW_36_486 VGND VPWR sky130_fd_sc_hd__tapvpwrvgnd_1
XFILLER_0_48_333 VGND VGND VPWR VPWR sky130_fd_sc_hd__decap_6
XFILLER_0_48_355 VGND VGND VPWR VPWR sky130_fd_sc_hd__decap_8
XFILLER_0_16_296 VPWR VGND VPWR VGND sky130_ef_sc_hd__decap_12
XFILLER_0_31_222 VGND VGND VPWR VPWR sky130_fd_sc_hd__fill_2
XPHY_EDGE_ROW_33_Right_33 VGND VGND VPWR VPWR sky130_fd_sc_hd__decap_3
XPHY_EDGE_ROW_42_Right_42 VGND VGND VPWR VPWR sky130_fd_sc_hd__decap_3
XFILLER_0_13_37 VGND VGND VPWR VPWR sky130_fd_sc_hd__decap_8
XFILLER_0_66_141 VGND VGND VPWR VPWR sky130_fd_sc_hd__fill_1
XFILLER_0_54_314 VGND VGND VPWR VPWR sky130_fd_sc_hd__fill_2
XPHY_EDGE_ROW_51_Right_51 VGND VGND VPWR VPWR sky130_fd_sc_hd__decap_3
XFILLER_0_1_149 VPWR VGND VPWR VGND sky130_ef_sc_hd__decap_12
X_3130_ _0381_ _0382_ VGND VGND VPWR VPWR _0384_ sky130_fd_sc_hd__nand2_1
XFILLER_0_38_78 VGND VGND VPWR VPWR sky130_fd_sc_hd__decap_6
XTAP_TAPCELL_ROW_78_843 VGND VPWR sky130_fd_sc_hd__tapvpwrvgnd_1
X_3061_ _0205_ _0315_ VGND VGND VPWR VPWR _0317_ sky130_fd_sc_hd__and2_1
XPHY_EDGE_ROW_60_Right_60 VGND VGND VPWR VPWR sky130_fd_sc_hd__decap_3
X_3963_ _0511_ _1865_ _1862_ _0680_ VGND VGND VPWR VPWR _1187_ sky130_fd_sc_hd__a22oi_1
XFILLER_0_57_163 VGND VGND VPWR VPWR sky130_fd_sc_hd__decap_4
XFILLER_0_72_122 VGND VGND VPWR VPWR sky130_fd_sc_hd__fill_1
X_2914_ _2258_ _2254_ VGND VGND VPWR VPWR _2309_ sky130_fd_sc_hd__or2b_1
XTAP_TAPCELL_ROW_33_456 VGND VPWR sky130_fd_sc_hd__tapvpwrvgnd_1
X_3894_ _1080_ _1082_ _1119_ VGND VGND VPWR VPWR _1120_ sky130_fd_sc_hd__a21o_1
XFILLER_0_5_411 VGND VGND VPWR VPWR sky130_fd_sc_hd__fill_1
X_2845_ _2233_ _2234_ _2212_ VGND VGND VPWR VPWR _2241_ sky130_fd_sc_hd__or3b_1
XFILLER_0_5_455 VGND VGND VPWR VPWR sky130_fd_sc_hd__fill_1
XFILLER_0_60_306 VGND VGND VPWR VPWR sky130_fd_sc_hd__fill_2
XFILLER_0_60_339 VGND VGND VPWR VPWR sky130_fd_sc_hd__decap_8
X_4515_ u_interface.core_attn_out\[29\] _1966_ VGND VGND VPWR VPWR _1727_ sky130_fd_sc_hd__or2_1
X_2776_ _2175_ VGND VGND VPWR VPWR _2176_ sky130_fd_sc_hd__inv_2
XFILLER_0_53_391 VGND VGND VPWR VPWR sky130_fd_sc_hd__fill_1
X_4446_ net136 _0715_ _1813_ _1660_ VGND VGND VPWR VPWR _0143_ sky130_fd_sc_hd__o211a_1
X_4377_ _1538_ _1543_ _1592_ VGND VGND VPWR VPWR _1593_ sky130_fd_sc_hd__a21oi_2
X_3328_ _0521_ _0523_ VGND VGND VPWR VPWR _0566_ sky130_fd_sc_hd__nand2_1
X_3259_ _0498_ _0482_ VGND VGND VPWR VPWR _0499_ sky130_fd_sc_hd__xnor2_1
XFILLER_0_68_406 VGND VGND VPWR VPWR sky130_fd_sc_hd__fill_1
XFILLER_0_36_303 VGND VGND VPWR VPWR sky130_fd_sc_hd__decap_4
XFILLER_0_76_483 VGND VGND VPWR VPWR sky130_fd_sc_hd__fill_1
XFILLER_0_63_100 VGND VGND VPWR VPWR sky130_fd_sc_hd__decap_4
XTAP_TAPCELL_ROW_75_813 VGND VPWR sky130_fd_sc_hd__tapvpwrvgnd_1
X_2630_ net115 _2026_ _2049_ _2051_ VGND VGND VPWR VPWR _0071_ sky130_fd_sc_hd__a22o_1
X_2561_ _1988_ _1989_ _1990_ VGND VGND VPWR VPWR _1992_ sky130_fd_sc_hd__and3_1
XFILLER_0_2_469 VGND VGND VPWR VPWR sky130_fd_sc_hd__decap_6
XFILLER_0_49_44 VPWR VGND VPWR VGND sky130_ef_sc_hd__decap_12
XFILLER_0_50_372 VGND VGND VPWR VPWR sky130_fd_sc_hd__decap_6
X_2492_ _1939_ VGND VGND VPWR VPWR _0045_ sky130_fd_sc_hd__clkbuf_1
X_4300_ _1515_ _1516_ u_interface.core_attn_out\[23\] VGND VGND VPWR VPWR _1518_ sky130_fd_sc_hd__a21o_1
XFILLER_0_10_258 VPWR VGND VPWR VGND sky130_ef_sc_hd__decap_12
XFILLER_0_10_236 VGND VGND VPWR VPWR sky130_fd_sc_hd__decap_4
X_4231_ _1397_ _1449_ VGND VGND VPWR VPWR _1450_ sky130_fd_sc_hd__xnor2_1
X_4162_ _0443_ _1197_ VGND VGND VPWR VPWR _1382_ sky130_fd_sc_hd__nand2_1
X_3113_ _2220_ _2244_ _0366_ VGND VGND VPWR VPWR _0367_ sky130_fd_sc_hd__a21o_1
X_4093_ _1275_ _1313_ _1276_ VGND VGND VPWR VPWR _1315_ sky130_fd_sc_hd__nand3_1
X_3044_ _2193_ _2275_ VGND VGND VPWR VPWR _0300_ sky130_fd_sc_hd__or2_1
XFILLER_0_81_53 VGND VGND VPWR VPWR sky130_fd_sc_hd__decap_3
XFILLER_0_77_225 VGND VGND VPWR VPWR sky130_fd_sc_hd__decap_3
XTAP_TAPCELL_ROW_46_570 VGND VPWR sky130_fd_sc_hd__tapvpwrvgnd_1
XFILLER_0_81_97 VPWR VGND VPWR VGND sky130_ef_sc_hd__decap_12
X_3946_ _1125_ _1123_ VGND VGND VPWR VPWR _1171_ sky130_fd_sc_hd__or2_1
XFILLER_0_58_483 VGND VGND VPWR VPWR sky130_fd_sc_hd__fill_1
XFILLER_0_45_177 VGND VGND VPWR VPWR sky130_fd_sc_hd__fill_1
X_3877_ _1100_ _1102_ VGND VGND VPWR VPWR _1103_ sky130_fd_sc_hd__nor2_1
X_2828_ net25 _2193_ _2224_ VGND VGND VPWR VPWR _2225_ sky130_fd_sc_hd__and3_1
XFILLER_0_26_391 VGND VGND VPWR VPWR sky130_fd_sc_hd__decap_3
X_2759_ net25 VGND VGND VPWR VPWR _2161_ sky130_fd_sc_hd__buf_2
X_4429_ _1639_ _1642_ VGND VGND VPWR VPWR _1644_ sky130_fd_sc_hd__and2_1
XTAP_TAPCELL_ROW_1_184 VGND VPWR sky130_fd_sc_hd__tapvpwrvgnd_1
XTAP_TAPCELL_ROW_80_860 VGND VPWR sky130_fd_sc_hd__tapvpwrvgnd_1
XFILLER_0_64_442 VGND VGND VPWR VPWR sky130_fd_sc_hd__decap_6
XFILLER_0_36_177 VGND VGND VPWR VPWR sky130_fd_sc_hd__fill_1
XFILLER_0_64_475 VGND VGND VPWR VPWR sky130_fd_sc_hd__fill_1
XFILLER_0_10_16 VGND VGND VPWR VPWR sky130_fd_sc_hd__fill_2
XFILLER_0_51_125 VPWR VGND VPWR VGND sky130_ef_sc_hd__decap_12
XFILLER_0_32_350 VGND VGND VPWR VPWR sky130_fd_sc_hd__decap_3
XFILLER_0_51_169 VGND VGND VPWR VPWR sky130_fd_sc_hd__decap_8
XTAP_TAPCELL_ROW_9_251 VGND VPWR sky130_fd_sc_hd__tapvpwrvgnd_1
XFILLER_0_35_57 VGND VGND VPWR VPWR sky130_fd_sc_hd__decap_8
XFILLER_0_59_247 VPWR VGND VPWR VGND sky130_ef_sc_hd__decap_12
X_4780_ clknet_4_15_0_clk _0145_ VGND VGND VPWR VPWR u_interface.core_attn_out\[28\]
+ sky130_fd_sc_hd__dfxtp_1
X_3800_ _1027_ VGND VGND VPWR VPWR _1028_ sky130_fd_sc_hd__inv_2
XTAP_TAPCELL_ROW_43_540 VGND VPWR sky130_fd_sc_hd__tapvpwrvgnd_1
XFILLER_0_27_133 VGND VGND VPWR VPWR sky130_fd_sc_hd__decap_3
X_3731_ _0958_ _0959_ VGND VGND VPWR VPWR _0960_ sky130_fd_sc_hd__xnor2_1
XFILLER_0_55_431 VPWR VGND VPWR VGND sky130_ef_sc_hd__decap_12
XFILLER_0_27_166 VGND VGND VPWR VPWR sky130_fd_sc_hd__fill_2
X_3662_ _0888_ _0892_ VGND VGND VPWR VPWR _0893_ sky130_fd_sc_hd__xor2_1
Xclkload10 clknet_4_11_0_clk VGND VGND VPWR VPWR clkload10/Y sky130_fd_sc_hd__clkinv_4
XFILLER_0_70_456 VGND VGND VPWR VPWR sky130_fd_sc_hd__fill_2
XFILLER_0_23_350 VGND VGND VPWR VPWR sky130_fd_sc_hd__decap_4
X_3593_ _0822_ _0824_ VGND VGND VPWR VPWR _0825_ sky130_fd_sc_hd__xnor2_2
X_2613_ _2027_ _2036_ _2029_ VGND VGND VPWR VPWR _2037_ sky130_fd_sc_hd__a21oi_1
XFILLER_0_2_233 VPWR VGND VPWR VGND sky130_ef_sc_hd__decap_12
X_2544_ _1976_ VGND VGND VPWR VPWR _1977_ sky130_fd_sc_hd__inv_2
XFILLER_0_2_277 VPWR VGND VPWR VGND sky130_ef_sc_hd__decap_12
X_2475_ _1909_ _1927_ VGND VGND VPWR VPWR _1928_ sky130_fd_sc_hd__and2_1
XFILLER_0_76_53 VPWR VGND VPWR VGND sky130_ef_sc_hd__decap_12
X_4214_ _0446_ _1197_ _1151_ _0450_ VGND VGND VPWR VPWR _1433_ sky130_fd_sc_hd__a22oi_1
XFILLER_0_76_97 VPWR VGND VPWR VGND sky130_ef_sc_hd__decap_12
X_4145_ _1319_ _1317_ _1364_ _1270_ _1365_ VGND VGND VPWR VPWR _1366_ sky130_fd_sc_hd__a221o_1
X_4076_ _1297_ VGND VGND VPWR VPWR _1298_ sky130_fd_sc_hd__inv_2
X_3027_ _0278_ _0279_ _0283_ VGND VGND VPWR VPWR _0284_ sky130_fd_sc_hd__nand3_1
XFILLER_0_65_206 VGND VGND VPWR VPWR sky130_fd_sc_hd__decap_6
XFILLER_0_18_111 VGND VGND VPWR VPWR sky130_fd_sc_hd__decap_8
XFILLER_0_46_453 VGND VGND VPWR VPWR sky130_fd_sc_hd__fill_2
XFILLER_0_73_261 VPWR VGND VPWR VGND sky130_ef_sc_hd__decap_12
XFILLER_0_46_475 VGND VGND VPWR VPWR sky130_fd_sc_hd__fill_1
Xclkload4 clknet_4_4_0_clk VGND VGND VPWR VPWR clkload4/Y sky130_fd_sc_hd__clkinvlp_2
X_3929_ _1152_ _1153_ VGND VGND VPWR VPWR _1154_ sky130_fd_sc_hd__or2_1
XFILLER_0_61_401 VGND VGND VPWR VPWR sky130_fd_sc_hd__fill_1
XFILLER_0_33_125 VGND VGND VPWR VPWR sky130_fd_sc_hd__fill_2
XFILLER_0_61_434 VPWR VGND VPWR VGND sky130_ef_sc_hd__decap_12
XFILLER_0_33_169 VPWR VGND VPWR VGND sky130_ef_sc_hd__decap_12
XFILLER_0_61_478 VGND VGND VPWR VPWR sky130_fd_sc_hd__decap_6
XFILLER_0_14_361 VGND VGND VPWR VPWR sky130_fd_sc_hd__decap_3
XFILLER_0_14_394 VGND VGND VPWR VPWR sky130_fd_sc_hd__decap_6
XFILLER_0_21_37 VGND VGND VPWR VPWR sky130_fd_sc_hd__fill_2
XTAP_TAPCELL_ROW_12_278 VGND VPWR sky130_fd_sc_hd__tapvpwrvgnd_1
XFILLER_0_12_309 VGND VGND VPWR VPWR sky130_fd_sc_hd__fill_1
XFILLER_0_52_456 VGND VGND VPWR VPWR sky130_fd_sc_hd__fill_2
XFILLER_0_52_467 VGND VGND VPWR VPWR sky130_fd_sc_hd__decap_8
XFILLER_0_1_69 VGND VGND VPWR VPWR sky130_fd_sc_hd__decap_8
XFILLER_0_62_55 VGND VGND VPWR VPWR sky130_fd_sc_hd__fill_2
X_4763_ clknet_4_10_0_clk _0128_ VGND VGND VPWR VPWR u_interface.core_attn_out\[11\]
+ sky130_fd_sc_hd__dfxtp_1
XFILLER_0_28_475 VGND VGND VPWR VPWR sky130_fd_sc_hd__fill_1
XFILLER_0_15_125 VPWR VGND VPWR VGND sky130_ef_sc_hd__decap_12
X_3714_ _0923_ _0896_ _0942_ VGND VGND VPWR VPWR _0943_ sky130_fd_sc_hd__a21o_1
X_4694_ clknet_4_1_0_clk _0059_ VGND VGND VPWR VPWR u_interface.u_compute_core.mac_accum\[0\]
+ sky130_fd_sc_hd__dfxtp_1
XFILLER_0_43_412 VPWR VGND VPWR VGND sky130_ef_sc_hd__decap_12
XFILLER_0_70_286 VGND VGND VPWR VPWR sky130_fd_sc_hd__fill_2
X_3645_ _0828_ _0826_ VGND VGND VPWR VPWR _0876_ sky130_fd_sc_hd__and2b_1
X_3576_ _0766_ _0807_ VGND VGND VPWR VPWR _0808_ sky130_fd_sc_hd__xnor2_2
XFILLER_0_30_139 VGND VGND VPWR VPWR sky130_fd_sc_hd__fill_1
X_2527_ _1963_ VGND VGND VPWR VPWR _0056_ sky130_fd_sc_hd__clkbuf_1
X_2458_ u_interface.u_compute_core.scaled_data\[6\] u_interface.u_compute_core.mac_accum\[9\]
+ _1900_ VGND VGND VPWR VPWR _1916_ sky130_fd_sc_hd__mux2_1
XFILLER_0_53_3 VPWR VGND VPWR VGND sky130_ef_sc_hd__decap_12
XTAP_TAPCELL_ROW_3_202 VGND VPWR sky130_fd_sc_hd__tapvpwrvgnd_1
Xhold27 net40 VGND VGND VPWR VPWR net91 sky130_fd_sc_hd__dlygate4sd3_1
Xhold38 u_interface.u_compute_core.u_mac.product_reg\[1\] VGND VGND VPWR VPWR net102
+ sky130_fd_sc_hd__dlygate4sd3_1
X_2389_ u_interface.u_compute_core.scaled_data\[15\] _1849_ _1866_ _1843_ VGND VGND
+ VPWR VPWR _1867_ sky130_fd_sc_hd__o2bb2a_1
Xhold49 u_interface.u_compute_core.mac_accum\[29\] VGND VGND VPWR VPWR net113 sky130_fd_sc_hd__dlygate4sd3_1
X_4128_ _1347_ _1348_ VGND VGND VPWR VPWR _1349_ sky130_fd_sc_hd__nor2_1
X_4059_ _0442_ u_interface.u_compute_core.relu_data\[18\] VGND VGND VPWR VPWR _1281_
+ sky130_fd_sc_hd__nand2_1
XFILLER_0_78_342 VGND VGND VPWR VPWR sky130_fd_sc_hd__fill_1
XTAP_TAPCELL_ROW_54_635 VGND VPWR sky130_fd_sc_hd__tapvpwrvgnd_1
XFILLER_0_78_386 VPWR VGND VPWR VGND sky130_ef_sc_hd__decap_12
XFILLER_0_38_239 VPWR VGND VPWR VGND sky130_ef_sc_hd__decap_12
XFILLER_0_46_250 VGND VGND VPWR VPWR sky130_fd_sc_hd__fill_2
XFILLER_0_34_412 VGND VGND VPWR VPWR sky130_fd_sc_hd__decap_4
XFILLER_0_61_220 VGND VGND VPWR VPWR sky130_fd_sc_hd__decap_4
XFILLER_0_34_456 VPWR VGND VPWR VGND sky130_ef_sc_hd__decap_12
XFILLER_0_61_231 VGND VGND VPWR VPWR sky130_fd_sc_hd__fill_1
XFILLER_0_25_401 VPWR VGND VPWR VGND sky130_ef_sc_hd__decap_12
XTAP_TAPCELL_ROW_25_392 VGND VPWR sky130_fd_sc_hd__tapvpwrvgnd_1
XFILLER_0_37_250 VGND VGND VPWR VPWR sky130_fd_sc_hd__decap_8
XFILLER_0_52_242 VGND VGND VPWR VPWR sky130_fd_sc_hd__decap_8
XFILLER_0_52_253 VGND VGND VPWR VPWR sky130_fd_sc_hd__decap_8
XFILLER_0_40_415 VGND VGND VPWR VPWR sky130_fd_sc_hd__decap_4
X_3430_ u_interface.core_attn_out\[5\] _0435_ VGND VGND VPWR VPWR _0666_ sky130_fd_sc_hd__or2_1
X_3361_ _0436_ u_interface.u_compute_core.relu_data\[4\] VGND VGND VPWR VPWR _0598_
+ sky130_fd_sc_hd__and2_1
XFILLER_0_20_172 VPWR VGND VPWR VGND sky130_ef_sc_hd__decap_12
X_3292_ _0528_ _0529_ _0530_ VGND VGND VPWR VPWR _0531_ sky130_fd_sc_hd__nand3_2
XFILLER_0_75_356 VGND VGND VPWR VPWR sky130_fd_sc_hd__fill_1
X_4815_ clknet_4_15_0_clk _0180_ VGND VGND VPWR VPWR net52 sky130_fd_sc_hd__dfxtp_1
XFILLER_0_7_155 VPWR VGND VPWR VGND sky130_ef_sc_hd__decap_12
X_4746_ clknet_4_8_0_clk _0111_ VGND VGND VPWR VPWR u_interface.u_compute_core.u_av.v_extended\[2\]
+ sky130_fd_sc_hd__dfxtp_1
XFILLER_0_43_231 VGND VGND VPWR VPWR sky130_fd_sc_hd__decap_3
XFILLER_0_43_264 VPWR VGND VPWR VGND sky130_ef_sc_hd__decap_12
X_4677_ clknet_4_4_0_clk _0042_ VGND VGND VPWR VPWR u_interface.u_compute_core.scaled_data\[13\]
+ sky130_fd_sc_hd__dfxtp_1
XFILLER_0_3_361 VPWR VGND VPWR VGND sky130_ef_sc_hd__decap_12
X_3628_ _0639_ _1845_ VGND VGND VPWR VPWR _0859_ sky130_fd_sc_hd__nand2_1
XFILLER_0_43_297 VGND VGND VPWR VPWR sky130_fd_sc_hd__fill_1
Xoutput39 net39 VGND VGND VPWR VPWR m_tdata[19] sky130_fd_sc_hd__buf_2
X_3559_ _0761_ _0791_ VGND VGND VPWR VPWR _0792_ sky130_fd_sc_hd__xor2_1
XFILLER_0_26_209 VGND VGND VPWR VPWR sky130_fd_sc_hd__decap_4
XFILLER_0_81_337 VPWR VGND VPWR VGND sky130_ef_sc_hd__decap_12
XTAP_TAPCELL_ROW_22_362 VGND VPWR sky130_fd_sc_hd__tapvpwrvgnd_1
XFILLER_0_22_404 VGND VGND VPWR VPWR sky130_fd_sc_hd__decap_3
XFILLER_0_34_286 VPWR VGND VPWR VGND sky130_ef_sc_hd__decap_12
XFILLER_0_76_109 VPWR VGND VPWR VGND sky130_ef_sc_hd__decap_12
XFILLER_0_69_161 VGND VGND VPWR VPWR sky130_fd_sc_hd__decap_6
XTAP_TAPCELL_ROW_73_796 VGND VPWR sky130_fd_sc_hd__tapvpwrvgnd_1
X_2930_ _0187_ _0188_ VGND VGND VPWR VPWR _0189_ sky130_fd_sc_hd__nor2_1
XFILLER_0_57_345 VGND VGND VPWR VPWR sky130_fd_sc_hd__decap_8
XFILLER_0_72_337 VGND VGND VPWR VPWR sky130_fd_sc_hd__fill_1
X_2861_ net25 _2256_ _2224_ VGND VGND VPWR VPWR _2257_ sky130_fd_sc_hd__a21oi_1
XFILLER_0_57_389 VGND VGND VPWR VPWR sky130_fd_sc_hd__decap_3
X_4600_ _1775_ _1787_ VGND VGND VPWR VPWR _1788_ sky130_fd_sc_hd__and2_1
X_2792_ _2190_ VGND VGND VPWR VPWR _2191_ sky130_fd_sc_hd__inv_2
X_4531_ u_interface.core_attn_out\[31\] _1966_ VGND VGND VPWR VPWR _1741_ sky130_fd_sc_hd__or2_1
XFILLER_0_25_286 VGND VGND VPWR VPWR sky130_fd_sc_hd__decap_8
XFILLER_0_80_392 VGND VGND VPWR VPWR sky130_fd_sc_hd__decap_8
X_4462_ _1626_ _1632_ _1624_ VGND VGND VPWR VPWR _1676_ sky130_fd_sc_hd__a21oi_1
XFILLER_0_40_212 VGND VGND VPWR VPWR sky130_fd_sc_hd__fill_2
X_3413_ _0602_ _0595_ VGND VGND VPWR VPWR _0649_ sky130_fd_sc_hd__or2b_1
XFILLER_0_40_278 VGND VGND VPWR VPWR sky130_fd_sc_hd__fill_2
X_4393_ _1607_ _1608_ VGND VGND VPWR VPWR _1609_ sky130_fd_sc_hd__nor2_1
X_3344_ _0565_ _0566_ VGND VGND VPWR VPWR _0581_ sky130_fd_sc_hd__and2_1
X_3275_ _0512_ _0513_ VGND VGND VPWR VPWR _0514_ sky130_fd_sc_hd__nor2_1
XFILLER_0_67_109 VGND VGND VPWR VPWR sky130_fd_sc_hd__decap_3
XFILLER_0_63_337 VGND VGND VPWR VPWR sky130_fd_sc_hd__decap_6
X_4729_ clknet_4_0_0_clk _0094_ VGND VGND VPWR VPWR u_interface.u_compute_core.u_mac.product_reg\[3\]
+ sky130_fd_sc_hd__dfxtp_1
XFILLER_0_31_256 VPWR VGND VPWR VGND sky130_ef_sc_hd__decap_12
XPHY_EDGE_ROW_10_Left_92 VGND VGND VPWR VPWR sky130_fd_sc_hd__decap_3
XFILLER_0_39_301 VGND VGND VPWR VPWR sky130_fd_sc_hd__fill_2
XFILLER_0_54_304 VGND VGND VPWR VPWR sky130_fd_sc_hd__decap_4
XFILLER_0_66_175 VGND VGND VPWR VPWR sky130_fd_sc_hd__fill_2
XFILLER_0_66_197 VPWR VGND VPWR VGND sky130_ef_sc_hd__decap_12
XFILLER_0_10_429 VGND VGND VPWR VPWR sky130_fd_sc_hd__fill_2
X_3060_ _0205_ _0315_ VGND VGND VPWR VPWR _0316_ sky130_fd_sc_hd__nor2_1
XFILLER_0_57_120 VGND VGND VPWR VPWR sky130_fd_sc_hd__fill_2
X_3962_ _1183_ _1185_ VGND VGND VPWR VPWR _1186_ sky130_fd_sc_hd__xor2_1
XFILLER_0_57_153 VGND VGND VPWR VPWR sky130_fd_sc_hd__fill_2
X_2913_ _2305_ _2307_ VGND VGND VPWR VPWR _2308_ sky130_fd_sc_hd__xor2_1
XTAP_TAPCELL_ROW_33_457 VGND VPWR sky130_fd_sc_hd__tapvpwrvgnd_1
X_3893_ _1117_ _1118_ VGND VGND VPWR VPWR _1119_ sky130_fd_sc_hd__nand2_1
XFILLER_0_45_337 VPWR VGND VPWR VGND sky130_ef_sc_hd__decap_12
X_2844_ net109 _2026_ _2240_ _1973_ VGND VGND VPWR VPWR _0096_ sky130_fd_sc_hd__a22o_1
X_4514_ _1723_ _1725_ VGND VGND VPWR VPWR _1726_ sky130_fd_sc_hd__xnor2_1
X_2775_ _2162_ _2168_ _2172_ _2173_ VGND VGND VPWR VPWR _2175_ sky130_fd_sc_hd__and4_1
X_4445_ _0421_ _1659_ VGND VGND VPWR VPWR _1660_ sky130_fd_sc_hd__nand2_1
X_4376_ _1537_ _1536_ VGND VGND VPWR VPWR _1592_ sky130_fd_sc_hd__and2b_1
X_3327_ _0550_ _0564_ VGND VGND VPWR VPWR _0565_ sky130_fd_sc_hd__xor2_1
X_3258_ _0496_ _0497_ VGND VGND VPWR VPWR _0498_ sky130_fd_sc_hd__and2_1
X_3189_ u_interface.u_compute_core.relu_valid VGND VGND VPWR VPWR _0435_ sky130_fd_sc_hd__buf_2
XTAP_TAPCELL_ROW_49_590 VGND VPWR sky130_fd_sc_hd__tapvpwrvgnd_1
XFILLER_0_48_186 VGND VGND VPWR VPWR sky130_fd_sc_hd__decap_8
XFILLER_0_63_134 VGND VGND VPWR VPWR sky130_fd_sc_hd__decap_4
XFILLER_0_44_381 VGND VGND VPWR VPWR sky130_fd_sc_hd__fill_2
XFILLER_0_5_3 VPWR VGND VPWR VGND sky130_ef_sc_hd__decap_12
XTAP_TAPCELL_ROW_75_814 VGND VPWR sky130_fd_sc_hd__tapvpwrvgnd_1
XFILLER_0_27_315 VGND VGND VPWR VPWR sky130_fd_sc_hd__fill_1
XFILLER_0_6_209 VPWR VGND VPWR VGND sky130_ef_sc_hd__decap_12
XTAP_TAPCELL_ROW_30_427 VGND VPWR sky130_fd_sc_hd__tapvpwrvgnd_1
XFILLER_0_35_381 VGND VGND VPWR VPWR sky130_fd_sc_hd__decap_8
X_2560_ _1988_ _1989_ _1990_ VGND VGND VPWR VPWR _1991_ sky130_fd_sc_hd__a21o_1
X_2491_ _1931_ _1938_ VGND VGND VPWR VPWR _1939_ sky130_fd_sc_hd__and2_1
XFILLER_0_10_248 VGND VGND VPWR VPWR sky130_fd_sc_hd__decap_4
X_4230_ _1447_ _1448_ VGND VGND VPWR VPWR _1449_ sky130_fd_sc_hd__nor2_1
X_4161_ _1379_ _1380_ VGND VGND VPWR VPWR _1381_ sky130_fd_sc_hd__nor2_1
X_3112_ _2220_ _2244_ _2294_ VGND VGND VPWR VPWR _0366_ sky130_fd_sc_hd__o21ai_1
X_4092_ _1275_ _1276_ _1313_ VGND VGND VPWR VPWR _1314_ sky130_fd_sc_hd__a21o_1
XFILLER_0_65_55 VGND VGND VPWR VPWR sky130_fd_sc_hd__fill_1
X_3043_ _2220_ _2226_ _2244_ _2256_ VGND VGND VPWR VPWR _0299_ sky130_fd_sc_hd__and4_1
XTAP_TAPCELL_ROW_46_571 VGND VPWR sky130_fd_sc_hd__tapvpwrvgnd_1
XFILLER_0_73_410 VPWR VGND VPWR VGND sky130_ef_sc_hd__decap_12
XFILLER_0_14_81 VGND VGND VPWR VPWR sky130_fd_sc_hd__decap_3
X_3945_ _1168_ _1169_ VGND VGND VPWR VPWR _1170_ sky130_fd_sc_hd__nor2_1
XFILLER_0_14_92 VGND VGND VPWR VPWR sky130_fd_sc_hd__fill_2
X_3876_ _1053_ _1058_ _1101_ VGND VGND VPWR VPWR _1102_ sky130_fd_sc_hd__a21boi_1
X_2827_ net26 net16 VGND VGND VPWR VPWR _2224_ sky130_fd_sc_hd__and2_1
XFILLER_0_45_189 VGND VGND VPWR VPWR sky130_fd_sc_hd__decap_4
X_2758_ net111 _2026_ _2159_ _2160_ VGND VGND VPWR VPWR _0090_ sky130_fd_sc_hd__a22o_1
X_4428_ _1639_ _1642_ VGND VGND VPWR VPWR _1643_ sky130_fd_sc_hd__nor2_1
X_2689_ _2068_ u_interface.u_compute_core.mac_accum\[20\] _2098_ VGND VGND VPWR VPWR
+ _2102_ sky130_fd_sc_hd__a21o_1
XFILLER_0_1_481 VGND VGND VPWR VPWR sky130_fd_sc_hd__decap_3
X_4359_ _1511_ _1563_ _1562_ VGND VGND VPWR VPWR _1575_ sky130_fd_sc_hd__a21oi_1
XTAP_TAPCELL_ROW_1_185 VGND VPWR sky130_fd_sc_hd__tapvpwrvgnd_1
XFILLER_0_64_421 VGND VGND VPWR VPWR sky130_fd_sc_hd__fill_1
XFILLER_0_51_104 VGND VGND VPWR VPWR sky130_fd_sc_hd__fill_1
XFILLER_0_24_329 VGND VGND VPWR VPWR sky130_fd_sc_hd__decap_3
XFILLER_0_51_137 VGND VGND VPWR VPWR sky130_fd_sc_hd__fill_2
XTAP_TAPCELL_ROW_9_252 VGND VPWR sky130_fd_sc_hd__tapvpwrvgnd_1
XFILLER_0_59_215 VGND VGND VPWR VPWR sky130_fd_sc_hd__decap_8
XFILLER_0_59_259 VPWR VGND VPWR VGND sky130_ef_sc_hd__decap_12
XFILLER_0_27_101 VGND VGND VPWR VPWR sky130_fd_sc_hd__decap_8
XTAP_TAPCELL_ROW_43_541 VGND VPWR sky130_fd_sc_hd__tapvpwrvgnd_1
X_3730_ _0484_ u_interface.u_compute_core.relu_data\[12\] VGND VGND VPWR VPWR _0959_
+ sky130_fd_sc_hd__nand2_1
XFILLER_0_51_57 VGND VGND VPWR VPWR sky130_fd_sc_hd__fill_2
XFILLER_0_55_443 VGND VGND VPWR VPWR sky130_fd_sc_hd__decap_4
XFILLER_0_67_281 VPWR VGND VPWR VGND sky130_ef_sc_hd__decap_12
X_3661_ _0759_ _0889_ _0891_ VGND VGND VPWR VPWR _0892_ sky130_fd_sc_hd__o21a_1
XFILLER_0_27_189 VGND VGND VPWR VPWR sky130_fd_sc_hd__fill_1
X_3592_ _0774_ _0782_ _0823_ VGND VGND VPWR VPWR _0824_ sky130_fd_sc_hd__a21oi_1
X_2612_ u_interface.u_compute_core.u_mac.product_reg\[9\] u_interface.u_compute_core.mac_accum\[9\]
+ VGND VGND VPWR VPWR _2036_ sky130_fd_sc_hd__nand2_1
Xclkload11 clknet_4_12_0_clk VGND VGND VPWR VPWR clkload11/Y sky130_fd_sc_hd__inv_8
XFILLER_0_2_245 VGND VGND VPWR VPWR sky130_fd_sc_hd__decap_6
XFILLER_0_23_373 VGND VGND VPWR VPWR sky130_fd_sc_hd__decap_8
X_2543_ u_interface.u_compute_core.u_mac.product_reg\[0\] u_interface.u_compute_core.mac_accum\[0\]
+ _1974_ _1975_ VGND VGND VPWR VPWR _1976_ sky130_fd_sc_hd__and4_1
XFILLER_0_2_289 VPWR VGND VPWR VGND sky130_ef_sc_hd__decap_12
X_2474_ u_interface.u_compute_core.scaled_data\[11\] u_interface.u_compute_core.mac_accum\[14\]
+ _1922_ VGND VGND VPWR VPWR _1927_ sky130_fd_sc_hd__mux2_1
XFILLER_0_76_65 VPWR VGND VPWR VGND sky130_ef_sc_hd__decap_12
X_4213_ _1430_ _1431_ VGND VGND VPWR VPWR _1432_ sky130_fd_sc_hd__xnor2_1
X_4144_ _1316_ VGND VGND VPWR VPWR _1365_ sky130_fd_sc_hd__inv_2
X_4075_ _0426_ _0422_ u_interface.u_compute_core.relu_data\[22\] u_interface.u_compute_core.relu_data\[21\]
+ VGND VGND VPWR VPWR _1297_ sky130_fd_sc_hd__and4_1
X_3026_ _0281_ _0282_ VGND VGND VPWR VPWR _0283_ sky130_fd_sc_hd__and2_1
XFILLER_0_25_91 VGND VGND VPWR VPWR sky130_fd_sc_hd__decap_6
XFILLER_0_58_281 VGND VGND VPWR VPWR sky130_fd_sc_hd__decap_8
X_3928_ _0427_ _0423_ _1151_ _1874_ VGND VGND VPWR VPWR _1153_ sky130_fd_sc_hd__and4_1
Xclkload5 clknet_4_5_0_clk VGND VGND VPWR VPWR clkload5/Y sky130_fd_sc_hd__bufinv_16
XFILLER_0_73_273 VGND VGND VPWR VPWR sky130_fd_sc_hd__decap_6
X_3859_ _1043_ _1040_ VGND VGND VPWR VPWR _1085_ sky130_fd_sc_hd__or2b_1
XFILLER_0_61_446 VGND VGND VPWR VPWR sky130_fd_sc_hd__fill_2
XFILLER_0_37_421 VGND VGND VPWR VPWR sky130_fd_sc_hd__decap_3
XFILLER_0_49_281 VPWR VGND VPWR VGND sky130_ef_sc_hd__decap_12
XFILLER_0_64_251 VGND VGND VPWR VPWR sky130_fd_sc_hd__fill_1
XTAP_TAPCELL_ROW_12_279 VGND VPWR sky130_fd_sc_hd__tapvpwrvgnd_1
XFILLER_0_24_148 VGND VGND VPWR VPWR sky130_fd_sc_hd__fill_2
XFILLER_0_20_365 VPWR VGND VPWR VGND sky130_ef_sc_hd__decap_12
XFILLER_0_46_24 VGND VGND VPWR VPWR sky130_fd_sc_hd__decap_4
XFILLER_0_1_15 VPWR VGND VPWR VGND sky130_ef_sc_hd__decap_12
XFILLER_0_28_421 VGND VGND VPWR VPWR sky130_fd_sc_hd__decap_3
X_4762_ clknet_4_10_0_clk _0127_ VGND VGND VPWR VPWR u_interface.core_attn_out\[10\]
+ sky130_fd_sc_hd__dfxtp_1
XFILLER_0_7_337 VPWR VGND VPWR VGND sky130_ef_sc_hd__decap_12
X_3713_ _0920_ _0922_ VGND VGND VPWR VPWR _0942_ sky130_fd_sc_hd__and2_1
X_4693_ clknet_4_8_0_clk _0058_ VGND VGND VPWR VPWR u_interface.core_valid_out sky130_fd_sc_hd__dfxtp_2
XFILLER_0_43_424 VPWR VGND VPWR VGND sky130_ef_sc_hd__decap_12
XFILLER_0_15_148 VGND VGND VPWR VPWR sky130_fd_sc_hd__decap_8
X_3644_ _0847_ _0874_ VGND VGND VPWR VPWR _0875_ sky130_fd_sc_hd__xnor2_1
XFILLER_0_43_446 VGND VGND VPWR VPWR sky130_fd_sc_hd__fill_2
XFILLER_0_70_243 VGND VGND VPWR VPWR sky130_fd_sc_hd__fill_1
X_3575_ _0803_ _0806_ VGND VGND VPWR VPWR _0807_ sky130_fd_sc_hd__xnor2_2
X_2526_ _1953_ _1962_ VGND VGND VPWR VPWR _1963_ sky130_fd_sc_hd__and2_1
X_2457_ _1915_ VGND VGND VPWR VPWR _0034_ sky130_fd_sc_hd__clkbuf_1
Xhold28 _0151_ VGND VGND VPWR VPWR net92 sky130_fd_sc_hd__dlygate4sd3_1
XFILLER_0_46_3 VPWR VGND VPWR VGND sky130_ef_sc_hd__decap_12
XTAP_TAPCELL_ROW_3_203 VGND VPWR sky130_fd_sc_hd__tapvpwrvgnd_1
Xhold39 u_interface.u_compute_core.mac_accum\[4\] VGND VGND VPWR VPWR net103 sky130_fd_sc_hd__dlygate4sd3_1
X_2388_ _1865_ VGND VGND VPWR VPWR _1866_ sky130_fd_sc_hd__inv_2
X_4127_ _1344_ _1346_ _1343_ VGND VGND VPWR VPWR _1348_ sky130_fd_sc_hd__a21oi_1
XFILLER_0_78_321 VGND VGND VPWR VPWR sky130_fd_sc_hd__decap_8
X_4058_ _1278_ _1279_ VGND VGND VPWR VPWR _1280_ sky130_fd_sc_hd__xnor2_1
X_3009_ _2182_ _2275_ _0263_ _0264_ VGND VGND VPWR VPWR _0266_ sky130_fd_sc_hd__nor4_1
XTAP_TAPCELL_ROW_54_636 VGND VPWR sky130_fd_sc_hd__tapvpwrvgnd_1
XFILLER_0_78_365 VGND VGND VPWR VPWR sky130_fd_sc_hd__decap_4
XFILLER_0_78_398 VGND VGND VPWR VPWR sky130_fd_sc_hd__decap_8
XFILLER_0_34_468 VGND VGND VPWR VPWR sky130_fd_sc_hd__decap_8
XFILLER_0_69_310 VPWR VGND VPWR VGND sky130_ef_sc_hd__decap_12
XFILLER_0_4_307 VGND VGND VPWR VPWR sky130_fd_sc_hd__fill_1
XFILLER_0_25_413 VGND VGND VPWR VPWR sky130_fd_sc_hd__decap_4
X_3360_ u_interface.u_compute_core.relu_data\[0\] _0596_ VGND VGND VPWR VPWR _0597_
+ sky130_fd_sc_hd__nor2b_2
XFILLER_0_20_184 VPWR VGND VPWR VGND sky130_ef_sc_hd__decap_12
XPHY_EDGE_ROW_29_Left_111 VGND VGND VPWR VPWR sky130_fd_sc_hd__decap_3
X_3291_ _0464_ _0482_ _0498_ VGND VGND VPWR VPWR _0530_ sky130_fd_sc_hd__o21a_1
XFILLER_0_73_55 VGND VGND VPWR VPWR sky130_fd_sc_hd__fill_1
XFILLER_0_73_77 VGND VGND VPWR VPWR sky130_fd_sc_hd__fill_1
XPHY_EDGE_ROW_38_Left_120 VGND VGND VPWR VPWR sky130_fd_sc_hd__decap_3
XFILLER_0_75_335 VGND VGND VPWR VPWR sky130_fd_sc_hd__fill_1
XTAP_TAPCELL_ROW_51_606 VGND VPWR sky130_fd_sc_hd__tapvpwrvgnd_1
X_4814_ clknet_4_13_0_clk _0179_ VGND VGND VPWR VPWR net50 sky130_fd_sc_hd__dfxtp_1
XFILLER_0_75_368 VGND VGND VPWR VPWR sky130_fd_sc_hd__decap_3
XFILLER_0_28_251 VGND VGND VPWR VPWR sky130_fd_sc_hd__fill_1
X_4745_ clknet_4_8_0_clk _0110_ VGND VGND VPWR VPWR u_interface.u_compute_core.u_av.v_extended\[1\]
+ sky130_fd_sc_hd__dfxtp_2
XFILLER_0_7_167 VGND VGND VPWR VPWR sky130_fd_sc_hd__fill_1
XFILLER_0_43_243 VGND VGND VPWR VPWR sky130_fd_sc_hd__fill_1
XFILLER_0_43_276 VGND VGND VPWR VPWR sky130_fd_sc_hd__decap_4
X_4676_ clknet_4_6_0_clk _0041_ VGND VGND VPWR VPWR u_interface.u_compute_core.scaled_data\[12\]
+ sky130_fd_sc_hd__dfxtp_1
X_3627_ _0854_ _0857_ VGND VGND VPWR VPWR _0858_ sky130_fd_sc_hd__xnor2_1
XFILLER_0_3_373 VPWR VGND VPWR VGND sky130_ef_sc_hd__decap_12
X_3558_ _0763_ _0790_ VGND VGND VPWR VPWR _0791_ sky130_fd_sc_hd__xor2_2
Xoutput29 net29 VGND VGND VPWR VPWR m_tdata[0] sky130_fd_sc_hd__buf_2
X_2509_ u_interface.u_compute_core.scaled_data\[22\] u_interface.u_compute_core.mac_accum\[25\]
+ _1944_ VGND VGND VPWR VPWR _1951_ sky130_fd_sc_hd__mux2_1
X_3489_ _0483_ _1841_ VGND VGND VPWR VPWR _0723_ sky130_fd_sc_hd__nand2_1
XFILLER_0_78_173 VGND VGND VPWR VPWR sky130_fd_sc_hd__decap_6
XFILLER_0_81_305 VGND VGND VPWR VPWR sky130_fd_sc_hd__decap_3
XFILLER_0_66_379 VPWR VGND VPWR VGND sky130_ef_sc_hd__decap_12
XFILLER_0_81_349 VPWR VGND VPWR VGND sky130_ef_sc_hd__decap_12
XTAP_TAPCELL_ROW_22_363 VGND VPWR sky130_fd_sc_hd__tapvpwrvgnd_1
XFILLER_0_22_427 VGND VGND VPWR VPWR sky130_fd_sc_hd__fill_1
XFILLER_0_34_298 VGND VGND VPWR VPWR sky130_fd_sc_hd__decap_8
XFILLER_0_27_15 VPWR VGND VPWR VGND sky130_ef_sc_hd__decap_12
XFILLER_0_43_47 VGND VGND VPWR VPWR sky130_fd_sc_hd__decap_4
XTAP_TAPCELL_ROW_73_797 VGND VPWR sky130_fd_sc_hd__tapvpwrvgnd_1
X_2860_ net17 VGND VGND VPWR VPWR _2256_ sky130_fd_sc_hd__buf_2
X_2791_ _2177_ _2175_ _2188_ _2189_ VGND VGND VPWR VPWR _2190_ sky130_fd_sc_hd__o211a_1
X_4530_ _1731_ _1735_ _1738_ VGND VGND VPWR VPWR _1740_ sky130_fd_sc_hd__a21oi_1
XFILLER_0_13_405 VGND VGND VPWR VPWR sky130_fd_sc_hd__fill_2
XFILLER_0_25_276 VGND VGND VPWR VPWR sky130_fd_sc_hd__decap_4
X_4461_ _1670_ _1674_ VGND VGND VPWR VPWR _1675_ sky130_fd_sc_hd__xor2_1
XFILLER_0_13_449 VPWR VGND VPWR VGND sky130_ef_sc_hd__decap_12
X_3412_ _0638_ _0647_ VGND VGND VPWR VPWR _0648_ sky130_fd_sc_hd__xnor2_1
XFILLER_0_0_321 VPWR VGND VPWR VGND sky130_ef_sc_hd__decap_12
X_4392_ _1605_ _1606_ VGND VGND VPWR VPWR _1608_ sky130_fd_sc_hd__and2_1
X_3343_ _0571_ _0570_ _0579_ VGND VGND VPWR VPWR _0580_ sky130_fd_sc_hd__o21ai_1
XFILLER_0_0_365 VPWR VGND VPWR VGND sky130_ef_sc_hd__decap_12
X_3274_ _0445_ u_interface.u_compute_core.u_av.v_extended\[2\] _0458_ _1818_ VGND
+ VGND VPWR VPWR _0513_ sky130_fd_sc_hd__and4_1
XTAP_TAPCELL_ROW_64_720 VGND VPWR sky130_fd_sc_hd__tapvpwrvgnd_1
XPHY_EDGE_ROW_5_Right_5 VGND VGND VPWR VPWR sky130_fd_sc_hd__decap_3
XFILLER_0_48_302 VGND VGND VPWR VPWR sky130_fd_sc_hd__decap_6
XFILLER_0_8_421 VGND VGND VPWR VPWR sky130_fd_sc_hd__decap_8
XFILLER_0_33_91 VPWR VGND VPWR VGND sky130_ef_sc_hd__decap_12
XFILLER_0_63_305 VPWR VGND VPWR VGND sky130_ef_sc_hd__decap_12
X_2989_ _0205_ _0245_ VGND VGND VPWR VPWR _0247_ sky130_fd_sc_hd__nand2_1
XFILLER_0_16_265 VGND VGND VPWR VPWR sky130_fd_sc_hd__decap_4
X_4728_ clknet_4_0_0_clk _0093_ VGND VGND VPWR VPWR u_interface.u_compute_core.u_mac.product_reg\[2\]
+ sky130_fd_sc_hd__dfxtp_1
XFILLER_0_71_393 VPWR VGND VPWR VGND sky130_ef_sc_hd__decap_12
X_4659_ clknet_4_7_0_clk _0024_ VGND VGND VPWR VPWR u_interface.u_compute_core.relu_data\[24\]
+ sky130_fd_sc_hd__dfxtp_1
XFILLER_0_3_181 VPWR VGND VPWR VGND sky130_ef_sc_hd__decap_12
XFILLER_0_31_268 VGND VGND VPWR VPWR sky130_fd_sc_hd__decap_4
XFILLER_0_31_279 VGND VGND VPWR VPWR sky130_fd_sc_hd__fill_1
XFILLER_0_39_335 VGND VGND VPWR VPWR sky130_fd_sc_hd__fill_1
XFILLER_0_81_113 VPWR VGND VPWR VGND sky130_ef_sc_hd__decap_12
XTAP_TAPCELL_ROW_70_767 VGND VPWR sky130_fd_sc_hd__tapvpwrvgnd_1
XFILLER_0_1_107 VGND VGND VPWR VPWR sky130_fd_sc_hd__decap_4
XFILLER_0_38_25 VGND VGND VPWR VPWR sky130_fd_sc_hd__decap_3
XFILLER_0_54_68 VGND VGND VPWR VPWR sky130_fd_sc_hd__fill_1
X_3961_ _0442_ _1865_ _1133_ _1184_ VGND VGND VPWR VPWR _1185_ sky130_fd_sc_hd__a31o_1
X_2912_ _2253_ _2260_ _2306_ VGND VGND VPWR VPWR _2307_ sky130_fd_sc_hd__o21ai_1
XTAP_TAPCELL_ROW_33_458 VGND VPWR sky130_fd_sc_hd__tapvpwrvgnd_1
X_3892_ _1083_ _1084_ _1116_ VGND VGND VPWR VPWR _1118_ sky130_fd_sc_hd__nand3_1
X_2843_ _2238_ _2239_ VGND VGND VPWR VPWR _2240_ sky130_fd_sc_hd__xor2_1
XFILLER_0_45_349 VGND VGND VPWR VPWR sky130_fd_sc_hd__decap_8
XFILLER_0_72_168 VPWR VGND VPWR VGND sky130_ef_sc_hd__decap_12
X_2774_ _2162_ _2168_ _2172_ _2173_ VGND VGND VPWR VPWR _2174_ sky130_fd_sc_hd__a22o_1
X_4513_ _1701_ _1720_ _1724_ VGND VGND VPWR VPWR _1725_ sky130_fd_sc_hd__a21oi_1
XFILLER_0_53_371 VPWR VGND VPWR VGND sky130_ef_sc_hd__decap_12
X_4444_ _1656_ _1658_ VGND VGND VPWR VPWR _1659_ sky130_fd_sc_hd__xnor2_1
X_4375_ _1585_ _1590_ VGND VGND VPWR VPWR _1591_ sky130_fd_sc_hd__xnor2_1
X_3326_ _0562_ _0563_ VGND VGND VPWR VPWR _0564_ sky130_fd_sc_hd__xnor2_1
XFILLER_0_0_195 VGND VGND VPWR VPWR sky130_fd_sc_hd__fill_1
X_3257_ _0489_ _0490_ _0495_ VGND VGND VPWR VPWR _0497_ sky130_fd_sc_hd__o21ai_1
XFILLER_0_28_80 VGND VGND VPWR VPWR sky130_fd_sc_hd__decap_4
X_3188_ _1812_ VGND VGND VPWR VPWR _0434_ sky130_fd_sc_hd__clkbuf_4
XTAP_TAPCELL_ROW_49_591 VGND VPWR sky130_fd_sc_hd__tapvpwrvgnd_1
XFILLER_0_68_419 VGND VGND VPWR VPWR sky130_fd_sc_hd__fill_1
XFILLER_0_63_113 VPWR VGND VPWR VGND sky130_ef_sc_hd__decap_12
XTAP_TAPCELL_ROW_75_815 VGND VPWR sky130_fd_sc_hd__tapvpwrvgnd_1
XTAP_TAPCELL_ROW_30_428 VGND VPWR sky130_fd_sc_hd__tapvpwrvgnd_1
XFILLER_0_35_393 VGND VGND VPWR VPWR sky130_fd_sc_hd__decap_4
XFILLER_0_50_363 VGND VGND VPWR VPWR sky130_fd_sc_hd__fill_1
X_2490_ u_interface.u_compute_core.scaled_data\[16\] u_interface.u_compute_core.mac_accum\[19\]
+ _1922_ VGND VGND VPWR VPWR _1938_ sky130_fd_sc_hd__mux2_1
XFILLER_0_49_57 VGND VGND VPWR VPWR sky130_fd_sc_hd__fill_1
XFILLER_0_49_68 VGND VGND VPWR VPWR sky130_fd_sc_hd__decap_8
XFILLER_0_4_15 VPWR VGND VPWR VGND sky130_ef_sc_hd__decap_12
X_4160_ _0438_ u_interface.u_compute_core.relu_data\[21\] _1378_ VGND VGND VPWR VPWR
+ _1380_ sky130_fd_sc_hd__and3_1
X_3111_ _0237_ _0307_ VGND VGND VPWR VPWR _0365_ sky130_fd_sc_hd__xnor2_1
X_4091_ _1311_ _1312_ VGND VGND VPWR VPWR _1313_ sky130_fd_sc_hd__or2_1
X_3042_ _2226_ _2244_ _2256_ _2220_ VGND VGND VPWR VPWR _0298_ sky130_fd_sc_hd__a22oi_1
XFILLER_0_18_316 VGND VGND VPWR VPWR sky130_fd_sc_hd__decap_8
X_3944_ _1166_ _1167_ u_interface.core_attn_out\[16\] VGND VGND VPWR VPWR _1169_ sky130_fd_sc_hd__a21oi_1
X_3875_ _1050_ _1052_ VGND VGND VPWR VPWR _1101_ sky130_fd_sc_hd__nand2_1
XFILLER_0_73_455 VGND VGND VPWR VPWR sky130_fd_sc_hd__decap_4
X_2826_ _2201_ _2205_ _2203_ VGND VGND VPWR VPWR _2223_ sky130_fd_sc_hd__o21ai_2
XFILLER_0_30_92 VPWR VGND VPWR VGND sky130_ef_sc_hd__decap_12
X_2757_ _2157_ _2158_ _2004_ VGND VGND VPWR VPWR _2160_ sky130_fd_sc_hd__a21oi_1
XFILLER_0_76_3 VPWR VGND VPWR VGND sky130_ef_sc_hd__decap_12
X_2688_ _2064_ u_interface.u_compute_core.mac_accum\[21\] VGND VGND VPWR VPWR _2101_
+ sky130_fd_sc_hd__xor2_1
X_4427_ _1640_ _1597_ _1641_ VGND VGND VPWR VPWR _1642_ sky130_fd_sc_hd__a21oi_1
X_4358_ _1573_ _1562_ VGND VGND VPWR VPWR _1574_ sky130_fd_sc_hd__nor2_1
X_3309_ _0513_ _0546_ VGND VGND VPWR VPWR _0547_ sky130_fd_sc_hd__xnor2_1
X_4289_ _1397_ _1449_ _1447_ VGND VGND VPWR VPWR _1507_ sky130_fd_sc_hd__a21oi_1
XTAP_TAPCELL_ROW_1_186 VGND VPWR sky130_fd_sc_hd__tapvpwrvgnd_1
XFILLER_0_76_293 VGND VGND VPWR VPWR sky130_fd_sc_hd__fill_1
XFILLER_0_36_157 VPWR VGND VPWR VGND sky130_ef_sc_hd__decap_12
XFILLER_0_64_477 VGND VGND VPWR VPWR sky130_fd_sc_hd__decap_3
XFILLER_0_17_393 VGND VGND VPWR VPWR sky130_fd_sc_hd__decap_8
XFILLER_0_32_363 VGND VGND VPWR VPWR sky130_fd_sc_hd__fill_1
XTAP_TAPCELL_ROW_9_253 VGND VPWR sky130_fd_sc_hd__tapvpwrvgnd_1
XFILLER_0_35_15 VGND VGND VPWR VPWR sky130_fd_sc_hd__decap_4
XFILLER_0_35_26 VGND VGND VPWR VPWR sky130_fd_sc_hd__decap_8
XTAP_TAPCELL_ROW_43_542 VGND VPWR sky130_fd_sc_hd__tapvpwrvgnd_1
XFILLER_0_51_36 VPWR VGND VPWR VGND sky130_ef_sc_hd__decap_12
XFILLER_0_27_113 VPWR VGND VPWR VGND sky130_ef_sc_hd__decap_12
XFILLER_0_67_293 VGND VGND VPWR VPWR sky130_fd_sc_hd__decap_8
XFILLER_0_27_146 VPWR VGND VPWR VGND sky130_ef_sc_hd__decap_12
XFILLER_0_55_466 VPWR VGND VPWR VGND sky130_ef_sc_hd__decap_12
X_3660_ u_interface.core_attn_out\[9\] _0841_ _0890_ VGND VGND VPWR VPWR _0891_ sky130_fd_sc_hd__a21oi_1
Xclkload12 clknet_4_13_0_clk VGND VGND VPWR VPWR clkload12/Y sky130_fd_sc_hd__inv_6
X_3591_ _0779_ _0781_ VGND VGND VPWR VPWR _0823_ sky130_fd_sc_hd__and2_1
X_2611_ _2033_ _2034_ VGND VGND VPWR VPWR _2035_ sky130_fd_sc_hd__nand2_1
X_2542_ u_interface.u_compute_core.u_mac.product_reg\[1\] u_interface.u_compute_core.mac_accum\[1\]
+ VGND VGND VPWR VPWR _1975_ sky130_fd_sc_hd__or2_1
XFILLER_0_50_171 VPWR VGND VPWR VGND sky130_ef_sc_hd__decap_12
X_2473_ _1926_ VGND VGND VPWR VPWR _0039_ sky130_fd_sc_hd__clkbuf_1
X_4212_ _1379_ _1382_ _1380_ VGND VGND VPWR VPWR _1431_ sky130_fd_sc_hd__o21ba_1
XFILLER_0_76_77 VGND VGND VPWR VPWR sky130_fd_sc_hd__decap_6
X_4143_ _1269_ _1316_ _1317_ VGND VGND VPWR VPWR _1364_ sky130_fd_sc_hd__and3b_1
X_4074_ _0423_ _1884_ _1246_ _0427_ VGND VGND VPWR VPWR _1296_ sky130_fd_sc_hd__a22o_1
X_3025_ _0205_ _0280_ VGND VGND VPWR VPWR _0282_ sky130_fd_sc_hd__nand2_1
XFILLER_0_18_135 VGND VGND VPWR VPWR sky130_fd_sc_hd__decap_4
XFILLER_0_46_477 VGND VGND VPWR VPWR sky130_fd_sc_hd__decap_6
X_3927_ _0423_ _1151_ _1874_ _0427_ VGND VGND VPWR VPWR _1152_ sky130_fd_sc_hd__a22oi_1
X_3858_ _1039_ _1066_ VGND VGND VPWR VPWR _1084_ sky130_fd_sc_hd__nand2_1
Xclkload6 clknet_4_6_0_clk VGND VGND VPWR VPWR clkload6/Y sky130_fd_sc_hd__clkinvlp_2
X_2809_ _2200_ _2206_ VGND VGND VPWR VPWR _2207_ sky130_fd_sc_hd__xnor2_1
XFILLER_0_26_190 VGND VGND VPWR VPWR sky130_fd_sc_hd__fill_1
X_3789_ _1015_ _1016_ VGND VGND VPWR VPWR _1017_ sky130_fd_sc_hd__and2_1
XTAP_TAPCELL_ROW_6_223 VGND VPWR sky130_fd_sc_hd__tapvpwrvgnd_1
XFILLER_0_49_293 VPWR VGND VPWR VGND sky130_ef_sc_hd__decap_12
XTAP_TAPCELL_ROW_40_512 VGND VPWR sky130_fd_sc_hd__tapvpwrvgnd_1
XFILLER_0_20_377 VGND VGND VPWR VPWR sky130_fd_sc_hd__decap_4
XFILLER_0_1_27 VPWR VGND VPWR VGND sky130_ef_sc_hd__decap_12
XFILLER_0_62_68 VGND VGND VPWR VPWR sky130_fd_sc_hd__fill_1
X_4761_ clknet_4_10_0_clk _0126_ VGND VGND VPWR VPWR u_interface.core_attn_out\[9\]
+ sky130_fd_sc_hd__dfxtp_1
XFILLER_0_7_327 VGND VGND VPWR VPWR sky130_fd_sc_hd__fill_2
X_3712_ _0887_ _0932_ _0933_ VGND VGND VPWR VPWR _0941_ sky130_fd_sc_hd__o21a_1
XFILLER_0_7_349 VGND VGND VPWR VPWR sky130_fd_sc_hd__decap_4
XFILLER_0_28_477 VGND VGND VPWR VPWR sky130_fd_sc_hd__decap_6
XFILLER_0_43_436 VGND VGND VPWR VPWR sky130_fd_sc_hd__fill_2
XFILLER_0_55_274 VGND VGND VPWR VPWR sky130_fd_sc_hd__decap_6
X_4692_ clknet_4_7_0_clk _0057_ VGND VGND VPWR VPWR u_interface.u_compute_core.scaled_data\[28\]
+ sky130_fd_sc_hd__dfxtp_1
XFILLER_0_70_200 VGND VGND VPWR VPWR sky130_fd_sc_hd__decap_3
X_3643_ _0871_ _0873_ VGND VGND VPWR VPWR _0874_ sky130_fd_sc_hd__xnor2_1
XFILLER_0_30_108 VGND VGND VPWR VPWR sky130_fd_sc_hd__fill_1
XFILLER_0_70_266 VPWR VGND VPWR VGND sky130_ef_sc_hd__decap_12
XFILLER_0_11_333 VGND VGND VPWR VPWR sky130_fd_sc_hd__decap_3
XFILLER_0_11_322 VGND VGND VPWR VPWR sky130_fd_sc_hd__decap_4
X_3574_ _0804_ _0805_ VGND VGND VPWR VPWR _0806_ sky130_fd_sc_hd__or2_1
X_2525_ u_interface.u_compute_core.scaled_data\[27\] u_interface.u_compute_core.mac_accum\[30\]
+ _1944_ VGND VGND VPWR VPWR _1962_ sky130_fd_sc_hd__mux2_1
X_2456_ _1909_ _1914_ VGND VGND VPWR VPWR _1915_ sky130_fd_sc_hd__and2_1
Xhold29 u_interface.u_compute_core.u_mac.product_reg\[6\] VGND VGND VPWR VPWR net93
+ sky130_fd_sc_hd__dlygate4sd3_1
XTAP_TAPCELL_ROW_3_204 VGND VPWR sky130_fd_sc_hd__tapvpwrvgnd_1
XFILLER_0_39_3 VPWR VGND VPWR VGND sky130_ef_sc_hd__decap_12
X_2387_ u_interface.u_compute_core.relu_data\[15\] VGND VGND VPWR VPWR _1865_ sky130_fd_sc_hd__clkbuf_4
X_4126_ _1343_ _1344_ _1346_ VGND VGND VPWR VPWR _1347_ sky130_fd_sc_hd__and3_1
XFILLER_0_78_300 VGND VGND VPWR VPWR sky130_fd_sc_hd__decap_8
X_4057_ _0437_ u_interface.u_compute_core.relu_data\[19\] VGND VGND VPWR VPWR _1279_
+ sky130_fd_sc_hd__nand2_1
X_3008_ _2182_ _2275_ _0263_ _0264_ VGND VGND VPWR VPWR _0265_ sky130_fd_sc_hd__o22a_1
XTAP_TAPCELL_ROW_54_637 VGND VPWR sky130_fd_sc_hd__tapvpwrvgnd_1
XFILLER_0_38_208 VGND VGND VPWR VPWR sky130_fd_sc_hd__fill_2
XFILLER_0_19_444 VGND VGND VPWR VPWR sky130_fd_sc_hd__decap_4
XFILLER_0_61_200 VGND VGND VPWR VPWR sky130_fd_sc_hd__decap_4
XFILLER_0_6_382 VGND VGND VPWR VPWR sky130_fd_sc_hd__fill_1
XFILLER_0_61_277 VGND VGND VPWR VPWR sky130_fd_sc_hd__decap_3
XTAP_TAPCELL_ROW_17_317 VGND VPWR sky130_fd_sc_hd__tapvpwrvgnd_1
XFILLER_0_69_322 VGND VGND VPWR VPWR sky130_fd_sc_hd__decap_8
XFILLER_0_25_425 VGND VGND VPWR VPWR sky130_fd_sc_hd__fill_1
XFILLER_0_52_200 VPWR VGND VPWR VGND sky130_ef_sc_hd__decap_12
XFILLER_0_25_447 VGND VGND VPWR VPWR sky130_fd_sc_hd__fill_1
XFILLER_0_40_439 VPWR VGND VPWR VGND sky130_ef_sc_hd__decap_12
X_3290_ _0526_ _0527_ _0506_ VGND VGND VPWR VPWR _0529_ sky130_fd_sc_hd__a21o_1
XFILLER_0_57_57 VPWR VGND VPWR VGND sky130_ef_sc_hd__decap_12
XTAP_TAPCELL_ROW_51_607 VGND VPWR sky130_fd_sc_hd__tapvpwrvgnd_1
X_4813_ clknet_4_15_0_clk _0178_ VGND VGND VPWR VPWR net49 sky130_fd_sc_hd__dfxtp_1
XFILLER_0_28_230 VGND VGND VPWR VPWR sky130_fd_sc_hd__decap_8
X_4744_ clknet_4_8_0_clk _0109_ VGND VGND VPWR VPWR u_interface.u_compute_core.u_av.v_extended\[0\]
+ sky130_fd_sc_hd__dfxtp_1
XFILLER_0_22_82 VGND VGND VPWR VPWR sky130_fd_sc_hd__fill_2
X_4675_ clknet_4_6_0_clk _0040_ VGND VGND VPWR VPWR u_interface.u_compute_core.scaled_data\[11\]
+ sky130_fd_sc_hd__dfxtp_1
X_3626_ _0855_ _0856_ VGND VGND VPWR VPWR _0857_ sky130_fd_sc_hd__nor2_1
XFILLER_0_3_385 VGND VGND VPWR VPWR sky130_fd_sc_hd__decap_6
X_3557_ _0789_ _0787_ VGND VGND VPWR VPWR _0790_ sky130_fd_sc_hd__xnor2_2
X_2508_ _1950_ VGND VGND VPWR VPWR _0050_ sky130_fd_sc_hd__clkbuf_1
X_3488_ _0672_ _0721_ VGND VGND VPWR VPWR _0722_ sky130_fd_sc_hd__xnor2_2
X_2439_ u_interface.u_compute_core.scaled_data\[0\] u_interface.u_compute_core.mac_accum\[3\]
+ _1900_ VGND VGND VPWR VPWR _1903_ sky130_fd_sc_hd__mux2_1
X_4109_ _1328_ _1329_ VGND VGND VPWR VPWR _1330_ sky130_fd_sc_hd__xnor2_1
XFILLER_0_78_141 VPWR VGND VPWR VGND sky130_ef_sc_hd__decap_12
XFILLER_0_19_241 VGND VGND VPWR VPWR sky130_fd_sc_hd__fill_1
XTAP_TAPCELL_ROW_22_364 VGND VPWR sky130_fd_sc_hd__tapvpwrvgnd_1
XFILLER_0_27_27 VGND VGND VPWR VPWR sky130_fd_sc_hd__fill_2
XFILLER_0_57_303 VGND VGND VPWR VPWR sky130_fd_sc_hd__fill_1
XFILLER_0_69_196 VGND VGND VPWR VPWR sky130_fd_sc_hd__decap_3
XTAP_TAPCELL_ROW_73_798 VGND VPWR sky130_fd_sc_hd__tapvpwrvgnd_1
X_2790_ _2179_ _2181_ _2185_ _2186_ VGND VGND VPWR VPWR _2189_ sky130_fd_sc_hd__a22o_1
XFILLER_0_65_391 VGND VGND VPWR VPWR sky130_fd_sc_hd__fill_1
X_4460_ _1671_ _1673_ VGND VGND VPWR VPWR _1674_ sky130_fd_sc_hd__nand2_1
XFILLER_0_7_15 VGND VGND VPWR VPWR sky130_fd_sc_hd__fill_2
X_4391_ _1605_ _1606_ VGND VGND VPWR VPWR _1607_ sky130_fd_sc_hd__nor2_1
X_3411_ _0644_ _0646_ VGND VGND VPWR VPWR _0647_ sky130_fd_sc_hd__xor2_1
X_3342_ _0568_ _0569_ VGND VGND VPWR VPWR _0579_ sky130_fd_sc_hd__or2b_1
XFILLER_0_0_333 VGND VGND VPWR VPWR sky130_fd_sc_hd__decap_3
XFILLER_0_0_377 VPWR VGND VPWR VGND sky130_ef_sc_hd__decap_12
X_3273_ u_interface.u_compute_core.u_av.v_extended\[2\] _0458_ _1818_ _0511_ VGND
+ VGND VPWR VPWR _0512_ sky130_fd_sc_hd__a22oi_1
XTAP_TAPCELL_ROW_64_721 VGND VPWR sky130_fd_sc_hd__tapvpwrvgnd_1
XFILLER_0_75_111 VGND VGND VPWR VPWR sky130_fd_sc_hd__fill_1
XTAP_TAPCELL_ROW_36_478 VGND VPWR sky130_fd_sc_hd__tapvpwrvgnd_1
XFILLER_0_33_81 VGND VGND VPWR VPWR sky130_fd_sc_hd__decap_3
XFILLER_0_63_317 VGND VGND VPWR VPWR sky130_fd_sc_hd__fill_1
XFILLER_0_8_477 VGND VGND VPWR VPWR sky130_fd_sc_hd__decap_6
X_2988_ _0205_ _0245_ VGND VGND VPWR VPWR _0246_ sky130_fd_sc_hd__or2_1
XFILLER_0_71_361 VPWR VGND VPWR VGND sky130_ef_sc_hd__decap_12
X_4727_ clknet_4_1_0_clk _0092_ VGND VGND VPWR VPWR u_interface.u_compute_core.u_mac.product_reg\[1\]
+ sky130_fd_sc_hd__dfxtp_1
XFILLER_0_16_288 VGND VGND VPWR VPWR sky130_fd_sc_hd__fill_1
XFILLER_0_31_225 VGND VGND VPWR VPWR sky130_fd_sc_hd__decap_3
X_4658_ clknet_4_7_0_clk _0023_ VGND VGND VPWR VPWR u_interface.u_compute_core.relu_data\[23\]
+ sky130_fd_sc_hd__dfxtp_1
X_3609_ _0833_ _0840_ VGND VGND VPWR VPWR _0841_ sky130_fd_sc_hd__xor2_2
XFILLER_0_3_193 VPWR VGND VPWR VGND sky130_ef_sc_hd__decap_12
X_4589_ net37 u_interface.core_attn_out\[17\] _1760_ VGND VGND VPWR VPWR _1780_ sky130_fd_sc_hd__mux2_1
XFILLER_0_79_483 VGND VGND VPWR VPWR sky130_fd_sc_hd__fill_1
XPHY_EDGE_ROW_11_Right_11 VGND VGND VPWR VPWR sky130_fd_sc_hd__decap_3
XTAP_TAPCELL_ROW_70_768 VGND VPWR sky130_fd_sc_hd__tapvpwrvgnd_1
XFILLER_0_81_125 VPWR VGND VPWR VGND sky130_ef_sc_hd__decap_12
XFILLER_0_81_169 VPWR VGND VPWR VGND sky130_ef_sc_hd__decap_12
XPHY_EDGE_ROW_57_Left_139 VGND VGND VPWR VPWR sky130_fd_sc_hd__decap_3
XFILLER_0_22_269 VGND VGND VPWR VPWR sky130_fd_sc_hd__decap_8
XPHY_EDGE_ROW_20_Right_20 VGND VGND VPWR VPWR sky130_fd_sc_hd__decap_3
XFILLER_0_38_15 VGND VGND VPWR VPWR sky130_fd_sc_hd__fill_1
XTAP_TAPCELL_ROW_78_835 VGND VPWR sky130_fd_sc_hd__tapvpwrvgnd_1
XPHY_EDGE_ROW_66_Left_148 VGND VGND VPWR VPWR sky130_fd_sc_hd__decap_3
X_3960_ _0438_ _1868_ _1131_ VGND VGND VPWR VPWR _1184_ sky130_fd_sc_hd__and3_1
XFILLER_0_57_111 VGND VGND VPWR VPWR sky130_fd_sc_hd__fill_1
X_2911_ _2219_ _2252_ VGND VGND VPWR VPWR _2306_ sky130_fd_sc_hd__or2b_1
XTAP_TAPCELL_ROW_33_459 VGND VPWR sky130_fd_sc_hd__tapvpwrvgnd_1
X_3891_ _1083_ _1084_ _1116_ VGND VGND VPWR VPWR _1117_ sky130_fd_sc_hd__a21o_1
XFILLER_0_45_306 VPWR VGND VPWR VGND sky130_ef_sc_hd__decap_12
XPHY_EDGE_ROW_75_Left_157 VGND VGND VPWR VPWR sky130_fd_sc_hd__decap_3
X_2842_ _2207_ _2208_ _2210_ VGND VGND VPWR VPWR _2239_ sky130_fd_sc_hd__a21o_1
X_2773_ _2170_ _2171_ _2167_ VGND VGND VPWR VPWR _2173_ sky130_fd_sc_hd__a21bo_1
X_4512_ _1719_ u_interface.core_attn_out\[28\] VGND VGND VPWR VPWR _1724_ sky130_fd_sc_hd__and2b_1
XFILLER_0_13_225 VPWR VGND VPWR VGND sky130_ef_sc_hd__decap_12
XFILLER_0_53_383 VGND VGND VPWR VPWR sky130_fd_sc_hd__decap_8
XFILLER_0_79_55 VGND VGND VPWR VPWR sky130_fd_sc_hd__fill_1
X_4443_ _1568_ _1657_ _1611_ VGND VGND VPWR VPWR _1658_ sky130_fd_sc_hd__o21ai_1
X_4374_ _1588_ _1589_ VGND VGND VPWR VPWR _1590_ sky130_fd_sc_hd__xnor2_1
XFILLER_0_0_141 VPWR VGND VPWR VGND sky130_ef_sc_hd__decap_12
X_3325_ _0517_ _0519_ VGND VGND VPWR VPWR _0563_ sky130_fd_sc_hd__and2_1
X_3256_ _0489_ _0490_ _0495_ VGND VGND VPWR VPWR _0496_ sky130_fd_sc_hd__or3_1
XFILLER_0_28_92 VGND VGND VPWR VPWR sky130_fd_sc_hd__decap_6
XFILLER_0_21_3 VGND VGND VPWR VPWR sky130_fd_sc_hd__decap_4
X_3187_ _1968_ net19 _0420_ _0433_ VGND VGND VPWR VPWR _0111_ sky130_fd_sc_hd__o211a_1
XTAP_TAPCELL_ROW_49_592 VGND VPWR sky130_fd_sc_hd__tapvpwrvgnd_1
XFILLER_0_76_475 VGND VGND VPWR VPWR sky130_fd_sc_hd__fill_1
XFILLER_0_8_285 VGND VGND VPWR VPWR sky130_fd_sc_hd__decap_6
XFILLER_0_44_350 VPWR VGND VPWR VGND sky130_ef_sc_hd__decap_12
XFILLER_0_63_147 VGND VGND VPWR VPWR sky130_fd_sc_hd__fill_1
XFILLER_0_63_169 VGND VGND VPWR VPWR sky130_fd_sc_hd__decap_6
XTAP_TAPCELL_ROW_75_816 VGND VPWR sky130_fd_sc_hd__tapvpwrvgnd_1
XFILLER_0_39_133 VGND VGND VPWR VPWR sky130_fd_sc_hd__fill_2
XFILLER_0_39_166 VGND VGND VPWR VPWR sky130_fd_sc_hd__fill_2
XFILLER_0_39_177 VGND VGND VPWR VPWR sky130_fd_sc_hd__fill_1
XTAP_TAPCELL_ROW_30_429 VGND VPWR sky130_fd_sc_hd__tapvpwrvgnd_1
XFILLER_0_42_309 VGND VGND VPWR VPWR sky130_fd_sc_hd__fill_1
XFILLER_0_50_320 VGND VGND VPWR VPWR sky130_fd_sc_hd__decap_4
XFILLER_0_4_27 VGND VGND VPWR VPWR sky130_fd_sc_hd__fill_1
X_3110_ _0363_ _0364_ net101 _2026_ VGND VGND VPWR VPWR _0103_ sky130_fd_sc_hd__a2bb2o_1
X_4090_ _1277_ _1259_ _1310_ VGND VGND VPWR VPWR _1312_ sky130_fd_sc_hd__and3_1
X_3041_ _0292_ _0293_ VGND VGND VPWR VPWR _0297_ sky130_fd_sc_hd__and2b_1
XFILLER_0_77_239 VGND VGND VPWR VPWR sky130_fd_sc_hd__fill_1
XFILLER_0_18_306 VGND VGND VPWR VPWR sky130_fd_sc_hd__fill_2
X_3943_ u_interface.core_attn_out\[16\] _1166_ _1167_ VGND VGND VPWR VPWR _1168_ sky130_fd_sc_hd__and3_1
X_3874_ _1094_ _1099_ VGND VGND VPWR VPWR _1100_ sky130_fd_sc_hd__xnor2_1
XFILLER_0_73_467 VPWR VGND VPWR VGND sky130_ef_sc_hd__decap_12
X_2825_ _2219_ _2221_ VGND VGND VPWR VPWR _2222_ sky130_fd_sc_hd__nand2_1
XFILLER_0_5_233 VGND VGND VPWR VPWR sky130_fd_sc_hd__fill_2
XFILLER_0_60_106 VGND VGND VPWR VPWR sky130_fd_sc_hd__fill_2
XFILLER_0_30_60 VPWR VGND VPWR VGND sky130_ef_sc_hd__decap_12
X_2756_ _2157_ _2158_ VGND VGND VPWR VPWR _2159_ sky130_fd_sc_hd__or2_1
X_2687_ _2020_ _2097_ _2099_ _2100_ net153 VGND VGND VPWR VPWR _0079_ sky130_fd_sc_hd__a32o_1
X_4426_ _1591_ _1593_ VGND VGND VPWR VPWR _1641_ sky130_fd_sc_hd__nor2_1
XFILLER_0_1_461 VPWR VGND VPWR VGND sky130_ef_sc_hd__decap_12
XFILLER_0_41_386 VGND VGND VPWR VPWR sky130_fd_sc_hd__fill_1
XFILLER_0_69_3 VPWR VGND VPWR VGND sky130_ef_sc_hd__decap_12
X_4357_ _1512_ VGND VGND VPWR VPWR _1573_ sky130_fd_sc_hd__inv_2
X_4288_ _1504_ _1505_ VGND VGND VPWR VPWR _1506_ sky130_fd_sc_hd__nand2_1
X_3308_ _0507_ _0544_ _0545_ VGND VGND VPWR VPWR _0546_ sky130_fd_sc_hd__a21oi_1
X_3239_ _1968_ _0478_ _0479_ net62 VGND VGND VPWR VPWR _0117_ sky130_fd_sc_hd__o211a_1
XTAP_TAPCELL_ROW_1_187 VGND VPWR sky130_fd_sc_hd__tapvpwrvgnd_1
XTAP_TAPCELL_ROW_80_852 VGND VPWR sky130_fd_sc_hd__tapvpwrvgnd_1
XFILLER_0_76_261 VGND VGND VPWR VPWR sky130_fd_sc_hd__fill_1
XFILLER_0_76_250 VGND VGND VPWR VPWR sky130_fd_sc_hd__fill_2
XFILLER_0_64_412 VGND VGND VPWR VPWR sky130_fd_sc_hd__decap_4
XFILLER_0_24_309 VGND VGND VPWR VPWR sky130_fd_sc_hd__fill_1
XFILLER_0_36_169 VGND VGND VPWR VPWR sky130_fd_sc_hd__decap_8
XFILLER_0_32_331 VGND VGND VPWR VPWR sky130_fd_sc_hd__decap_4
XTAP_TAPCELL_ROW_9_254 VGND VPWR sky130_fd_sc_hd__tapvpwrvgnd_1
XTAP_TAPCELL_ROW_43_543 VGND VPWR sky130_fd_sc_hd__tapvpwrvgnd_1
XFILLER_0_55_401 VPWR VGND VPWR VGND sky130_ef_sc_hd__decap_12
XFILLER_0_67_261 VGND VGND VPWR VPWR sky130_fd_sc_hd__fill_2
XFILLER_0_27_125 VGND VGND VPWR VPWR sky130_fd_sc_hd__decap_8
XFILLER_0_51_48 VGND VGND VPWR VPWR sky130_fd_sc_hd__decap_8
XFILLER_0_27_158 VGND VGND VPWR VPWR sky130_fd_sc_hd__decap_8
XFILLER_0_27_169 VPWR VGND VPWR VGND sky130_ef_sc_hd__decap_12
XFILLER_0_55_478 VGND VGND VPWR VPWR sky130_fd_sc_hd__decap_6
X_3590_ _0813_ _0821_ VGND VGND VPWR VPWR _0822_ sky130_fd_sc_hd__xnor2_2
XFILLER_0_42_139 VGND VGND VPWR VPWR sky130_fd_sc_hd__fill_1
X_2610_ u_interface.u_compute_core.u_mac.product_reg\[10\] u_interface.u_compute_core.mac_accum\[10\]
+ VGND VGND VPWR VPWR _2034_ sky130_fd_sc_hd__or2_1
Xclkload13 clknet_4_14_0_clk VGND VGND VPWR VPWR clkload13/Y sky130_fd_sc_hd__clkinv_4
XFILLER_0_23_364 VGND VGND VPWR VPWR sky130_fd_sc_hd__fill_1
X_2541_ u_interface.u_compute_core.u_mac.product_reg\[1\] u_interface.u_compute_core.mac_accum\[1\]
+ VGND VGND VPWR VPWR _1974_ sky130_fd_sc_hd__nand2_1
X_2472_ _1909_ _1925_ VGND VGND VPWR VPWR _1926_ sky130_fd_sc_hd__and2_1
XFILLER_0_50_183 VPWR VGND VPWR VGND sky130_ef_sc_hd__decap_12
X_4211_ _1428_ _1429_ VGND VGND VPWR VPWR _1430_ sky130_fd_sc_hd__xnor2_1
X_4142_ u_interface.core_attn_out\[20\] _1362_ VGND VGND VPWR VPWR _1363_ sky130_fd_sc_hd__xor2_2
X_4073_ _0626_ _1151_ _1238_ _1237_ VGND VGND VPWR VPWR _1295_ sky130_fd_sc_hd__a31o_1
X_3024_ _0205_ _0280_ VGND VGND VPWR VPWR _0281_ sky130_fd_sc_hd__or2_1
XFILLER_0_46_401 VPWR VGND VPWR VGND sky130_ef_sc_hd__decap_12
XFILLER_0_58_250 VGND VGND VPWR VPWR sky130_fd_sc_hd__fill_2
XFILLER_0_58_294 VGND VGND VPWR VPWR sky130_fd_sc_hd__decap_3
X_3926_ u_interface.u_compute_core.relu_data\[19\] VGND VGND VPWR VPWR _1151_ sky130_fd_sc_hd__buf_2
XFILLER_0_46_445 VGND VGND VPWR VPWR sky130_fd_sc_hd__decap_8
Xclkload7 clknet_4_8_0_clk VGND VGND VPWR VPWR clkload7/Y sky130_fd_sc_hd__inv_8
XFILLER_0_41_81 VGND VGND VPWR VPWR sky130_fd_sc_hd__decap_8
X_3857_ _1065_ _1063_ VGND VGND VPWR VPWR _1083_ sky130_fd_sc_hd__or2b_1
XFILLER_0_73_297 VPWR VGND VPWR VGND sky130_ef_sc_hd__decap_12
XFILLER_0_14_331 VGND VGND VPWR VPWR sky130_fd_sc_hd__fill_1
X_2808_ _2201_ _2205_ VGND VGND VPWR VPWR _2206_ sky130_fd_sc_hd__xor2_1
X_3788_ _0945_ _0972_ VGND VGND VPWR VPWR _1016_ sky130_fd_sc_hd__nand2b_1
XFILLER_0_14_342 VGND VGND VPWR VPWR sky130_fd_sc_hd__fill_1
X_2739_ _2143_ _2142_ _2141_ _2129_ VGND VGND VPWR VPWR _2145_ sky130_fd_sc_hd__a211o_1
X_4409_ _1617_ _1623_ VGND VGND VPWR VPWR _1624_ sky130_fd_sc_hd__and2b_1
XTAP_TAPCELL_ROW_6_224 VGND VPWR sky130_fd_sc_hd__tapvpwrvgnd_1
XTAP_TAPCELL_ROW_57_657 VGND VPWR sky130_fd_sc_hd__tapvpwrvgnd_1
XTAP_TAPCELL_ROW_40_513 VGND VPWR sky130_fd_sc_hd__tapvpwrvgnd_1
XFILLER_0_64_253 VPWR VGND VPWR VGND sky130_ef_sc_hd__decap_12
XFILLER_0_24_117 VGND VGND VPWR VPWR sky130_fd_sc_hd__fill_1
XFILLER_0_24_139 VGND VGND VPWR VPWR sky130_fd_sc_hd__fill_1
XFILLER_0_32_183 VPWR VGND VPWR VGND sky130_ef_sc_hd__decap_12
XFILLER_0_46_15 VGND VGND VPWR VPWR sky130_fd_sc_hd__fill_1
XFILLER_0_1_39 VPWR VGND VPWR VGND sky130_ef_sc_hd__decap_12
XFILLER_0_47_209 VGND VGND VPWR VPWR sky130_fd_sc_hd__fill_2
X_4760_ clknet_4_10_0_clk _0125_ VGND VGND VPWR VPWR u_interface.core_attn_out\[8\]
+ sky130_fd_sc_hd__dfxtp_1
XFILLER_0_55_220 VGND VGND VPWR VPWR sky130_fd_sc_hd__decap_4
X_3711_ _0889_ _0759_ _0891_ _0939_ VGND VGND VPWR VPWR _0940_ sky130_fd_sc_hd__o211a_1
X_4691_ clknet_4_7_0_clk _0056_ VGND VGND VPWR VPWR u_interface.u_compute_core.scaled_data\[27\]
+ sky130_fd_sc_hd__dfxtp_1
X_3642_ _0808_ _0825_ _0872_ VGND VGND VPWR VPWR _0873_ sky130_fd_sc_hd__o21a_1
XTAP_TAPCELL_ROW_11_270 VGND VPWR sky130_fd_sc_hd__tapvpwrvgnd_1
XFILLER_0_23_150 VGND VGND VPWR VPWR sky130_fd_sc_hd__decap_4
XFILLER_0_70_278 VGND VGND VPWR VPWR sky130_fd_sc_hd__decap_8
X_3573_ _0459_ _0456_ _1856_ _1853_ VGND VGND VPWR VPWR _0805_ sky130_fd_sc_hd__and4_1
XPHY_EDGE_ROW_49_Right_49 VGND VGND VPWR VPWR sky130_fd_sc_hd__decap_3
X_2524_ _1961_ VGND VGND VPWR VPWR _0055_ sky130_fd_sc_hd__clkbuf_1
X_2455_ u_interface.u_compute_core.scaled_data\[5\] u_interface.u_compute_core.mac_accum\[8\]
+ _1900_ VGND VGND VPWR VPWR _1914_ sky130_fd_sc_hd__mux2_1
X_2386_ _1848_ _1864_ VGND VGND VPWR VPWR _0014_ sky130_fd_sc_hd__nor2_1
XTAP_TAPCELL_ROW_3_205 VGND VPWR sky130_fd_sc_hd__tapvpwrvgnd_1
X_4125_ _1345_ VGND VGND VPWR VPWR _1346_ sky130_fd_sc_hd__inv_2
XFILLER_0_36_81 VGND VGND VPWR VPWR sky130_fd_sc_hd__decap_3
X_4056_ u_interface.u_compute_core.relu_data\[15\] _0453_ VGND VGND VPWR VPWR _1278_
+ sky130_fd_sc_hd__nor2b_1
XPHY_EDGE_ROW_58_Right_58 VGND VGND VPWR VPWR sky130_fd_sc_hd__decap_3
X_3007_ net7 _2193_ _2226_ _2244_ VGND VGND VPWR VPWR _0264_ sky130_fd_sc_hd__and4_1
XTAP_TAPCELL_ROW_54_638 VGND VPWR sky130_fd_sc_hd__tapvpwrvgnd_1
X_3909_ _0689_ _1865_ VGND VGND VPWR VPWR _1134_ sky130_fd_sc_hd__nand2_1
XPHY_EDGE_ROW_67_Right_67 VGND VGND VPWR VPWR sky130_fd_sc_hd__decap_3
XPHY_EDGE_ROW_76_Right_76 VGND VGND VPWR VPWR sky130_fd_sc_hd__decap_3
XFILLER_0_16_29 VPWR VGND VPWR VGND sky130_ef_sc_hd__decap_12
XFILLER_0_16_18 VGND VGND VPWR VPWR sky130_fd_sc_hd__fill_1
XTAP_TAPCELL_ROW_17_318 VGND VPWR sky130_fd_sc_hd__tapvpwrvgnd_1
XFILLER_0_69_356 VGND VGND VPWR VPWR sky130_fd_sc_hd__fill_2
XFILLER_0_4_309 VPWR VGND VPWR VGND sky130_ef_sc_hd__decap_12
XFILLER_0_52_212 VGND VGND VPWR VPWR sky130_fd_sc_hd__fill_1
XFILLER_0_33_470 VPWR VGND VPWR VGND sky130_ef_sc_hd__decap_12
XFILLER_0_40_429 VGND VGND VPWR VPWR sky130_fd_sc_hd__fill_1
XFILLER_0_57_69 VPWR VGND VPWR VGND sky130_ef_sc_hd__decap_12
XFILLER_0_73_57 VPWR VGND VPWR VGND sky130_ef_sc_hd__decap_12
XFILLER_0_18_9 VGND VGND VPWR VPWR sky130_fd_sc_hd__fill_1
XFILLER_0_75_337 VGND VGND VPWR VPWR sky130_fd_sc_hd__decap_8
XTAP_TAPCELL_ROW_51_608 VGND VPWR sky130_fd_sc_hd__tapvpwrvgnd_1
X_4812_ clknet_4_12_0_clk _0177_ VGND VGND VPWR VPWR net48 sky130_fd_sc_hd__dfxtp_1
XFILLER_0_75_348 VGND VGND VPWR VPWR sky130_fd_sc_hd__decap_8
XFILLER_0_28_220 VGND VGND VPWR VPWR sky130_fd_sc_hd__fill_1
XFILLER_0_28_275 VGND VGND VPWR VPWR sky130_fd_sc_hd__decap_6
X_4743_ clknet_4_5_0_clk _0108_ VGND VGND VPWR VPWR u_interface.u_compute_core.mac_last
+ sky130_fd_sc_hd__dfxtp_1
XFILLER_0_7_169 VPWR VGND VPWR VGND sky130_ef_sc_hd__decap_12
XFILLER_0_28_286 VPWR VGND VPWR VGND sky130_ef_sc_hd__decap_12
X_4674_ clknet_4_4_0_clk _0039_ VGND VGND VPWR VPWR u_interface.u_compute_core.scaled_data\[10\]
+ sky130_fd_sc_hd__dfxtp_1
X_3625_ _0445_ _1841_ _1838_ _0449_ VGND VGND VPWR VPWR _0856_ sky130_fd_sc_hd__a22oi_1
X_3556_ _0722_ _0739_ _0788_ VGND VGND VPWR VPWR _0789_ sky130_fd_sc_hd__o21a_1
XFILLER_0_11_153 VPWR VGND VPWR VGND sky130_ef_sc_hd__decap_12
X_2507_ _1931_ _1949_ VGND VGND VPWR VPWR _1950_ sky130_fd_sc_hd__and2_1
X_3487_ _0717_ _0720_ VGND VGND VPWR VPWR _0721_ sky130_fd_sc_hd__xnor2_1
XFILLER_0_51_3 VPWR VGND VPWR VGND sky130_ef_sc_hd__decap_12
X_2438_ _1902_ VGND VGND VPWR VPWR _0028_ sky130_fd_sc_hd__clkbuf_1
X_2369_ net150 _1849_ _1851_ _1843_ VGND VGND VPWR VPWR _1852_ sky130_fd_sc_hd__o2bb2a_1
X_4108_ _0689_ u_interface.u_compute_core.relu_data\[19\] VGND VGND VPWR VPWR _1329_
+ sky130_fd_sc_hd__nand2_1
X_4039_ _1206_ _1205_ VGND VGND VPWR VPWR _1262_ sky130_fd_sc_hd__or2b_1
XFILLER_0_78_153 VGND VGND VPWR VPWR sky130_fd_sc_hd__decap_6
XFILLER_0_78_197 VGND VGND VPWR VPWR sky130_fd_sc_hd__decap_8
XFILLER_0_78_186 VGND VGND VPWR VPWR sky130_fd_sc_hd__fill_2
XFILLER_0_63_90 VGND VGND VPWR VPWR sky130_fd_sc_hd__decap_4
XTAP_TAPCELL_ROW_22_365 VGND VPWR sky130_fd_sc_hd__tapvpwrvgnd_1
XFILLER_0_34_223 VGND VGND VPWR VPWR sky130_fd_sc_hd__decap_4
XFILLER_0_34_256 VGND VGND VPWR VPWR sky130_fd_sc_hd__fill_1
XFILLER_0_30_462 VPWR VGND VPWR VGND sky130_ef_sc_hd__decap_12
XFILLER_0_69_120 VGND VGND VPWR VPWR sky130_fd_sc_hd__decap_3
XTAP_TAPCELL_ROW_73_799 VGND VPWR sky130_fd_sc_hd__tapvpwrvgnd_1
XFILLER_0_57_337 VGND VGND VPWR VPWR sky130_fd_sc_hd__fill_2
XFILLER_0_4_139 VGND VGND VPWR VPWR sky130_fd_sc_hd__fill_1
X_4390_ _1559_ _1560_ _1557_ VGND VGND VPWR VPWR _1606_ sky130_fd_sc_hd__o21a_1
X_3410_ _0597_ _0598_ _0645_ VGND VGND VPWR VPWR _0646_ sky130_fd_sc_hd__a21o_1
X_3341_ _0480_ _0577_ _0578_ net62 VGND VGND VPWR VPWR _0120_ sky130_fd_sc_hd__o211a_1
XFILLER_0_0_389 VGND VGND VPWR VPWR sky130_fd_sc_hd__decap_3
X_3272_ u_interface.u_compute_core.u_av.v_extended\[5\] VGND VGND VPWR VPWR _0511_
+ sky130_fd_sc_hd__buf_2
XFILLER_0_16_6 VGND VGND VPWR VPWR sky130_fd_sc_hd__decap_4
XTAP_TAPCELL_ROW_64_722 VGND VPWR sky130_fd_sc_hd__tapvpwrvgnd_1
XTAP_TAPCELL_ROW_36_479 VGND VPWR sky130_fd_sc_hd__tapvpwrvgnd_1
X_2987_ _0192_ _0193_ _0194_ VGND VGND VPWR VPWR _0245_ sky130_fd_sc_hd__o21ba_1
XFILLER_0_8_456 VGND VGND VPWR VPWR sky130_fd_sc_hd__fill_2
X_4726_ clknet_4_0_0_clk _0091_ VGND VGND VPWR VPWR u_interface.u_compute_core.u_mac.product_reg\[0\]
+ sky130_fd_sc_hd__dfxtp_1
XFILLER_0_71_373 VPWR VGND VPWR VGND sky130_ef_sc_hd__decap_12
X_4657_ clknet_4_7_0_clk _0022_ VGND VGND VPWR VPWR u_interface.u_compute_core.relu_data\[22\]
+ sky130_fd_sc_hd__dfxtp_1
X_3608_ _0835_ _0839_ VGND VGND VPWR VPWR _0840_ sky130_fd_sc_hd__nand2_1
XFILLER_0_3_161 VGND VGND VPWR VPWR sky130_fd_sc_hd__decap_6
X_4588_ _1779_ VGND VGND VPWR VPWR _0166_ sky130_fd_sc_hd__clkbuf_1
X_3539_ _0511_ _1835_ _1832_ _0680_ VGND VGND VPWR VPWR _0772_ sky130_fd_sc_hd__a22oi_1
XTAP_TAPCELL_ROW_27_402 VGND VPWR sky130_fd_sc_hd__tapvpwrvgnd_1
XFILLER_0_39_337 VPWR VGND VPWR VGND sky130_ef_sc_hd__decap_12
XFILLER_0_66_134 VGND VGND VPWR VPWR sky130_fd_sc_hd__fill_1
XTAP_TAPCELL_ROW_70_769 VGND VPWR sky130_fd_sc_hd__tapvpwrvgnd_1
XFILLER_0_81_137 VGND VGND VPWR VPWR sky130_fd_sc_hd__decap_3
XTAP_TAPCELL_ROW_78_836 VGND VPWR sky130_fd_sc_hd__tapvpwrvgnd_1
XFILLER_0_54_15 VPWR VGND VPWR VGND sky130_ef_sc_hd__decap_12
X_2910_ _2292_ _2304_ VGND VGND VPWR VPWR _2305_ sky130_fd_sc_hd__xnor2_1
X_3890_ _1086_ _1115_ VGND VGND VPWR VPWR _1116_ sky130_fd_sc_hd__xor2_1
XFILLER_0_45_318 VPWR VGND VPWR VGND sky130_ef_sc_hd__decap_12
XFILLER_0_57_167 VGND VGND VPWR VPWR sky130_fd_sc_hd__fill_1
XFILLER_0_70_69 VPWR VGND VPWR VGND sky130_ef_sc_hd__decap_12
X_2841_ _2236_ _2237_ VGND VGND VPWR VPWR _2238_ sky130_fd_sc_hd__xnor2_1
X_2772_ _2167_ _2170_ _2171_ VGND VGND VPWR VPWR _2172_ sky130_fd_sc_hd__nand3b_1
X_4511_ u_interface.core_attn_out\[29\] _1719_ VGND VGND VPWR VPWR _1723_ sky130_fd_sc_hd__xnor2_1
XFILLER_0_13_237 VPWR VGND VPWR VGND sky130_ef_sc_hd__decap_12
X_4442_ u_interface.core_attn_out\[24\] _1566_ _1612_ VGND VGND VPWR VPWR _1657_ sky130_fd_sc_hd__a21bo_1
X_4373_ _0432_ u_interface.u_compute_core.relu_data\[26\] VGND VGND VPWR VPWR _1589_
+ sky130_fd_sc_hd__nand2_1
XFILLER_0_0_153 VPWR VGND VPWR VGND sky130_ef_sc_hd__decap_12
X_3324_ _0556_ _0561_ VGND VGND VPWR VPWR _0562_ sky130_fd_sc_hd__xnor2_2
XFILLER_0_0_197 VGND VGND VPWR VPWR sky130_fd_sc_hd__fill_2
X_3255_ _0462_ _0494_ VGND VGND VPWR VPWR _0495_ sky130_fd_sc_hd__xnor2_1
XFILLER_0_28_60 VGND VGND VPWR VPWR sky130_fd_sc_hd__fill_1
X_3186_ _0421_ _0432_ VGND VGND VPWR VPWR _0433_ sky130_fd_sc_hd__or2_1
XTAP_TAPCELL_ROW_49_593 VGND VPWR sky130_fd_sc_hd__tapvpwrvgnd_1
XFILLER_0_76_421 VPWR VGND VPWR VGND sky130_ef_sc_hd__decap_12
XPHY_EDGE_ROW_14_Left_96 VGND VGND VPWR VPWR sky130_fd_sc_hd__decap_3
XFILLER_0_36_307 VGND VGND VPWR VPWR sky130_fd_sc_hd__fill_1
XFILLER_0_8_253 VGND VGND VPWR VPWR sky130_fd_sc_hd__decap_3
XFILLER_0_44_362 VGND VGND VPWR VPWR sky130_fd_sc_hd__fill_2
X_4709_ clknet_4_4_0_clk _0074_ VGND VGND VPWR VPWR u_interface.u_compute_core.mac_accum\[15\]
+ sky130_fd_sc_hd__dfxtp_1
XFILLER_0_71_192 VPWR VGND VPWR VGND sky130_ef_sc_hd__decap_12
XTAP_TAPCELL_ROW_75_817 VGND VPWR sky130_fd_sc_hd__tapvpwrvgnd_1
XFILLER_0_79_281 VGND VGND VPWR VPWR sky130_fd_sc_hd__decap_8
XFILLER_0_39_145 VPWR VGND VPWR VGND sky130_ef_sc_hd__decap_12
XFILLER_0_67_465 VPWR VGND VPWR VGND sky130_ef_sc_hd__decap_12
XFILLER_0_35_362 VGND VGND VPWR VPWR sky130_fd_sc_hd__fill_1
XFILLER_0_49_37 VGND VGND VPWR VPWR sky130_fd_sc_hd__decap_4
X_3040_ _0295_ _0296_ net110 _2006_ VGND VGND VPWR VPWR _0101_ sky130_fd_sc_hd__a2bb2o_1
XFILLER_0_65_69 VPWR VGND VPWR VGND sky130_ef_sc_hd__decap_12
XFILLER_0_58_410 VGND VGND VPWR VPWR sky130_fd_sc_hd__fill_1
XFILLER_0_81_57 VPWR VGND VPWR VGND sky130_ef_sc_hd__decap_12
XTAP_TAPCELL_ROW_46_563 VGND VPWR sky130_fd_sc_hd__tapvpwrvgnd_1
X_3942_ _1117_ _1120_ _1165_ VGND VGND VPWR VPWR _1167_ sky130_fd_sc_hd__a21o_1
X_3873_ _1097_ _1098_ VGND VGND VPWR VPWR _1099_ sky130_fd_sc_hd__xnor2_1
XFILLER_0_73_479 VGND VGND VPWR VPWR sky130_fd_sc_hd__decap_4
X_2824_ _2162_ _2220_ _2218_ VGND VGND VPWR VPWR _2221_ sky130_fd_sc_hd__a21o_1
XFILLER_0_5_223 VGND VGND VPWR VPWR sky130_fd_sc_hd__fill_1
XFILLER_0_30_72 VGND VGND VPWR VPWR sky130_fd_sc_hd__fill_1
XFILLER_0_30_83 VGND VGND VPWR VPWR sky130_fd_sc_hd__fill_1
X_2755_ _2068_ u_interface.u_compute_core.mac_accum\[31\] VGND VGND VPWR VPWR _2158_
+ sky130_fd_sc_hd__xnor2_1
X_2686_ _1979_ VGND VGND VPWR VPWR _2100_ sky130_fd_sc_hd__clkbuf_4
XFILLER_0_41_354 VPWR VGND VPWR VGND sky130_ef_sc_hd__decap_12
X_4425_ _1591_ _1593_ VGND VGND VPWR VPWR _1640_ sky130_fd_sc_hd__nand2_1
XFILLER_0_1_473 VGND VGND VPWR VPWR sky130_fd_sc_hd__decap_8
X_4356_ u_interface.core_attn_out\[24\] _1566_ _1568_ VGND VGND VPWR VPWR _1572_ sky130_fd_sc_hd__a21o_1
X_3307_ u_interface.u_compute_core.u_av.v_extended\[1\] u_interface.u_compute_core.u_av.v_extended\[0\]
+ u_interface.u_compute_core.relu_data\[6\] u_interface.u_compute_core.relu_data\[5\]
+ VGND VGND VPWR VPWR _0545_ sky130_fd_sc_hd__and4_1
XFILLER_0_39_92 VGND VGND VPWR VPWR sky130_fd_sc_hd__fill_1
X_4287_ _1503_ _1475_ VGND VGND VPWR VPWR _1505_ sky130_fd_sc_hd__or2b_1
X_3238_ _0421_ _0477_ net131 VGND VGND VPWR VPWR _0479_ sky130_fd_sc_hd__a21o_1
X_3169_ _1901_ _1969_ net27 VGND VGND VPWR VPWR _0419_ sky130_fd_sc_hd__and3_1
XTAP_TAPCELL_ROW_1_188 VGND VPWR sky130_fd_sc_hd__tapvpwrvgnd_1
XTAP_TAPCELL_ROW_80_853 VGND VPWR sky130_fd_sc_hd__tapvpwrvgnd_1
XFILLER_0_76_273 VPWR VGND VPWR VGND sky130_ef_sc_hd__decap_12
XFILLER_0_64_457 VPWR VGND VPWR VGND sky130_ef_sc_hd__decap_12
XTAP_TAPCELL_ROW_9_255 VGND VPWR sky130_fd_sc_hd__tapvpwrvgnd_1
XFILLER_0_3_3 VPWR VGND VPWR VGND sky130_ef_sc_hd__decap_12
XTAP_TAPCELL_ROW_43_544 VGND VPWR sky130_fd_sc_hd__tapvpwrvgnd_1
XFILLER_0_55_413 VPWR VGND VPWR VGND sky130_ef_sc_hd__decap_12
XFILLER_0_55_457 VGND VGND VPWR VPWR sky130_fd_sc_hd__decap_3
XFILLER_0_70_416 VGND VGND VPWR VPWR sky130_fd_sc_hd__decap_4
Xclkload14 clknet_4_15_0_clk VGND VGND VPWR VPWR clkload14/Y sky130_fd_sc_hd__inv_6
X_2540_ _1972_ VGND VGND VPWR VPWR _1973_ sky130_fd_sc_hd__clkbuf_4
XFILLER_0_23_387 VGND VGND VPWR VPWR sky130_fd_sc_hd__fill_2
X_2471_ u_interface.u_compute_core.scaled_data\[10\] u_interface.u_compute_core.mac_accum\[13\]
+ _1922_ VGND VGND VPWR VPWR _1925_ sky130_fd_sc_hd__mux2_1
XFILLER_0_50_195 VGND VGND VPWR VPWR sky130_fd_sc_hd__fill_1
X_4210_ _0443_ _1246_ VGND VGND VPWR VPWR _1429_ sky130_fd_sc_hd__nand2_1
X_4141_ _1359_ _1361_ VGND VGND VPWR VPWR _1362_ sky130_fd_sc_hd__xnor2_2
X_4072_ _1291_ _1293_ VGND VGND VPWR VPWR _1294_ sky130_fd_sc_hd__xnor2_1
X_3023_ _0234_ _0237_ _0235_ VGND VGND VPWR VPWR _0280_ sky130_fd_sc_hd__o21ba_1
X_3925_ _0431_ _1868_ _1097_ _1096_ VGND VGND VPWR VPWR _1150_ sky130_fd_sc_hd__a31o_1
Xclkload8 clknet_4_9_0_clk VGND VGND VPWR VPWR clkload8/Y sky130_fd_sc_hd__inv_6
X_3856_ _1071_ _1081_ _1069_ VGND VGND VPWR VPWR _1082_ sky130_fd_sc_hd__a21oi_1
XFILLER_0_81_3 VPWR VGND VPWR VGND sky130_ef_sc_hd__decap_12
X_2807_ _2203_ _2204_ VGND VGND VPWR VPWR _2205_ sky130_fd_sc_hd__nand2_1
X_3787_ _0971_ _0969_ VGND VGND VPWR VPWR _1015_ sky130_fd_sc_hd__or2b_1
XFILLER_0_14_365 VGND VGND VPWR VPWR sky130_fd_sc_hd__decap_4
X_2738_ _2129_ _2141_ _2142_ _2143_ VGND VGND VPWR VPWR _2144_ sky130_fd_sc_hd__o211ai_2
X_4408_ _1621_ _1622_ VGND VGND VPWR VPWR _1623_ sky130_fd_sc_hd__xnor2_1
X_2669_ _2064_ u_interface.u_compute_core.mac_accum\[18\] VGND VGND VPWR VPWR _2085_
+ sky130_fd_sc_hd__or2_1
XTAP_TAPCELL_ROW_6_225 VGND VPWR sky130_fd_sc_hd__tapvpwrvgnd_1
XFILLER_0_1_281 VPWR VGND VPWR VGND sky130_ef_sc_hd__decap_12
X_4339_ _1547_ _1555_ VGND VGND VPWR VPWR _1556_ sky130_fd_sc_hd__xor2_1
XTAP_TAPCELL_ROW_57_658 VGND VPWR sky130_fd_sc_hd__tapvpwrvgnd_1
XTAP_TAPCELL_ROW_40_514 VGND VPWR sky130_fd_sc_hd__tapvpwrvgnd_1
XFILLER_0_52_405 VGND VGND VPWR VPWR sky130_fd_sc_hd__fill_2
XFILLER_0_64_265 VGND VGND VPWR VPWR sky130_fd_sc_hd__decap_3
XFILLER_0_17_181 VGND VGND VPWR VPWR sky130_fd_sc_hd__decap_4
XFILLER_0_32_195 VGND VGND VPWR VPWR sky130_fd_sc_hd__fill_1
XFILLER_0_62_15 VPWR VGND VPWR VGND sky130_ef_sc_hd__decap_12
X_3710_ _0885_ _0933_ _0932_ VGND VGND VPWR VPWR _0939_ sky130_fd_sc_hd__a21o_1
XFILLER_0_55_232 VGND VGND VPWR VPWR sky130_fd_sc_hd__fill_1
XFILLER_0_55_243 VGND VGND VPWR VPWR sky130_fd_sc_hd__fill_2
X_4690_ clknet_4_5_0_clk _0055_ VGND VGND VPWR VPWR u_interface.u_compute_core.scaled_data\[26\]
+ sky130_fd_sc_hd__dfxtp_1
XFILLER_0_15_107 VGND VGND VPWR VPWR sky130_fd_sc_hd__decap_4
XFILLER_0_11_41 VPWR VGND VPWR VGND sky130_ef_sc_hd__decap_12
X_3641_ _0822_ _0824_ VGND VGND VPWR VPWR _0872_ sky130_fd_sc_hd__or2_1
XFILLER_0_43_449 VGND VGND VPWR VPWR sky130_fd_sc_hd__decap_6
XTAP_TAPCELL_ROW_11_271 VGND VPWR sky130_fd_sc_hd__tapvpwrvgnd_1
X_3572_ _0457_ _1856_ _1853_ _0460_ VGND VGND VPWR VPWR _0804_ sky130_fd_sc_hd__a22oi_1
XFILLER_0_23_162 VGND VGND VPWR VPWR sky130_fd_sc_hd__decap_6
X_2523_ _1953_ _1960_ VGND VGND VPWR VPWR _1961_ sky130_fd_sc_hd__and2_1
X_2454_ _1913_ VGND VGND VPWR VPWR _0033_ sky130_fd_sc_hd__clkbuf_1
X_2385_ u_interface.u_compute_core.scaled_data\[14\] _1849_ _1863_ _1843_ VGND VGND
+ VPWR VPWR _1864_ sky130_fd_sc_hd__o2bb2a_1
X_4124_ _0460_ _0457_ u_interface.u_compute_core.relu_data\[23\] u_interface.u_compute_core.relu_data\[22\]
+ VGND VGND VPWR VPWR _1345_ sky130_fd_sc_hd__and4_1
Xinput1 m_tready VGND VGND VPWR VPWR net1 sky130_fd_sc_hd__clkbuf_1
XFILLER_0_36_60 VGND VGND VPWR VPWR sky130_fd_sc_hd__fill_1
X_4055_ _1256_ _1254_ VGND VGND VPWR VPWR _1277_ sky130_fd_sc_hd__or2b_1
X_3006_ _2220_ _2226_ _2244_ _2193_ VGND VGND VPWR VPWR _0263_ sky130_fd_sc_hd__a22oi_1
XFILLER_0_36_93 VPWR VGND VPWR VGND sky130_ef_sc_hd__decap_12
XTAP_TAPCELL_ROW_54_639 VGND VPWR sky130_fd_sc_hd__tapvpwrvgnd_1
XFILLER_0_52_70 VGND VGND VPWR VPWR sky130_fd_sc_hd__decap_8
X_3908_ _1131_ _1132_ VGND VGND VPWR VPWR _1133_ sky130_fd_sc_hd__xnor2_1
X_3839_ _1063_ _1065_ VGND VGND VPWR VPWR _1066_ sky130_fd_sc_hd__xnor2_2
XFILLER_0_61_246 VGND VGND VPWR VPWR sky130_fd_sc_hd__decap_4
XFILLER_0_42_482 VGND VGND VPWR VPWR sky130_fd_sc_hd__fill_2
XTAP_TAPCELL_ROW_17_319 VGND VPWR sky130_fd_sc_hd__tapvpwrvgnd_1
XTAP_TAPCELL_ROW_25_385 VGND VPWR sky130_fd_sc_hd__tapvpwrvgnd_1
XPHY_EDGE_ROW_2_Left_84 VGND VGND VPWR VPWR sky130_fd_sc_hd__decap_3
XFILLER_0_33_482 VGND VGND VPWR VPWR sky130_fd_sc_hd__fill_2
XFILLER_0_40_419 VGND VGND VPWR VPWR sky130_fd_sc_hd__fill_1
XFILLER_0_52_279 VGND VGND VPWR VPWR sky130_fd_sc_hd__decap_3
XFILLER_0_73_69 VGND VGND VPWR VPWR sky130_fd_sc_hd__decap_8
X_4811_ clknet_4_12_0_clk _0176_ VGND VGND VPWR VPWR net47 sky130_fd_sc_hd__dfxtp_1
XTAP_TAPCELL_ROW_51_609 VGND VPWR sky130_fd_sc_hd__tapvpwrvgnd_1
X_4742_ clknet_4_8_0_clk _0107_ VGND VGND VPWR VPWR u_interface.u_compute_core.relu_valid
+ sky130_fd_sc_hd__dfxtp_1
XFILLER_0_28_298 VGND VGND VPWR VPWR sky130_fd_sc_hd__decap_8
X_4673_ clknet_4_1_0_clk _0038_ VGND VGND VPWR VPWR u_interface.u_compute_core.scaled_data\[9\]
+ sky130_fd_sc_hd__dfxtp_1
X_3624_ _0551_ _0634_ u_interface.u_compute_core.relu_data\[8\] u_interface.u_compute_core.relu_data\[7\]
+ VGND VGND VPWR VPWR _0855_ sky130_fd_sc_hd__and4_1
XFILLER_0_11_132 VGND VGND VPWR VPWR sky130_fd_sc_hd__decap_8
X_3555_ _0736_ _0738_ VGND VGND VPWR VPWR _0788_ sky130_fd_sc_hd__or2_1
XFILLER_0_11_165 VGND VGND VPWR VPWR sky130_fd_sc_hd__decap_3
X_3486_ _0718_ _0719_ VGND VGND VPWR VPWR _0720_ sky130_fd_sc_hd__or2_1
X_2506_ u_interface.u_compute_core.scaled_data\[21\] u_interface.u_compute_core.mac_accum\[24\]
+ _1944_ VGND VGND VPWR VPWR _1949_ sky130_fd_sc_hd__mux2_1
X_2437_ _1900_ _1901_ VGND VGND VPWR VPWR _1902_ sky130_fd_sc_hd__and2_1
X_2368_ _1850_ VGND VGND VPWR VPWR _1851_ sky130_fd_sc_hd__inv_2
X_4107_ _1326_ _1327_ VGND VGND VPWR VPWR _1328_ sky130_fd_sc_hd__xnor2_1
XTAP_TAPCELL_ROW_67_742 VGND VPWR sky130_fd_sc_hd__tapvpwrvgnd_1
X_4038_ _1259_ _1260_ VGND VGND VPWR VPWR _1261_ sky130_fd_sc_hd__nand2_1
XFILLER_0_78_121 VPWR VGND VPWR VGND sky130_ef_sc_hd__decap_12
XFILLER_0_2_83 VGND VGND VPWR VPWR sky130_fd_sc_hd__fill_1
XFILLER_0_66_305 VGND VGND VPWR VPWR sky130_fd_sc_hd__decap_3
XFILLER_0_66_349 VGND VGND VPWR VPWR sky130_fd_sc_hd__decap_8
XFILLER_0_74_371 VGND VGND VPWR VPWR sky130_fd_sc_hd__fill_1
XTAP_TAPCELL_ROW_22_366 VGND VPWR sky130_fd_sc_hd__tapvpwrvgnd_1
XFILLER_0_22_419 VGND VGND VPWR VPWR sky130_fd_sc_hd__fill_1
XFILLER_0_30_474 VGND VGND VPWR VPWR sky130_fd_sc_hd__fill_2
Xmax_cap63 _2095_ VGND VGND VPWR VPWR net63 sky130_fd_sc_hd__clkbuf_1
XFILLER_0_65_371 VGND VGND VPWR VPWR sky130_fd_sc_hd__decap_4
X_3340_ u_interface.core_attn_out\[3\] _0435_ VGND VGND VPWR VPWR _0578_ sky130_fd_sc_hd__or2_1
X_3271_ _0493_ _0509_ VGND VGND VPWR VPWR _0510_ sky130_fd_sc_hd__xnor2_1
XTAP_TAPCELL_ROW_64_723 VGND VPWR sky130_fd_sc_hd__tapvpwrvgnd_1
XFILLER_0_75_113 VPWR VGND VPWR VGND sky130_ef_sc_hd__decap_12
XFILLER_0_75_157 VGND VGND VPWR VPWR sky130_fd_sc_hd__fill_1
X_2986_ _0224_ _0197_ _0242_ VGND VGND VPWR VPWR _0244_ sky130_fd_sc_hd__nand3_1
XFILLER_0_56_371 VGND VGND VPWR VPWR sky130_fd_sc_hd__decap_8
X_4725_ clknet_4_5_0_clk _0090_ VGND VGND VPWR VPWR u_interface.u_compute_core.mac_accum\[31\]
+ sky130_fd_sc_hd__dfxtp_1
XFILLER_0_71_385 VGND VGND VPWR VPWR sky130_fd_sc_hd__fill_1
X_4656_ clknet_4_7_0_clk _0021_ VGND VGND VPWR VPWR u_interface.u_compute_core.relu_data\[21\]
+ sky130_fd_sc_hd__dfxtp_1
X_3607_ _0749_ _0834_ _0838_ VGND VGND VPWR VPWR _0839_ sky130_fd_sc_hd__a21oi_2
X_4587_ _1775_ _1778_ VGND VGND VPWR VPWR _1779_ sky130_fd_sc_hd__and2_1
X_3538_ _0449_ _0634_ _1835_ _1832_ VGND VGND VPWR VPWR _0771_ sky130_fd_sc_hd__and4_1
XFILLER_0_12_474 VGND VGND VPWR VPWR sky130_fd_sc_hd__fill_2
X_3469_ _0701_ _0703_ VGND VGND VPWR VPWR _0704_ sky130_fd_sc_hd__and2b_1
XTAP_TAPCELL_ROW_27_403 VGND VPWR sky130_fd_sc_hd__tapvpwrvgnd_1
XFILLER_0_39_349 VPWR VGND VPWR VGND sky130_ef_sc_hd__decap_12
XFILLER_0_54_319 VGND VGND VPWR VPWR sky130_fd_sc_hd__decap_3
XFILLER_0_66_157 VGND VGND VPWR VPWR sky130_fd_sc_hd__fill_1
XFILLER_0_47_360 VGND VGND VPWR VPWR sky130_fd_sc_hd__decap_4
XTAP_TAPCELL_ROW_78_837 VGND VPWR sky130_fd_sc_hd__tapvpwrvgnd_1
XFILLER_0_54_27 VGND VGND VPWR VPWR sky130_fd_sc_hd__fill_1
XFILLER_0_57_113 VGND VGND VPWR VPWR sky130_fd_sc_hd__fill_2
XFILLER_0_70_15 VPWR VGND VPWR VGND sky130_ef_sc_hd__decap_12
X_2840_ _2181_ _2196_ _2199_ VGND VGND VPWR VPWR _2237_ sky130_fd_sc_hd__o21a_1
XFILLER_0_57_146 VGND VGND VPWR VPWR sky130_fd_sc_hd__fill_1
XFILLER_0_5_416 VPWR VGND VPWR VGND sky130_ef_sc_hd__decap_12
XFILLER_0_5_405 VGND VGND VPWR VPWR sky130_fd_sc_hd__decap_6
X_2771_ _2161_ _2169_ _2166_ VGND VGND VPWR VPWR _2171_ sky130_fd_sc_hd__nand3_1
X_4510_ _0938_ _1721_ _1722_ _0420_ VGND VGND VPWR VPWR _0145_ sky130_fd_sc_hd__o211a_1
XFILLER_0_13_216 VGND VGND VPWR VPWR sky130_fd_sc_hd__fill_1
XFILLER_0_5_449 VGND VGND VPWR VPWR sky130_fd_sc_hd__decap_6
XFILLER_0_79_57 VPWR VGND VPWR VGND sky130_ef_sc_hd__decap_12
X_4441_ u_interface.core_attn_out\[26\] _1655_ VGND VGND VPWR VPWR _1656_ sky130_fd_sc_hd__xnor2_1
XFILLER_0_13_249 VGND VGND VPWR VPWR sky130_fd_sc_hd__decap_4
XPHY_EDGE_ROW_9_Right_9 VGND VGND VPWR VPWR sky130_fd_sc_hd__decap_3
X_4372_ _1586_ _1587_ VGND VGND VPWR VPWR _1588_ sky130_fd_sc_hd__nor2_1
X_3323_ _0559_ _0560_ VGND VGND VPWR VPWR _0561_ sky130_fd_sc_hd__nand2b_1
XFILLER_0_0_165 VGND VGND VPWR VPWR sky130_fd_sc_hd__decap_3
X_3254_ _0491_ _0492_ _0493_ VGND VGND VPWR VPWR _0494_ sky130_fd_sc_hd__a21oi_1
X_3185_ _0431_ VGND VGND VPWR VPWR _0432_ sky130_fd_sc_hd__clkbuf_4
XFILLER_0_48_102 VPWR VGND VPWR VGND sky130_ef_sc_hd__decap_12
XTAP_TAPCELL_ROW_49_594 VGND VPWR sky130_fd_sc_hd__tapvpwrvgnd_1
XFILLER_0_76_433 VGND VGND VPWR VPWR sky130_fd_sc_hd__fill_2
XFILLER_0_76_477 VGND VGND VPWR VPWR sky130_fd_sc_hd__decap_6
XFILLER_0_8_232 VPWR VGND VPWR VGND sky130_ef_sc_hd__decap_12
XTAP_TAPCELL_ROW_32_450 VGND VPWR sky130_fd_sc_hd__tapvpwrvgnd_1
XFILLER_0_36_319 VPWR VGND VPWR VGND sky130_ef_sc_hd__decap_12
X_2969_ _2169_ _2275_ VGND VGND VPWR VPWR _0227_ sky130_fd_sc_hd__or2_1
XFILLER_0_44_330 VGND VGND VPWR VPWR sky130_fd_sc_hd__decap_8
X_4708_ clknet_4_4_0_clk _0073_ VGND VGND VPWR VPWR u_interface.u_compute_core.mac_accum\[14\]
+ sky130_fd_sc_hd__dfxtp_1
X_4639_ clknet_4_2_0_clk _0004_ VGND VGND VPWR VPWR u_interface.u_compute_core.relu_data\[4\]
+ sky130_fd_sc_hd__dfxtp_1
XFILLER_0_39_113 VPWR VGND VPWR VGND sky130_ef_sc_hd__decap_12
XFILLER_0_67_433 VGND VGND VPWR VPWR sky130_fd_sc_hd__decap_6
XFILLER_0_67_477 VGND VGND VPWR VPWR sky130_fd_sc_hd__decap_3
XFILLER_0_54_116 VGND VGND VPWR VPWR sky130_fd_sc_hd__fill_1
XFILLER_0_2_419 VGND VGND VPWR VPWR sky130_fd_sc_hd__fill_1
XFILLER_0_62_171 VGND VGND VPWR VPWR sky130_fd_sc_hd__fill_1
XFILLER_0_4_29 VPWR VGND VPWR VGND sky130_ef_sc_hd__decap_12
XFILLER_0_65_15 VPWR VGND VPWR VGND sky130_ef_sc_hd__decap_12
XFILLER_0_81_69 VPWR VGND VPWR VGND sky130_ef_sc_hd__decap_12
XTAP_TAPCELL_ROW_46_564 VGND VPWR sky130_fd_sc_hd__tapvpwrvgnd_1
XFILLER_0_14_63 VGND VGND VPWR VPWR sky130_fd_sc_hd__decap_6
X_3941_ _1117_ _1120_ _1165_ VGND VGND VPWR VPWR _1166_ sky130_fd_sc_hd__nand3_1
XFILLER_0_58_477 VGND VGND VPWR VPWR sky130_fd_sc_hd__decap_6
X_3872_ _0626_ _1868_ VGND VGND VPWR VPWR _1098_ sky130_fd_sc_hd__nand2_1
X_2823_ net7 VGND VGND VPWR VPWR _2220_ sky130_fd_sc_hd__buf_2
XFILLER_0_38_190 VGND VGND VPWR VPWR sky130_fd_sc_hd__decap_6
XFILLER_0_45_138 VGND VGND VPWR VPWR sky130_fd_sc_hd__fill_2
XFILLER_0_26_363 VGND VGND VPWR VPWR sky130_fd_sc_hd__fill_1
X_2754_ _2153_ _2154_ _2151_ VGND VGND VPWR VPWR _2157_ sky130_fd_sc_hd__o21a_1
XFILLER_0_41_366 VGND VGND VPWR VPWR sky130_fd_sc_hd__decap_4
X_2685_ _2098_ VGND VGND VPWR VPWR _2099_ sky130_fd_sc_hd__inv_2
X_4424_ _1637_ _1638_ VGND VGND VPWR VPWR _1639_ sky130_fd_sc_hd__nand2_1
XFILLER_0_1_441 VGND VGND VPWR VPWR sky130_fd_sc_hd__decap_6
X_4355_ _0938_ _1570_ _1571_ _0420_ VGND VGND VPWR VPWR _0141_ sky130_fd_sc_hd__o211a_1
X_3306_ _0456_ _1835_ VGND VGND VPWR VPWR _0544_ sky130_fd_sc_hd__nand2_1
XFILLER_0_39_71 VGND VGND VPWR VPWR sky130_fd_sc_hd__decap_8
X_4286_ _1475_ _1503_ VGND VGND VPWR VPWR _1504_ sky130_fd_sc_hd__or2b_1
X_3237_ u_interface.core_attn_out\[0\] _0477_ VGND VGND VPWR VPWR _0478_ sky130_fd_sc_hd__nand2_1
X_3168_ _0418_ VGND VGND VPWR VPWR _0107_ sky130_fd_sc_hd__clkbuf_1
X_3099_ _0312_ _0319_ _0352_ VGND VGND VPWR VPWR _0354_ sky130_fd_sc_hd__nor3_1
XFILLER_0_76_230 VPWR VGND VPWR VGND sky130_ef_sc_hd__decap_12
XTAP_TAPCELL_ROW_80_854 VGND VPWR sky130_fd_sc_hd__tapvpwrvgnd_1
XFILLER_0_76_285 VGND VGND VPWR VPWR sky130_fd_sc_hd__fill_1
XFILLER_0_64_469 VGND VGND VPWR VPWR sky130_fd_sc_hd__decap_6
XTAP_TAPCELL_ROW_9_256 VGND VPWR sky130_fd_sc_hd__tapvpwrvgnd_1
XFILLER_0_59_208 VGND VGND VPWR VPWR sky130_fd_sc_hd__decap_3
XTAP_TAPCELL_ROW_43_545 VGND VPWR sky130_fd_sc_hd__tapvpwrvgnd_1
XFILLER_0_55_447 VGND VGND VPWR VPWR sky130_fd_sc_hd__fill_1
X_2470_ _1924_ VGND VGND VPWR VPWR _0038_ sky130_fd_sc_hd__clkbuf_1
X_4140_ _1360_ _1314_ VGND VGND VPWR VPWR _1361_ sky130_fd_sc_hd__nand2_1
X_4071_ _1235_ _1240_ _1292_ VGND VGND VPWR VPWR _1293_ sky130_fd_sc_hd__a21boi_1
X_3022_ _0231_ _0240_ _0277_ VGND VGND VPWR VPWR _0279_ sky130_fd_sc_hd__nand3_1
XFILLER_0_25_62 VGND VGND VPWR VPWR sky130_fd_sc_hd__fill_1
XFILLER_0_25_84 VGND VGND VPWR VPWR sky130_fd_sc_hd__decap_3
X_3924_ _1147_ _1148_ VGND VGND VPWR VPWR _1149_ sky130_fd_sc_hd__nor2b_1
XFILLER_0_73_244 VGND VGND VPWR VPWR sky130_fd_sc_hd__decap_4
XFILLER_0_46_436 VGND VGND VPWR VPWR sky130_fd_sc_hd__fill_1
Xclkload9 clknet_4_10_0_clk VGND VGND VPWR VPWR clkload9/Y sky130_fd_sc_hd__clkinvlp_2
XTAP_TAPCELL_ROW_14_291 VGND VPWR sky130_fd_sc_hd__tapvpwrvgnd_1
X_3855_ _1068_ VGND VGND VPWR VPWR _1081_ sky130_fd_sc_hd__inv_2
X_2806_ _2164_ _2178_ _2202_ net10 VGND VGND VPWR VPWR _2204_ sky130_fd_sc_hd__a22o_1
X_3786_ _0986_ _1013_ VGND VGND VPWR VPWR _1014_ sky130_fd_sc_hd__xnor2_1
X_2737_ _2067_ u_interface.u_compute_core.mac_accum\[28\] VGND VGND VPWR VPWR _2143_
+ sky130_fd_sc_hd__or2_1
XFILLER_0_74_3 VPWR VGND VPWR VGND sky130_ef_sc_hd__decap_12
XFILLER_0_41_152 VGND VGND VPWR VPWR sky130_fd_sc_hd__fill_2
X_2668_ u_interface.u_compute_core.mac_accum\[17\] u_interface.u_compute_core.mac_accum\[16\]
+ _2068_ VGND VGND VPWR VPWR _2084_ sky130_fd_sc_hd__o21ai_1
X_4407_ _0443_ _1893_ VGND VGND VPWR VPWR _1622_ sky130_fd_sc_hd__nand2_1
XFILLER_0_1_293 VPWR VGND VPWR VGND sky130_ef_sc_hd__decap_12
X_2599_ _2021_ _2022_ _2023_ VGND VGND VPWR VPWR _2025_ sky130_fd_sc_hd__a21o_1
X_4338_ _1553_ _1554_ VGND VGND VPWR VPWR _1555_ sky130_fd_sc_hd__or2b_1
XTAP_TAPCELL_ROW_6_226 VGND VPWR sky130_fd_sc_hd__tapvpwrvgnd_1
X_4269_ _1483_ _1484_ _1485_ VGND VGND VPWR VPWR _1487_ sky130_fd_sc_hd__nor3_1
XTAP_TAPCELL_ROW_57_659 VGND VPWR sky130_fd_sc_hd__tapvpwrvgnd_1
XTAP_TAPCELL_ROW_40_515 VGND VPWR sky130_fd_sc_hd__tapvpwrvgnd_1
XFILLER_0_9_393 VPWR VGND VPWR VGND sky130_ef_sc_hd__decap_12
XFILLER_0_9_371 VGND VGND VPWR VPWR sky130_fd_sc_hd__decap_8
XFILLER_0_24_108 VGND VGND VPWR VPWR sky130_fd_sc_hd__fill_2
XFILLER_0_32_141 VGND VGND VPWR VPWR sky130_fd_sc_hd__decap_3
XFILLER_0_32_174 VGND VGND VPWR VPWR sky130_fd_sc_hd__fill_1
XFILLER_0_20_347 VGND VGND VPWR VPWR sky130_fd_sc_hd__decap_4
XFILLER_0_62_27 VGND VGND VPWR VPWR sky130_fd_sc_hd__fill_1
XFILLER_0_62_49 VGND VGND VPWR VPWR sky130_fd_sc_hd__decap_3
XFILLER_0_28_403 VPWR VGND VPWR VGND sky130_ef_sc_hd__decap_12
XFILLER_0_55_255 VGND VGND VPWR VPWR sky130_fd_sc_hd__decap_4
XFILLER_0_55_266 VGND VGND VPWR VPWR sky130_fd_sc_hd__decap_4
X_3640_ _0870_ _0853_ VGND VGND VPWR VPWR _0871_ sky130_fd_sc_hd__xor2_1
XFILLER_0_55_288 VPWR VGND VPWR VGND sky130_ef_sc_hd__decap_12
XTAP_TAPCELL_ROW_11_272 VGND VPWR sky130_fd_sc_hd__tapvpwrvgnd_1
XFILLER_0_11_53 VGND VGND VPWR VPWR sky130_fd_sc_hd__decap_3
X_3571_ _0626_ _1845_ _0773_ _0771_ VGND VGND VPWR VPWR _0803_ sky130_fd_sc_hd__a31o_1
XFILLER_0_11_86 VPWR VGND VPWR VGND sky130_ef_sc_hd__decap_12
XFILLER_0_51_483 VGND VGND VPWR VPWR sky130_fd_sc_hd__fill_1
X_2522_ u_interface.u_compute_core.scaled_data\[26\] u_interface.u_compute_core.mac_accum\[29\]
+ _1944_ VGND VGND VPWR VPWR _1960_ sky130_fd_sc_hd__mux2_1
XFILLER_0_11_369 VGND VGND VPWR VPWR sky130_fd_sc_hd__decap_3
X_2453_ _1909_ _1912_ VGND VGND VPWR VPWR _1913_ sky130_fd_sc_hd__and2_1
X_2384_ _1862_ VGND VGND VPWR VPWR _1863_ sky130_fd_sc_hd__inv_2
X_4123_ _0423_ u_interface.u_compute_core.relu_data\[23\] _1884_ _0427_ VGND VGND
+ VPWR VPWR _1344_ sky130_fd_sc_hd__a22o_1
Xinput2 rst VGND VGND VPWR VPWR net2 sky130_fd_sc_hd__clkbuf_2
X_4054_ _1261_ _1263_ _1267_ VGND VGND VPWR VPWR _1276_ sky130_fd_sc_hd__o21ba_1
X_3005_ _0261_ _0262_ net120 _2006_ VGND VGND VPWR VPWR _0100_ sky130_fd_sc_hd__a2bb2o_1
XFILLER_0_46_200 VGND VGND VPWR VPWR sky130_fd_sc_hd__decap_4
XFILLER_0_46_222 VGND VGND VPWR VPWR sky130_fd_sc_hd__decap_8
X_3907_ _0484_ u_interface.u_compute_core.relu_data\[16\] VGND VGND VPWR VPWR _1132_
+ sky130_fd_sc_hd__nand2_1
X_3838_ _0992_ _1009_ _1064_ VGND VGND VPWR VPWR _1065_ sky130_fd_sc_hd__o21a_1
XFILLER_0_61_225 VGND VGND VPWR VPWR sky130_fd_sc_hd__decap_6
XFILLER_0_14_141 VPWR VGND VPWR VGND sky130_ef_sc_hd__decap_12
XFILLER_0_6_363 VGND VGND VPWR VPWR sky130_fd_sc_hd__fill_1
X_3769_ _0995_ _0996_ VGND VGND VPWR VPWR _0997_ sky130_fd_sc_hd__xnor2_1
XFILLER_0_42_472 VGND VGND VPWR VPWR sky130_fd_sc_hd__decap_4
XTAP_TAPCELL_ROW_25_386 VGND VPWR sky130_fd_sc_hd__tapvpwrvgnd_1
XFILLER_0_25_417 VGND VGND VPWR VPWR sky130_fd_sc_hd__fill_1
XFILLER_0_73_15 VPWR VGND VPWR VGND sky130_ef_sc_hd__decap_12
X_4810_ clknet_4_12_0_clk _0175_ VGND VGND VPWR VPWR net46 sky130_fd_sc_hd__dfxtp_1
XFILLER_0_22_41 VPWR VGND VPWR VGND sky130_ef_sc_hd__decap_12
X_4741_ clknet_4_4_0_clk _0106_ VGND VGND VPWR VPWR u_interface.u_compute_core.u_mac.product_reg\[15\]
+ sky130_fd_sc_hd__dfxtp_1
X_4672_ clknet_4_3_0_clk _0037_ VGND VGND VPWR VPWR u_interface.u_compute_core.scaled_data\[8\]
+ sky130_fd_sc_hd__dfxtp_1
X_3623_ _0483_ _1853_ VGND VGND VPWR VPWR _0854_ sky130_fd_sc_hd__nand2_1
XFILLER_0_11_111 VGND VGND VPWR VPWR sky130_fd_sc_hd__fill_1
X_3554_ _0769_ _0786_ VGND VGND VPWR VPWR _0787_ sky130_fd_sc_hd__xor2_2
X_3485_ _0459_ _0456_ _1850_ _1845_ VGND VGND VPWR VPWR _0719_ sky130_fd_sc_hd__and4_1
X_2505_ _1948_ VGND VGND VPWR VPWR _0049_ sky130_fd_sc_hd__clkbuf_1
X_2436_ _1811_ VGND VGND VPWR VPWR _1901_ sky130_fd_sc_hd__clkbuf_4
XFILLER_0_37_3 VGND VGND VPWR VPWR sky130_fd_sc_hd__decap_8
X_2367_ u_interface.u_compute_core.relu_data\[10\] VGND VGND VPWR VPWR _1850_ sky130_fd_sc_hd__buf_2
X_4106_ _0437_ u_interface.u_compute_core.relu_data\[20\] VGND VGND VPWR VPWR _1327_
+ sky130_fd_sc_hd__nand2_1
XTAP_TAPCELL_ROW_67_743 VGND VPWR sky130_fd_sc_hd__tapvpwrvgnd_1
X_4037_ _1257_ _1258_ VGND VGND VPWR VPWR _1260_ sky130_fd_sc_hd__nand2_1
XFILLER_0_78_133 VGND VGND VPWR VPWR sky130_fd_sc_hd__decap_6
XFILLER_0_59_380 VGND VGND VPWR VPWR sky130_fd_sc_hd__fill_1
XFILLER_0_59_391 VGND VGND VPWR VPWR sky130_fd_sc_hd__fill_1
XFILLER_0_81_309 VPWR VGND VPWR VGND sky130_ef_sc_hd__decap_12
XFILLER_0_74_350 VPWR VGND VPWR VGND sky130_ef_sc_hd__decap_12
XFILLER_0_19_255 VGND VGND VPWR VPWR sky130_fd_sc_hd__fill_2
XTAP_TAPCELL_ROW_22_367 VGND VPWR sky130_fd_sc_hd__tapvpwrvgnd_1
XFILLER_0_34_203 VPWR VGND VPWR VGND sky130_ef_sc_hd__decap_12
XFILLER_0_15_461 VGND VGND VPWR VPWR sky130_fd_sc_hd__fill_2
XFILLER_0_15_483 VGND VGND VPWR VPWR sky130_fd_sc_hd__fill_1
XFILLER_0_69_111 VGND VGND VPWR VPWR sky130_fd_sc_hd__fill_1
Xmax_cap64 _0636_ VGND VGND VPWR VPWR net64 sky130_fd_sc_hd__clkbuf_1
XFILLER_0_69_144 VPWR VGND VPWR VGND sky130_ef_sc_hd__decap_12
XFILLER_0_69_188 VGND VGND VPWR VPWR sky130_fd_sc_hd__decap_8
XFILLER_0_72_309 VPWR VGND VPWR VGND sky130_ef_sc_hd__decap_12
XFILLER_0_25_258 VGND VGND VPWR VPWR sky130_fd_sc_hd__fill_2
XFILLER_0_21_420 VGND VGND VPWR VPWR sky130_fd_sc_hd__decap_8
XFILLER_0_33_291 VPWR VGND VPWR VGND sky130_ef_sc_hd__decap_12
XFILLER_0_68_15 VPWR VGND VPWR VGND sky130_ef_sc_hd__decap_12
X_3270_ _0492_ _0507_ _0508_ VGND VGND VPWR VPWR _0509_ sky130_fd_sc_hd__o21ai_1
XFILLER_0_17_63 VGND VGND VPWR VPWR sky130_fd_sc_hd__decap_6
XTAP_TAPCELL_ROW_64_724 VGND VPWR sky130_fd_sc_hd__tapvpwrvgnd_1
XFILLER_0_75_125 VPWR VGND VPWR VGND sky130_ef_sc_hd__decap_12
XTAP_TAPCELL_ROW_72_790 VGND VPWR sky130_fd_sc_hd__tapvpwrvgnd_1
XFILLER_0_8_436 VPWR VGND VPWR VGND sky130_ef_sc_hd__decap_12
XFILLER_0_8_414 VGND VGND VPWR VPWR sky130_fd_sc_hd__fill_2
X_2985_ _0224_ _0197_ _0242_ VGND VGND VPWR VPWR _0243_ sky130_fd_sc_hd__a21o_1
XFILLER_0_56_361 VGND VGND VPWR VPWR sky130_fd_sc_hd__decap_3
X_4724_ clknet_4_5_0_clk _0089_ VGND VGND VPWR VPWR u_interface.u_compute_core.mac_accum\[30\]
+ sky130_fd_sc_hd__dfxtp_1
XFILLER_0_16_269 VGND VGND VPWR VPWR sky130_fd_sc_hd__fill_1
X_4655_ clknet_4_7_0_clk _0020_ VGND VGND VPWR VPWR u_interface.u_compute_core.relu_data\[20\]
+ sky130_fd_sc_hd__dfxtp_1
X_3606_ _0793_ _0836_ _0837_ VGND VGND VPWR VPWR _0838_ sky130_fd_sc_hd__a21o_1
X_4586_ net36 u_interface.core_attn_out\[16\] _1760_ VGND VGND VPWR VPWR _1778_ sky130_fd_sc_hd__mux2_1
XFILLER_0_12_453 VGND VGND VPWR VPWR sky130_fd_sc_hd__fill_2
X_3537_ _0430_ _1845_ VGND VGND VPWR VPWR _0770_ sky130_fd_sc_hd__nand2_1
X_3468_ _0623_ _0655_ _0702_ VGND VGND VPWR VPWR _0703_ sky130_fd_sc_hd__a21oi_1
X_2419_ u_interface.u_compute_core.scaled_data\[23\] _1814_ _1888_ _1816_ VGND VGND
+ VPWR VPWR _1889_ sky130_fd_sc_hd__o2bb2a_1
X_3399_ _0634_ _0458_ _1824_ _0551_ VGND VGND VPWR VPWR _0635_ sky130_fd_sc_hd__a22oi_4
XFILLER_0_79_420 VGND VGND VPWR VPWR sky130_fd_sc_hd__decap_4
XTAP_TAPCELL_ROW_27_404 VGND VPWR sky130_fd_sc_hd__tapvpwrvgnd_1
XTAP_TAPCELL_ROW_35_470 VGND VPWR sky130_fd_sc_hd__tapvpwrvgnd_1
XFILLER_0_47_372 VPWR VGND VPWR VGND sky130_ef_sc_hd__decap_12
XFILLER_0_74_180 VGND VGND VPWR VPWR sky130_fd_sc_hd__decap_4
XPHY_EDGE_ROW_26_Left_108 VGND VGND VPWR VPWR sky130_fd_sc_hd__decap_3
XTAP_TAPCELL_ROW_78_838 VGND VPWR sky130_fd_sc_hd__tapvpwrvgnd_1
XPHY_EDGE_ROW_35_Left_117 VGND VGND VPWR VPWR sky130_fd_sc_hd__decap_3
XFILLER_0_57_169 VGND VGND VPWR VPWR sky130_fd_sc_hd__decap_4
XFILLER_0_70_27 VGND VGND VPWR VPWR sky130_fd_sc_hd__fill_1
XFILLER_0_38_361 VGND VGND VPWR VPWR sky130_fd_sc_hd__decap_3
XFILLER_0_38_383 VGND VGND VPWR VPWR sky130_fd_sc_hd__decap_4
XFILLER_0_5_428 VPWR VGND VPWR VGND sky130_ef_sc_hd__decap_12
X_2770_ _2161_ _2169_ _2166_ VGND VGND VPWR VPWR _2170_ sky130_fd_sc_hd__a21o_1
XFILLER_0_65_180 VGND VGND VPWR VPWR sky130_fd_sc_hd__decap_3
XFILLER_0_79_69 VPWR VGND VPWR VGND sky130_ef_sc_hd__decap_12
X_4440_ _1650_ _1654_ VGND VGND VPWR VPWR _1655_ sky130_fd_sc_hd__xnor2_1
XPHY_EDGE_ROW_44_Left_126 VGND VGND VPWR VPWR sky130_fd_sc_hd__decap_3
XFILLER_0_0_100 VGND VGND VPWR VPWR sky130_fd_sc_hd__fill_1
XFILLER_0_0_111 VGND VGND VPWR VPWR sky130_fd_sc_hd__fill_1
X_4371_ _0451_ _0447_ _1887_ _1884_ VGND VGND VPWR VPWR _1587_ sky130_fd_sc_hd__and4_1
X_3322_ _0557_ _0558_ _0516_ VGND VGND VPWR VPWR _0560_ sky130_fd_sc_hd__a21bo_1
XFILLER_0_0_188 VGND VGND VPWR VPWR sky130_fd_sc_hd__decap_4
X_3253_ u_interface.u_compute_core.u_av.v_extended\[1\] _0456_ _1829_ _0458_ VGND
+ VGND VPWR VPWR _0493_ sky130_fd_sc_hd__and4_1
X_3184_ _0430_ VGND VGND VPWR VPWR _0431_ sky130_fd_sc_hd__clkbuf_4
XPHY_EDGE_ROW_53_Left_135 VGND VGND VPWR VPWR sky130_fd_sc_hd__decap_3
XTAP_TAPCELL_ROW_49_595 VGND VPWR sky130_fd_sc_hd__tapvpwrvgnd_1
XFILLER_0_48_114 VGND VGND VPWR VPWR sky130_fd_sc_hd__decap_4
XFILLER_0_76_445 VPWR VGND VPWR VGND sky130_ef_sc_hd__decap_12
XFILLER_0_36_309 VGND VGND VPWR VPWR sky130_fd_sc_hd__decap_4
XFILLER_0_8_244 VGND VGND VPWR VPWR sky130_fd_sc_hd__decap_8
XFILLER_0_29_350 VGND VGND VPWR VPWR sky130_fd_sc_hd__fill_2
XFILLER_0_8_277 VGND VGND VPWR VPWR sky130_fd_sc_hd__fill_1
X_2968_ net13 net7 net15 net8 VGND VGND VPWR VPWR _0226_ sky130_fd_sc_hd__and4_1
XTAP_TAPCELL_ROW_32_451 VGND VPWR sky130_fd_sc_hd__tapvpwrvgnd_1
XFILLER_0_60_82 VGND VGND VPWR VPWR sky130_fd_sc_hd__fill_2
X_4707_ clknet_4_1_0_clk _0072_ VGND VGND VPWR VPWR u_interface.u_compute_core.mac_accum\[13\]
+ sky130_fd_sc_hd__dfxtp_1
XFILLER_0_60_93 VGND VGND VPWR VPWR sky130_fd_sc_hd__fill_1
XPHY_EDGE_ROW_62_Left_144 VGND VGND VPWR VPWR sky130_fd_sc_hd__decap_3
X_2899_ net18 VGND VGND VPWR VPWR _2294_ sky130_fd_sc_hd__clkbuf_4
X_4638_ clknet_4_2_0_clk _0003_ VGND VGND VPWR VPWR u_interface.u_compute_core.relu_data\[3\]
+ sky130_fd_sc_hd__dfxtp_4
XFILLER_0_8_83 VGND VGND VPWR VPWR sky130_fd_sc_hd__fill_1
XFILLER_0_4_483 VGND VGND VPWR VPWR sky130_fd_sc_hd__fill_1
X_4569_ _1766_ VGND VGND VPWR VPWR _0160_ sky130_fd_sc_hd__clkbuf_1
XPHY_EDGE_ROW_71_Left_153 VGND VGND VPWR VPWR sky130_fd_sc_hd__decap_3
XFILLER_0_79_272 VGND VGND VPWR VPWR sky130_fd_sc_hd__decap_3
XFILLER_0_39_125 VGND VGND VPWR VPWR sky130_fd_sc_hd__decap_8
XFILLER_0_39_169 VGND VGND VPWR VPWR sky130_fd_sc_hd__decap_8
XPHY_EDGE_ROW_80_Left_162 VGND VGND VPWR VPWR sky130_fd_sc_hd__decap_3
XFILLER_0_54_139 VGND VGND VPWR VPWR sky130_fd_sc_hd__fill_1
XFILLER_0_10_209 VGND VGND VPWR VPWR sky130_fd_sc_hd__decap_8
XFILLER_0_65_27 VPWR VGND VPWR VGND sky130_ef_sc_hd__decap_12
XFILLER_0_81_15 VPWR VGND VPWR VGND sky130_ef_sc_hd__decap_12
X_3940_ _1163_ _1164_ VGND VGND VPWR VPWR _1165_ sky130_fd_sc_hd__or2b_1
XTAP_TAPCELL_ROW_46_565 VGND VPWR sky130_fd_sc_hd__tapvpwrvgnd_1
XFILLER_0_58_434 VPWR VGND VPWR VGND sky130_ef_sc_hd__decap_12
XFILLER_0_58_456 VPWR VGND VPWR VGND sky130_ef_sc_hd__decap_12
X_3871_ _1095_ _1096_ VGND VGND VPWR VPWR _1097_ sky130_fd_sc_hd__nor2_1
X_2822_ _2213_ _2218_ VGND VGND VPWR VPWR _2219_ sky130_fd_sc_hd__nand2b_1
XFILLER_0_5_225 VGND VGND VPWR VPWR sky130_fd_sc_hd__decap_8
XFILLER_0_30_41 VGND VGND VPWR VPWR sky130_fd_sc_hd__decap_8
X_2753_ net126 _1969_ _2156_ net62 VGND VGND VPWR VPWR _0089_ sky130_fd_sc_hd__o211a_1
XFILLER_0_30_85 VGND VGND VPWR VPWR sky130_fd_sc_hd__decap_4
X_2684_ net63 _2096_ _2094_ VGND VGND VPWR VPWR _2098_ sky130_fd_sc_hd__o21a_1
X_4423_ _1636_ _1616_ VGND VGND VPWR VPWR _1638_ sky130_fd_sc_hd__or2b_1
XFILLER_0_41_378 VGND VGND VPWR VPWR sky130_fd_sc_hd__decap_8
X_4354_ u_interface.core_attn_out\[24\] _1966_ VGND VGND VPWR VPWR _1571_ sky130_fd_sc_hd__or2_1
X_3305_ _0542_ _0493_ _0508_ VGND VGND VPWR VPWR _0543_ sky130_fd_sc_hd__and3b_1
X_4285_ _1492_ _1502_ VGND VGND VPWR VPWR _1503_ sky130_fd_sc_hd__xor2_1
X_3236_ _0475_ _0476_ VGND VGND VPWR VPWR _0477_ sky130_fd_sc_hd__nor2_1
X_3167_ _1817_ _1901_ VGND VGND VPWR VPWR _0418_ sky130_fd_sc_hd__and2_1
X_3098_ _0312_ _0319_ _0352_ VGND VGND VPWR VPWR _0353_ sky130_fd_sc_hd__o21a_1
XFILLER_0_76_253 VGND VGND VPWR VPWR sky130_fd_sc_hd__decap_8
XFILLER_0_76_242 VGND VGND VPWR VPWR sky130_fd_sc_hd__decap_8
XTAP_TAPCELL_ROW_80_855 VGND VPWR sky130_fd_sc_hd__tapvpwrvgnd_1
XFILLER_0_71_92 VGND VGND VPWR VPWR sky130_fd_sc_hd__fill_1
XFILLER_0_64_404 VGND VGND VPWR VPWR sky130_fd_sc_hd__fill_1
XFILLER_0_29_191 VGND VGND VPWR VPWR sky130_fd_sc_hd__decap_4
XFILLER_0_17_342 VPWR VGND VPWR VGND sky130_ef_sc_hd__decap_12
XFILLER_0_17_386 VGND VGND VPWR VPWR sky130_fd_sc_hd__decap_6
XFILLER_0_17_375 VGND VGND VPWR VPWR sky130_fd_sc_hd__decap_4
XFILLER_0_32_301 VGND VGND VPWR VPWR sky130_fd_sc_hd__decap_6
XFILLER_0_32_323 VGND VGND VPWR VPWR sky130_fd_sc_hd__fill_1
XFILLER_0_44_172 VGND VGND VPWR VPWR sky130_fd_sc_hd__fill_1
XFILLER_0_35_19 VGND VGND VPWR VPWR sky130_fd_sc_hd__fill_1
XFILLER_0_23_301 VPWR VGND VPWR VGND sky130_ef_sc_hd__decap_12
XFILLER_0_76_15 VPWR VGND VPWR VGND sky130_ef_sc_hd__decap_12
XFILLER_0_50_197 VGND VGND VPWR VPWR sky130_fd_sc_hd__fill_1
X_4070_ _1232_ _1234_ VGND VGND VPWR VPWR _1292_ sky130_fd_sc_hd__nand2_1
X_3021_ _0231_ _0240_ _0277_ VGND VGND VPWR VPWR _0278_ sky130_fd_sc_hd__a21o_1
X_3923_ _1144_ _1146_ VGND VGND VPWR VPWR _1148_ sky130_fd_sc_hd__nand2_1
XFILLER_0_58_253 VGND VGND VPWR VPWR sky130_fd_sc_hd__decap_4
XFILLER_0_18_139 VGND VGND VPWR VPWR sky130_fd_sc_hd__fill_1
X_3854_ _0839_ _0835_ _1022_ _1024_ _1079_ VGND VGND VPWR VPWR _1080_ sky130_fd_sc_hd__a311o_4
X_2805_ _2202_ _2180_ VGND VGND VPWR VPWR _2203_ sky130_fd_sc_hd__nand2_1
XFILLER_0_14_323 VGND VGND VPWR VPWR sky130_fd_sc_hd__decap_8
XTAP_TAPCELL_ROW_14_292 VGND VPWR sky130_fd_sc_hd__tapvpwrvgnd_1
X_3785_ _1010_ _1012_ VGND VGND VPWR VPWR _1013_ sky130_fd_sc_hd__xnor2_1
X_2736_ _2067_ u_interface.u_compute_core.mac_accum\[28\] VGND VGND VPWR VPWR _2142_
+ sky130_fd_sc_hd__nand2_1
X_2667_ _2078_ _2080_ VGND VGND VPWR VPWR _2083_ sky130_fd_sc_hd__or2_1
X_4406_ _1619_ _1620_ VGND VGND VPWR VPWR _1621_ sky130_fd_sc_hd__nor2_1
XFILLER_0_1_261 VPWR VGND VPWR VGND sky130_ef_sc_hd__decap_12
XFILLER_0_67_3 VPWR VGND VPWR VGND sky130_ef_sc_hd__decap_12
X_2598_ _2021_ _2022_ _2023_ VGND VGND VPWR VPWR _2024_ sky130_fd_sc_hd__nand3_1
X_4337_ _1496_ _1552_ VGND VGND VPWR VPWR _1554_ sky130_fd_sc_hd__nand2_1
XTAP_TAPCELL_ROW_6_227 VGND VPWR sky130_fd_sc_hd__tapvpwrvgnd_1
XFILLER_0_5_51 VGND VGND VPWR VPWR sky130_fd_sc_hd__decap_4
X_4268_ _1483_ _1484_ _1485_ VGND VGND VPWR VPWR _1486_ sky130_fd_sc_hd__o21a_1
X_3219_ _0459_ VGND VGND VPWR VPWR _0460_ sky130_fd_sc_hd__buf_2
XFILLER_0_66_92 VGND VGND VPWR VPWR sky130_fd_sc_hd__fill_1
X_4199_ _1416_ _1417_ u_interface.core_attn_out\[21\] VGND VGND VPWR VPWR _1419_ sky130_fd_sc_hd__a21o_1
XTAP_TAPCELL_ROW_40_516 VGND VPWR sky130_fd_sc_hd__tapvpwrvgnd_1
XFILLER_0_20_359 VGND VGND VPWR VPWR sky130_fd_sc_hd__decap_4
XFILLER_0_46_29 VGND VGND VPWR VPWR sky130_fd_sc_hd__decap_8
XFILLER_0_28_415 VGND VGND VPWR VPWR sky130_fd_sc_hd__decap_4
XTAP_TAPCELL_ROW_11_273 VGND VPWR sky130_fd_sc_hd__tapvpwrvgnd_1
X_3570_ _0719_ _0768_ _0801_ VGND VGND VPWR VPWR _0802_ sky130_fd_sc_hd__a21o_2
XFILLER_0_11_98 VGND VGND VPWR VPWR sky130_fd_sc_hd__decap_6
X_2521_ _1959_ VGND VGND VPWR VPWR _0054_ sky130_fd_sc_hd__clkbuf_1
XFILLER_0_11_337 VPWR VGND VPWR VGND sky130_ef_sc_hd__decap_12
X_2452_ u_interface.u_compute_core.scaled_data\[4\] u_interface.u_compute_core.mac_accum\[7\]
+ _1900_ VGND VGND VPWR VPWR _1912_ sky130_fd_sc_hd__mux2_1
XPHY_EDGE_ROW_18_Right_18 VGND VGND VPWR VPWR sky130_fd_sc_hd__decap_3
X_2383_ u_interface.u_compute_core.relu_data\[14\] VGND VGND VPWR VPWR _1862_ sky130_fd_sc_hd__clkbuf_4
X_4122_ _0431_ _1197_ _1288_ _1287_ VGND VGND VPWR VPWR _1343_ sky130_fd_sc_hd__a31o_1
X_4053_ _1080_ _1217_ _1218_ _1274_ VGND VGND VPWR VPWR _1275_ sky130_fd_sc_hd__a211o_1
Xinput3 s_tdata[0] VGND VGND VPWR VPWR net3 sky130_fd_sc_hd__buf_1
X_3004_ _0219_ _0222_ _0260_ _2003_ VGND VGND VPWR VPWR _0262_ sky130_fd_sc_hd__a31o_1
XTAP_TAPCELL_ROW_19_340 VGND VPWR sky130_fd_sc_hd__tapvpwrvgnd_1
XPHY_EDGE_ROW_27_Right_27 VGND VGND VPWR VPWR sky130_fd_sc_hd__decap_3
X_3906_ u_interface.u_compute_core.relu_data\[12\] _0596_ VGND VGND VPWR VPWR _1131_
+ sky130_fd_sc_hd__nor2b_1
XFILLER_0_52_94 VPWR VGND VPWR VGND sky130_ef_sc_hd__decap_12
XFILLER_0_46_256 VGND VGND VPWR VPWR sky130_fd_sc_hd__decap_6
X_3837_ _1006_ _1008_ VGND VGND VPWR VPWR _1064_ sky130_fd_sc_hd__or2_1
XFILLER_0_14_131 VGND VGND VPWR VPWR sky130_fd_sc_hd__decap_8
X_3768_ _0430_ _1862_ VGND VGND VPWR VPWR _0996_ sky130_fd_sc_hd__nand2_1
XFILLER_0_14_153 VPWR VGND VPWR VGND sky130_ef_sc_hd__decap_12
XFILLER_0_42_451 VGND VGND VPWR VPWR sky130_fd_sc_hd__fill_1
X_2719_ _2020_ _2126_ _2127_ _2100_ net123 VGND VGND VPWR VPWR _0084_ sky130_fd_sc_hd__a32o_1
XFILLER_0_14_197 VGND VGND VPWR VPWR sky130_fd_sc_hd__fill_2
X_3699_ _0875_ _0877_ _0928_ VGND VGND VPWR VPWR _0929_ sky130_fd_sc_hd__o21ai_1
XPHY_EDGE_ROW_36_Right_36 VGND VGND VPWR VPWR sky130_fd_sc_hd__decap_3
XPHY_EDGE_ROW_45_Right_45 VGND VGND VPWR VPWR sky130_fd_sc_hd__decap_3
XTAP_TAPCELL_ROW_53_630 VGND VPWR sky130_fd_sc_hd__tapvpwrvgnd_1
XFILLER_0_37_223 VGND VGND VPWR VPWR sky130_fd_sc_hd__fill_1
XTAP_TAPCELL_ROW_25_387 VGND VPWR sky130_fd_sc_hd__tapvpwrvgnd_1
XPHY_EDGE_ROW_54_Right_54 VGND VGND VPWR VPWR sky130_fd_sc_hd__decap_3
XFILLER_0_73_27 VPWR VGND VPWR VGND sky130_ef_sc_hd__decap_12
XPHY_EDGE_ROW_63_Right_63 VGND VGND VPWR VPWR sky130_fd_sc_hd__decap_3
XFILLER_0_75_307 VPWR VGND VPWR VGND sky130_ef_sc_hd__decap_12
XTAP_TAPCELL_ROW_16_310 VGND VPWR sky130_fd_sc_hd__tapvpwrvgnd_1
XFILLER_0_28_245 VGND VGND VPWR VPWR sky130_fd_sc_hd__decap_6
X_4740_ clknet_4_1_0_clk _0105_ VGND VGND VPWR VPWR u_interface.u_compute_core.u_mac.product_reg\[14\]
+ sky130_fd_sc_hd__dfxtp_1
XFILLER_0_16_429 VGND VGND VPWR VPWR sky130_fd_sc_hd__fill_1
XFILLER_0_16_418 VGND VGND VPWR VPWR sky130_fd_sc_hd__fill_2
XFILLER_0_22_53 VPWR VGND VPWR VGND sky130_ef_sc_hd__decap_12
X_4671_ clknet_4_6_0_clk _0036_ VGND VGND VPWR VPWR u_interface.u_compute_core.scaled_data\[7\]
+ sky130_fd_sc_hd__dfxtp_1
X_3622_ _0805_ _0852_ VGND VGND VPWR VPWR _0853_ sky130_fd_sc_hd__xnor2_1
XFILLER_0_43_237 VGND VGND VPWR VPWR sky130_fd_sc_hd__decap_6
XPHY_EDGE_ROW_72_Right_72 VGND VGND VPWR VPWR sky130_fd_sc_hd__decap_3
X_3553_ _0783_ _0785_ VGND VGND VPWR VPWR _0786_ sky130_fd_sc_hd__xnor2_2
X_3484_ _0457_ _1850_ _1845_ _0426_ VGND VGND VPWR VPWR _0718_ sky130_fd_sc_hd__a22oi_1
X_2504_ _1931_ _1947_ VGND VGND VPWR VPWR _1948_ sky130_fd_sc_hd__and2_1
X_2435_ u_interface.u_compute_core.mac_last VGND VGND VPWR VPWR _1900_ sky130_fd_sc_hd__clkbuf_4
X_2366_ _1814_ VGND VGND VPWR VPWR _1849_ sky130_fd_sc_hd__clkbuf_2
X_4105_ u_interface.u_compute_core.relu_data\[16\] _0453_ VGND VGND VPWR VPWR _1326_
+ sky130_fd_sc_hd__and2b_1
XPHY_EDGE_ROW_81_Right_81 VGND VGND VPWR VPWR sky130_fd_sc_hd__decap_3
XFILLER_0_2_41 VPWR VGND VPWR VGND sky130_ef_sc_hd__decap_12
X_4036_ _1257_ _1258_ VGND VGND VPWR VPWR _1259_ sky130_fd_sc_hd__or2_1
XTAP_TAPCELL_ROW_67_744 VGND VPWR sky130_fd_sc_hd__tapvpwrvgnd_1
XFILLER_0_2_85 VPWR VGND VPWR VGND sky130_ef_sc_hd__decap_12
XFILLER_0_63_60 VGND VGND VPWR VPWR sky130_fd_sc_hd__fill_1
XTAP_TAPCELL_ROW_50_600 VGND VPWR sky130_fd_sc_hd__tapvpwrvgnd_1
XFILLER_0_74_362 VGND VGND VPWR VPWR sky130_fd_sc_hd__fill_2
XFILLER_0_19_278 VGND VGND VPWR VPWR sky130_fd_sc_hd__fill_2
XFILLER_0_34_215 VGND VGND VPWR VPWR sky130_fd_sc_hd__fill_1
XFILLER_0_34_237 VGND VGND VPWR VPWR sky130_fd_sc_hd__decap_8
XFILLER_0_30_421 VGND VGND VPWR VPWR sky130_fd_sc_hd__decap_3
XFILLER_0_57_318 VPWR VGND VPWR VGND sky130_ef_sc_hd__decap_12
XFILLER_0_69_156 VGND VGND VPWR VPWR sky130_fd_sc_hd__fill_2
XFILLER_0_69_167 VGND VGND VPWR VPWR sky130_fd_sc_hd__fill_1
XFILLER_0_4_109 VPWR VGND VPWR VGND sky130_ef_sc_hd__decap_12
XFILLER_0_33_281 VGND VGND VPWR VPWR sky130_fd_sc_hd__decap_3
XFILLER_0_40_229 VGND VGND VPWR VPWR sky130_fd_sc_hd__fill_1
XFILLER_0_0_337 VPWR VGND VPWR VGND sky130_ef_sc_hd__decap_12
XFILLER_0_68_27 VGND VGND VPWR VPWR sky130_fd_sc_hd__fill_1
XFILLER_0_75_137 VPWR VGND VPWR VGND sky130_ef_sc_hd__decap_12
XFILLER_0_33_52 VGND VGND VPWR VPWR sky130_fd_sc_hd__decap_4
XTAP_TAPCELL_ROW_72_791 VGND VPWR sky130_fd_sc_hd__tapvpwrvgnd_1
X_2984_ _0240_ _0241_ VGND VGND VPWR VPWR _0242_ sky130_fd_sc_hd__nand2_1
XFILLER_0_33_74 VGND VGND VPWR VPWR sky130_fd_sc_hd__fill_1
XFILLER_0_8_448 VGND VGND VPWR VPWR sky130_fd_sc_hd__decap_8
X_4723_ clknet_4_5_0_clk _0088_ VGND VGND VPWR VPWR u_interface.u_compute_core.mac_accum\[29\]
+ sky130_fd_sc_hd__dfxtp_1
X_4654_ clknet_4_6_0_clk _0019_ VGND VGND VPWR VPWR u_interface.u_compute_core.relu_data\[19\]
+ sky130_fd_sc_hd__dfxtp_1
XFILLER_0_12_421 VGND VGND VPWR VPWR sky130_fd_sc_hd__fill_1
X_3605_ _0761_ _0791_ VGND VGND VPWR VPWR _0837_ sky130_fd_sc_hd__and2_1
X_4585_ _1777_ VGND VGND VPWR VPWR _0165_ sky130_fd_sc_hd__clkbuf_1
X_3536_ _0719_ _0768_ VGND VGND VPWR VPWR _0769_ sky130_fd_sc_hd__xnor2_2
X_3467_ _0652_ _0654_ VGND VGND VPWR VPWR _0702_ sky130_fd_sc_hd__nor2_1
XFILLER_0_58_82 VGND VGND VPWR VPWR sky130_fd_sc_hd__fill_2
X_2418_ _1887_ VGND VGND VPWR VPWR _1888_ sky130_fd_sc_hd__inv_2
X_3398_ u_interface.u_compute_core.u_av.v_extended\[5\] VGND VGND VPWR VPWR _0634_
+ sky130_fd_sc_hd__buf_4
X_2349_ _1835_ VGND VGND VPWR VPWR _1836_ sky130_fd_sc_hd__inv_2
XFILLER_0_79_432 VGND VGND VPWR VPWR sky130_fd_sc_hd__fill_2
XTAP_TAPCELL_ROW_27_405 VGND VPWR sky130_fd_sc_hd__tapvpwrvgnd_1
X_4019_ _1183_ _1185_ VGND VGND VPWR VPWR _1242_ sky130_fd_sc_hd__nand2_1
XFILLER_0_79_465 VPWR VGND VPWR VGND sky130_ef_sc_hd__decap_12
XPHY_EDGE_ROW_0_Right_0 VGND VGND VPWR VPWR sky130_fd_sc_hd__decap_3
XFILLER_0_39_329 VGND VGND VPWR VPWR sky130_fd_sc_hd__decap_6
XFILLER_0_66_126 VGND VGND VPWR VPWR sky130_fd_sc_hd__decap_8
XTAP_TAPCELL_ROW_35_471 VGND VPWR sky130_fd_sc_hd__tapvpwrvgnd_1
XFILLER_0_47_384 VGND VGND VPWR VPWR sky130_fd_sc_hd__decap_8
XFILLER_0_15_281 VGND VGND VPWR VPWR sky130_fd_sc_hd__decap_8
XFILLER_0_15_270 VGND VGND VPWR VPWR sky130_fd_sc_hd__decap_8
XFILLER_0_30_251 VGND VGND VPWR VPWR sky130_fd_sc_hd__fill_1
XTAP_TAPCELL_ROW_78_839 VGND VPWR sky130_fd_sc_hd__tapvpwrvgnd_1
XFILLER_0_54_29 VGND VGND VPWR VPWR sky130_fd_sc_hd__fill_1
XFILLER_0_79_15 VPWR VGND VPWR VGND sky130_ef_sc_hd__decap_12
XFILLER_0_53_343 VPWR VGND VPWR VGND sky130_ef_sc_hd__decap_12
XFILLER_0_80_195 VGND VGND VPWR VPWR sky130_fd_sc_hd__fill_1
X_4370_ _0447_ _1887_ _1884_ _0451_ VGND VGND VPWR VPWR _1586_ sky130_fd_sc_hd__a22oi_1
X_3321_ _0516_ _0557_ _0558_ VGND VGND VPWR VPWR _0559_ sky130_fd_sc_hd__and3b_1
XFILLER_0_21_273 VGND VGND VPWR VPWR sky130_fd_sc_hd__decap_6
XFILLER_0_21_295 VGND VGND VPWR VPWR sky130_fd_sc_hd__fill_1
X_3252_ _0456_ _1829_ VGND VGND VPWR VPWR _0492_ sky130_fd_sc_hd__nand2_1
X_3183_ u_interface.u_compute_core.u_av.v_extended\[2\] VGND VGND VPWR VPWR _0430_
+ sky130_fd_sc_hd__buf_2
XFILLER_0_21_7 VGND VGND VPWR VPWR sky130_fd_sc_hd__fill_1
XTAP_TAPCELL_ROW_49_596 VGND VPWR sky130_fd_sc_hd__tapvpwrvgnd_1
XFILLER_0_76_457 VPWR VGND VPWR VGND sky130_ef_sc_hd__decap_12
X_2967_ net7 _2193_ _2244_ _2182_ VGND VGND VPWR VPWR _0225_ sky130_fd_sc_hd__a22oi_1
XTAP_TAPCELL_ROW_32_452 VGND VPWR sky130_fd_sc_hd__tapvpwrvgnd_1
X_2898_ _2247_ _2250_ _2248_ VGND VGND VPWR VPWR _2293_ sky130_fd_sc_hd__o21ba_1
XFILLER_0_44_365 VGND VGND VPWR VPWR sky130_fd_sc_hd__decap_3
X_4706_ clknet_4_4_0_clk _0071_ VGND VGND VPWR VPWR u_interface.u_compute_core.mac_accum\[12\]
+ sky130_fd_sc_hd__dfxtp_1
XFILLER_0_71_184 VGND VGND VPWR VPWR sky130_fd_sc_hd__decap_3
X_4637_ clknet_4_2_0_clk _0002_ VGND VGND VPWR VPWR u_interface.u_compute_core.relu_data\[2\]
+ sky130_fd_sc_hd__dfxtp_4
X_4568_ _1753_ _1765_ VGND VGND VPWR VPWR _1766_ sky130_fd_sc_hd__and2_1
X_4499_ _1672_ _1711_ VGND VGND VPWR VPWR _1712_ sky130_fd_sc_hd__xor2_1
X_3519_ u_interface.core_attn_out\[7\] _0751_ VGND VGND VPWR VPWR _0753_ sky130_fd_sc_hd__or2_1
XFILLER_0_35_332 VGND VGND VPWR VPWR sky130_fd_sc_hd__decap_4
XFILLER_0_50_335 VPWR VGND VPWR VGND sky130_ef_sc_hd__decap_12
XFILLER_0_65_39 VPWR VGND VPWR VGND sky130_ef_sc_hd__decap_12
XFILLER_0_81_27 VGND VGND VPWR VPWR sky130_fd_sc_hd__fill_1
XTAP_TAPCELL_ROW_46_566 VGND VPWR sky130_fd_sc_hd__tapvpwrvgnd_1
XFILLER_0_58_402 VGND VGND VPWR VPWR sky130_fd_sc_hd__fill_1
XFILLER_0_58_446 VGND VGND VPWR VPWR sky130_fd_sc_hd__fill_2
XFILLER_0_58_468 VGND VGND VPWR VPWR sky130_fd_sc_hd__decap_8
X_3870_ _0680_ _0511_ u_interface.u_compute_core.relu_data\[13\] _1856_ VGND VGND
+ VPWR VPWR _1096_ sky130_fd_sc_hd__and4_1
X_2821_ _2216_ _2217_ VGND VGND VPWR VPWR _2218_ sky130_fd_sc_hd__xnor2_1
XFILLER_0_14_98 VGND VGND VPWR VPWR sky130_fd_sc_hd__fill_1
XFILLER_0_26_365 VGND VGND VPWR VPWR sky130_fd_sc_hd__decap_8
X_2752_ _2003_ _2155_ VGND VGND VPWR VPWR _2156_ sky130_fd_sc_hd__or2_1
XFILLER_0_81_471 VGND VGND VPWR VPWR sky130_fd_sc_hd__decap_4
XFILLER_0_5_248 VPWR VGND VPWR VGND sky130_ef_sc_hd__decap_12
X_4422_ _1616_ _1636_ VGND VGND VPWR VPWR _1637_ sky130_fd_sc_hd__or2b_1
XFILLER_0_41_346 VGND VGND VPWR VPWR sky130_fd_sc_hd__fill_2
XFILLER_0_53_195 VGND VGND VPWR VPWR sky130_fd_sc_hd__decap_8
X_2683_ _2094_ net63 _2096_ VGND VGND VPWR VPWR _2097_ sky130_fd_sc_hd__or3_1
X_4353_ _1568_ _1569_ VGND VGND VPWR VPWR _1570_ sky130_fd_sc_hd__nor2_1
X_4284_ _1500_ _1501_ VGND VGND VPWR VPWR _1502_ sky130_fd_sc_hd__nand2_1
X_3304_ _0492_ _0507_ VGND VGND VPWR VPWR _0542_ sky130_fd_sc_hd__nor2_1
X_3235_ _0471_ _0474_ VGND VGND VPWR VPWR _0476_ sky130_fd_sc_hd__nor2_1
X_3166_ _2068_ _1980_ _0405_ _0417_ VGND VGND VPWR VPWR _0106_ sky130_fd_sc_hd__a22o_1
X_3097_ _0350_ _0351_ VGND VGND VPWR VPWR _0352_ sky130_fd_sc_hd__and2_1
XFILLER_0_55_72 VGND VGND VPWR VPWR sky130_fd_sc_hd__fill_1
XFILLER_0_55_94 VGND VGND VPWR VPWR sky130_fd_sc_hd__decap_6
XFILLER_0_49_402 VPWR VGND VPWR VGND sky130_ef_sc_hd__decap_12
XFILLER_0_49_446 VGND VGND VPWR VPWR sky130_fd_sc_hd__fill_2
XTAP_TAPCELL_ROW_80_856 VGND VPWR sky130_fd_sc_hd__tapvpwrvgnd_1
XFILLER_0_76_265 VGND VGND VPWR VPWR sky130_fd_sc_hd__fill_1
XFILLER_0_64_416 VGND VGND VPWR VPWR sky130_fd_sc_hd__fill_1
X_3999_ _1221_ _1222_ VGND VGND VPWR VPWR _1223_ sky130_fd_sc_hd__and2b_1
XFILLER_0_17_354 VGND VGND VPWR VPWR sky130_fd_sc_hd__fill_1
XFILLER_0_32_313 VGND VGND VPWR VPWR sky130_fd_sc_hd__fill_1
XFILLER_0_32_335 VGND VGND VPWR VPWR sky130_fd_sc_hd__fill_1
XTAP_TAPCELL_ROW_0_180 VGND VPWR sky130_fd_sc_hd__tapvpwrvgnd_1
XFILLER_0_67_276 VGND VGND VPWR VPWR sky130_fd_sc_hd__decap_4
XFILLER_0_55_449 VGND VGND VPWR VPWR sky130_fd_sc_hd__decap_8
XFILLER_0_23_313 VPWR VGND VPWR VGND sky130_ef_sc_hd__decap_12
XFILLER_0_50_154 VGND VGND VPWR VPWR sky130_fd_sc_hd__fill_1
XFILLER_0_76_27 VGND VGND VPWR VPWR sky130_fd_sc_hd__fill_1
X_3020_ _0275_ _0276_ VGND VGND VPWR VPWR _0277_ sky130_fd_sc_hd__or2_1
XTAP_TAPCELL_ROW_59_680 VGND VPWR sky130_fd_sc_hd__tapvpwrvgnd_1
XFILLER_0_25_42 VGND VGND VPWR VPWR sky130_fd_sc_hd__fill_2
XFILLER_0_25_97 VGND VGND VPWR VPWR sky130_fd_sc_hd__fill_1
X_3922_ _1144_ _1146_ VGND VGND VPWR VPWR _1147_ sky130_fd_sc_hd__nor2_1
X_3853_ _1018_ _1070_ VGND VGND VPWR VPWR _1079_ sky130_fd_sc_hd__or2_1
X_2804_ net6 VGND VGND VPWR VPWR _2202_ sky130_fd_sc_hd__clkbuf_2
XFILLER_0_61_408 VGND VGND VPWR VPWR sky130_fd_sc_hd__decap_6
XFILLER_0_73_279 VGND VGND VPWR VPWR sky130_fd_sc_hd__fill_1
XTAP_TAPCELL_ROW_14_293 VGND VPWR sky130_fd_sc_hd__tapvpwrvgnd_1
XFILLER_0_26_173 VGND VGND VPWR VPWR sky130_fd_sc_hd__fill_1
X_3784_ _0951_ _0968_ _1011_ VGND VGND VPWR VPWR _1012_ sky130_fd_sc_hd__o21a_1
X_2735_ _2133_ _2128_ _2136_ _2140_ VGND VGND VPWR VPWR _2141_ sky130_fd_sc_hd__a31o_1
X_2666_ _2081_ _2082_ u_interface.u_compute_core.mac_accum\[17\] _2006_ VGND VGND
+ VPWR VPWR _0076_ sky130_fd_sc_hd__a2bb2o_1
X_4405_ _0439_ u_interface.u_compute_core.relu_data\[26\] _1618_ VGND VGND VPWR VPWR
+ _1620_ sky130_fd_sc_hd__and3_1
X_4336_ _1496_ _1552_ VGND VGND VPWR VPWR _1553_ sky130_fd_sc_hd__nor2_1
XFILLER_0_1_273 VGND VGND VPWR VPWR sky130_fd_sc_hd__decap_6
X_2597_ _2015_ _2016_ _2014_ VGND VGND VPWR VPWR _2023_ sky130_fd_sc_hd__a21bo_1
XTAP_TAPCELL_ROW_6_228 VGND VPWR sky130_fd_sc_hd__tapvpwrvgnd_1
X_4267_ _0432_ _1890_ VGND VGND VPWR VPWR _1485_ sky130_fd_sc_hd__nand2_1
X_3218_ u_interface.u_compute_core.u_av.v_extended\[1\] VGND VGND VPWR VPWR _0459_
+ sky130_fd_sc_hd__buf_2
X_4198_ u_interface.core_attn_out\[21\] _1416_ _1417_ VGND VGND VPWR VPWR _1418_ sky130_fd_sc_hd__and3_1
X_3149_ _0400_ _0401_ VGND VGND VPWR VPWR _0402_ sky130_fd_sc_hd__nor2_1
XTAP_TAPCELL_ROW_40_517 VGND VPWR sky130_fd_sc_hd__tapvpwrvgnd_1
XFILLER_0_1_3 VPWR VGND VPWR VGND sky130_ef_sc_hd__decap_12
XTAP_TAPCELL_ROW_56_650 VGND VPWR sky130_fd_sc_hd__tapvpwrvgnd_1
XFILLER_0_62_29 VPWR VGND VPWR VGND sky130_ef_sc_hd__decap_12
XFILLER_0_28_438 VPWR VGND VPWR VGND sky130_ef_sc_hd__decap_12
XFILLER_0_11_11 VGND VGND VPWR VPWR sky130_fd_sc_hd__fill_2
XFILLER_0_70_227 VPWR VGND VPWR VGND sky130_ef_sc_hd__decap_12
X_2520_ _1953_ _1958_ VGND VGND VPWR VPWR _1959_ sky130_fd_sc_hd__and2_1
XFILLER_0_11_349 VPWR VGND VPWR VGND sky130_ef_sc_hd__decap_12
X_2451_ _1911_ VGND VGND VPWR VPWR _0032_ sky130_fd_sc_hd__clkbuf_1
X_2382_ _1848_ _1861_ VGND VGND VPWR VPWR _0013_ sky130_fd_sc_hd__nor2_1
X_4121_ _1339_ _1341_ VGND VGND VPWR VPWR _1342_ sky130_fd_sc_hd__xnor2_1
X_4052_ _1215_ _1264_ VGND VGND VPWR VPWR _1274_ sky130_fd_sc_hd__or2_1
Xinput4 s_tdata[10] VGND VGND VPWR VPWR net4 sky130_fd_sc_hd__buf_1
X_3003_ _0219_ _0222_ _0260_ VGND VGND VPWR VPWR _0261_ sky130_fd_sc_hd__a21oi_1
XTAP_TAPCELL_ROW_19_341 VGND VPWR sky130_fd_sc_hd__tapvpwrvgnd_1
XFILLER_0_19_449 VPWR VGND VPWR VGND sky130_ef_sc_hd__decap_12
X_3905_ _1115_ _1086_ VGND VGND VPWR VPWR _1130_ sky130_fd_sc_hd__or2b_1
X_3836_ _1062_ _1045_ VGND VGND VPWR VPWR _1063_ sky130_fd_sc_hd__xor2_2
X_3767_ _0993_ _0994_ VGND VGND VPWR VPWR _0995_ sky130_fd_sc_hd__nor2_1
XFILLER_0_14_165 VPWR VGND VPWR VGND sky130_ef_sc_hd__decap_12
X_2718_ _2124_ _2121_ _2125_ VGND VGND VPWR VPWR _2127_ sky130_fd_sc_hd__o21ai_1
X_3698_ _0875_ _0877_ _0830_ _0832_ VGND VGND VPWR VPWR _0928_ sky130_fd_sc_hd__a211o_1
X_2649_ _2067_ VGND VGND VPWR VPWR _2068_ sky130_fd_sc_hd__buf_2
XFILLER_0_77_81 VPWR VGND VPWR VGND sky130_ef_sc_hd__decap_12
X_4319_ _1534_ _1535_ VGND VGND VPWR VPWR _1536_ sky130_fd_sc_hd__xnor2_1
XFILLER_0_77_393 VPWR VGND VPWR VGND sky130_ef_sc_hd__decap_12
XTAP_TAPCELL_ROW_25_388 VGND VPWR sky130_fd_sc_hd__tapvpwrvgnd_1
XFILLER_0_9_181 VPWR VGND VPWR VGND sky130_ef_sc_hd__decap_12
XFILLER_0_20_113 VGND VGND VPWR VPWR sky130_fd_sc_hd__fill_2
XFILLER_0_57_18 VPWR VGND VPWR VGND sky130_ef_sc_hd__decap_12
XFILLER_0_73_39 VPWR VGND VPWR VGND sky130_ef_sc_hd__decap_12
XFILLER_0_75_319 VPWR VGND VPWR VGND sky130_ef_sc_hd__decap_12
XTAP_TAPCELL_ROW_16_311 VGND VPWR sky130_fd_sc_hd__tapvpwrvgnd_1
XFILLER_0_16_408 VGND VGND VPWR VPWR sky130_fd_sc_hd__decap_3
XFILLER_0_22_65 VGND VGND VPWR VPWR sky130_fd_sc_hd__decap_4
X_4670_ clknet_4_3_0_clk _0035_ VGND VGND VPWR VPWR u_interface.u_compute_core.scaled_data\[6\]
+ sky130_fd_sc_hd__dfxtp_1
XFILLER_0_43_205 VGND VGND VPWR VPWR sky130_fd_sc_hd__decap_6
X_3621_ _0848_ _0851_ VGND VGND VPWR VPWR _0852_ sky130_fd_sc_hd__xnor2_1
XFILLER_0_3_335 VGND VGND VPWR VPWR sky130_fd_sc_hd__fill_1
X_3552_ _0727_ _0735_ _0784_ VGND VGND VPWR VPWR _0785_ sky130_fd_sc_hd__a21oi_2
XFILLER_0_11_113 VPWR VGND VPWR VGND sky130_ef_sc_hd__decap_12
X_2503_ u_interface.u_compute_core.scaled_data\[20\] u_interface.u_compute_core.mac_accum\[23\]
+ _1944_ VGND VGND VPWR VPWR _1947_ sky130_fd_sc_hd__mux2_1
X_3483_ _0430_ _1838_ _0682_ _0679_ VGND VGND VPWR VPWR _0717_ sky130_fd_sc_hd__a31o_1
X_2434_ _1879_ _1899_ VGND VGND VPWR VPWR _0027_ sky130_fd_sc_hd__nor2_1
XFILLER_0_44_6 VGND VGND VPWR VPWR sky130_fd_sc_hd__fill_2
X_2365_ net2 VGND VGND VPWR VPWR _1848_ sky130_fd_sc_hd__buf_2
X_4104_ _0442_ _1874_ _1280_ _1324_ VGND VGND VPWR VPWR _1325_ sky130_fd_sc_hd__a31oi_1
X_4035_ _1153_ _1203_ _1201_ VGND VGND VPWR VPWR _1258_ sky130_fd_sc_hd__a21oi_1
XTAP_TAPCELL_ROW_67_745 VGND VPWR sky130_fd_sc_hd__tapvpwrvgnd_1
XFILLER_0_2_53 VPWR VGND VPWR VGND sky130_ef_sc_hd__decap_12
XFILLER_0_2_97 VPWR VGND VPWR VGND sky130_ef_sc_hd__decap_12
XFILLER_0_63_94 VGND VGND VPWR VPWR sky130_fd_sc_hd__fill_1
XTAP_TAPCELL_ROW_50_601 VGND VPWR sky130_fd_sc_hd__tapvpwrvgnd_1
XFILLER_0_59_393 VGND VGND VPWR VPWR sky130_fd_sc_hd__fill_1
X_3819_ u_interface.u_compute_core.relu_data\[10\] u_interface.u_compute_core.u_av.v_extended\[10\]
+ VGND VGND VPWR VPWR _1046_ sky130_fd_sc_hd__and2b_1
XFILLER_0_6_195 VGND VGND VPWR VPWR sky130_fd_sc_hd__fill_1
X_4799_ clknet_4_9_0_clk _0164_ VGND VGND VPWR VPWR net34 sky130_fd_sc_hd__dfxtp_1
XFILLER_0_30_477 VGND VGND VPWR VPWR sky130_fd_sc_hd__decap_4
XPHY_EDGE_ROW_6_Left_88 VGND VGND VPWR VPWR sky130_fd_sc_hd__decap_3
XFILLER_0_69_113 VGND VGND VPWR VPWR sky130_fd_sc_hd__decap_4
XFILLER_0_25_238 VPWR VGND VPWR VGND sky130_ef_sc_hd__decap_12
XFILLER_0_0_305 VGND VGND VPWR VPWR sky130_fd_sc_hd__decap_3
XFILLER_0_21_433 VPWR VGND VPWR VGND sky130_ef_sc_hd__decap_12
XFILLER_0_0_349 VPWR VGND VPWR VGND sky130_ef_sc_hd__decap_12
XFILLER_0_75_105 VGND VGND VPWR VPWR sky130_fd_sc_hd__decap_6
XFILLER_0_75_149 VGND VGND VPWR VPWR sky130_fd_sc_hd__decap_8
XTAP_TAPCELL_ROW_72_792 VGND VPWR sky130_fd_sc_hd__tapvpwrvgnd_1
X_2983_ _0233_ _0239_ VGND VGND VPWR VPWR _0241_ sky130_fd_sc_hd__or2_1
XFILLER_0_56_330 VGND VGND VPWR VPWR sky130_fd_sc_hd__fill_1
X_4722_ clknet_4_5_0_clk _0087_ VGND VGND VPWR VPWR u_interface.u_compute_core.mac_accum\[28\]
+ sky130_fd_sc_hd__dfxtp_1
XFILLER_0_16_249 VGND VGND VPWR VPWR sky130_fd_sc_hd__decap_3
X_4653_ clknet_4_6_0_clk _0018_ VGND VGND VPWR VPWR u_interface.u_compute_core.relu_data\[18\]
+ sky130_fd_sc_hd__dfxtp_1
XFILLER_0_12_411 VGND VGND VPWR VPWR sky130_fd_sc_hd__decap_8
X_3604_ _0761_ _0791_ VGND VGND VPWR VPWR _0836_ sky130_fd_sc_hd__or2_1
X_4584_ _1775_ _1776_ VGND VGND VPWR VPWR _1777_ sky130_fd_sc_hd__and2_1
X_3535_ _0764_ _0767_ VGND VGND VPWR VPWR _0768_ sky130_fd_sc_hd__xnor2_2
XFILLER_0_12_477 VGND VGND VPWR VPWR sky130_fd_sc_hd__decap_3
X_3466_ _0700_ _0669_ VGND VGND VPWR VPWR _0701_ sky130_fd_sc_hd__xor2_1
X_2417_ u_interface.u_compute_core.relu_data\[23\] VGND VGND VPWR VPWR _1887_ sky130_fd_sc_hd__buf_2
X_3397_ u_interface.u_compute_core.relu_data\[2\] u_interface.u_compute_core.u_av.v_extended\[5\]
+ u_interface.u_compute_core.relu_data\[3\] u_interface.u_compute_core.u_av.v_extended\[6\]
+ VGND VGND VPWR VPWR _0633_ sky130_fd_sc_hd__and4_1
X_2348_ u_interface.u_compute_core.relu_data\[6\] VGND VGND VPWR VPWR _1835_ sky130_fd_sc_hd__buf_2
XTAP_TAPCELL_ROW_27_406 VGND VPWR sky130_fd_sc_hd__tapvpwrvgnd_1
X_4018_ _1235_ _1240_ VGND VGND VPWR VPWR _1241_ sky130_fd_sc_hd__xnor2_1
XFILLER_0_79_477 VGND VGND VPWR VPWR sky130_fd_sc_hd__decap_6
XTAP_TAPCELL_ROW_35_472 VGND VPWR sky130_fd_sc_hd__tapvpwrvgnd_1
XFILLER_0_7_482 VGND VGND VPWR VPWR sky130_fd_sc_hd__fill_2
XFILLER_0_62_355 VGND VGND VPWR VPWR sky130_fd_sc_hd__fill_1
XFILLER_0_57_105 VGND VGND VPWR VPWR sky130_fd_sc_hd__decap_6
XFILLER_0_57_138 VGND VGND VPWR VPWR sky130_fd_sc_hd__decap_8
XFILLER_0_70_29 VPWR VGND VPWR VGND sky130_ef_sc_hd__decap_12
XFILLER_0_80_141 VPWR VGND VPWR VGND sky130_ef_sc_hd__decap_12
XFILLER_0_79_27 VPWR VGND VPWR VGND sky130_ef_sc_hd__decap_12
XFILLER_0_53_355 VPWR VGND VPWR VGND sky130_ef_sc_hd__decap_12
XFILLER_0_13_208 VGND VGND VPWR VPWR sky130_fd_sc_hd__decap_8
XFILLER_0_0_113 VGND VGND VPWR VPWR sky130_fd_sc_hd__fill_2
X_3320_ net83 u_interface.u_compute_core.relu_data\[3\] u_interface.u_compute_core.relu_data\[2\]
+ u_interface.u_compute_core.u_av.v_extended\[4\] VGND VGND VPWR VPWR _0558_ sky130_fd_sc_hd__a22o_1
X_3251_ _0459_ _0458_ VGND VGND VPWR VPWR _0491_ sky130_fd_sc_hd__nand2_1
X_3182_ _1968_ net14 _0420_ _0429_ VGND VGND VPWR VPWR _0110_ sky130_fd_sc_hd__o211a_1
XFILLER_0_76_469 VGND VGND VPWR VPWR sky130_fd_sc_hd__decap_6
XFILLER_0_8_224 VGND VGND VPWR VPWR sky130_fd_sc_hd__decap_3
XFILLER_0_29_374 VPWR VGND VPWR VGND sky130_ef_sc_hd__decap_12
X_2966_ _0189_ _0190_ VGND VGND VPWR VPWR _0224_ sky130_fd_sc_hd__nand2_1
XFILLER_0_71_141 VGND VGND VPWR VPWR sky130_fd_sc_hd__decap_4
X_2897_ _2290_ _2291_ VGND VGND VPWR VPWR _2292_ sky130_fd_sc_hd__nand2_1
XFILLER_0_44_344 VGND VGND VPWR VPWR sky130_fd_sc_hd__fill_2
X_4705_ clknet_4_1_0_clk _0070_ VGND VGND VPWR VPWR u_interface.u_compute_core.mac_accum\[11\]
+ sky130_fd_sc_hd__dfxtp_1
X_4636_ clknet_4_2_0_clk _0001_ VGND VGND VPWR VPWR u_interface.u_compute_core.relu_data\[1\]
+ sky130_fd_sc_hd__dfxtp_2
XFILLER_0_44_399 VGND VGND VPWR VPWR sky130_fd_sc_hd__fill_1
X_4567_ net30 u_interface.core_attn_out\[10\] _1760_ VGND VGND VPWR VPWR _1765_ sky130_fd_sc_hd__mux2_1
XFILLER_0_8_85 VPWR VGND VPWR VGND sky130_ef_sc_hd__decap_12
X_4498_ _0447_ u_interface.u_compute_core.relu_data\[26\] VGND VGND VPWR VPWR _1711_
+ sky130_fd_sc_hd__nand2_1
X_3518_ u_interface.core_attn_out\[7\] _0751_ VGND VGND VPWR VPWR _0752_ sky130_fd_sc_hd__and2_1
X_3449_ _0639_ _1832_ VGND VGND VPWR VPWR _0684_ sky130_fd_sc_hd__nand2_1
XFILLER_0_54_108 VGND VGND VPWR VPWR sky130_fd_sc_hd__decap_8
XFILLER_0_62_141 VGND VGND VPWR VPWR sky130_fd_sc_hd__fill_2
XFILLER_0_50_347 VPWR VGND VPWR VGND sky130_ef_sc_hd__decap_12
XTAP_TAPCELL_ROW_46_567 VGND VPWR sky130_fd_sc_hd__tapvpwrvgnd_1
XPHY_EDGE_ROW_9_Left_91 VGND VGND VPWR VPWR sky130_fd_sc_hd__decap_3
X_2820_ _2168_ _2182_ VGND VGND VPWR VPWR _2217_ sky130_fd_sc_hd__nand2_1
XFILLER_0_5_205 VPWR VGND VPWR VGND sky130_ef_sc_hd__decap_12
X_2751_ _2153_ _2154_ VGND VGND VPWR VPWR _2155_ sky130_fd_sc_hd__xor2_1
XFILLER_0_81_483 VGND VGND VPWR VPWR sky130_fd_sc_hd__fill_1
XFILLER_0_81_461 VGND VGND VPWR VPWR sky130_fd_sc_hd__decap_4
X_2682_ u_interface.u_compute_core.mac_accum\[19\] u_interface.u_compute_core.mac_accum\[18\]
+ u_interface.u_compute_core.mac_accum\[17\] u_interface.u_compute_core.mac_accum\[16\]
+ _2066_ VGND VGND VPWR VPWR _2096_ sky130_fd_sc_hd__o41a_1
X_4421_ _1633_ _1635_ VGND VGND VPWR VPWR _1636_ sky130_fd_sc_hd__xor2_1
X_4352_ _1567_ _1529_ VGND VGND VPWR VPWR _1569_ sky130_fd_sc_hd__and2b_1
X_4283_ _1445_ _1499_ VGND VGND VPWR VPWR _1501_ sky130_fd_sc_hd__nand2_1
X_3303_ _0480_ _0540_ _0541_ net62 VGND VGND VPWR VPWR _0119_ sky130_fd_sc_hd__o211a_1
X_3234_ _0471_ _0474_ VGND VGND VPWR VPWR _0475_ sky130_fd_sc_hd__and2_1
X_3165_ _1972_ _0409_ _0416_ VGND VGND VPWR VPWR _0417_ sky130_fd_sc_hd__and3_1
X_3096_ _0344_ _0349_ VGND VGND VPWR VPWR _0351_ sky130_fd_sc_hd__or2_1
XFILLER_0_49_414 VPWR VGND VPWR VGND sky130_ef_sc_hd__decap_12
XFILLER_0_49_458 VPWR VGND VPWR VGND sky130_ef_sc_hd__decap_12
XTAP_TAPCELL_ROW_80_857 VGND VPWR sky130_fd_sc_hd__tapvpwrvgnd_1
XFILLER_0_36_119 VPWR VGND VPWR VGND sky130_ef_sc_hd__decap_12
X_3998_ u_interface.core_attn_out\[17\] _1220_ VGND VGND VPWR VPWR _1222_ sky130_fd_sc_hd__or2_1
XFILLER_0_17_333 VGND VGND VPWR VPWR sky130_fd_sc_hd__decap_3
X_2949_ _0203_ _0207_ VGND VGND VPWR VPWR _0208_ sky130_fd_sc_hd__xnor2_1
XFILLER_0_44_141 VGND VGND VPWR VPWR sky130_fd_sc_hd__decap_6
X_4619_ _1800_ VGND VGND VPWR VPWR _0176_ sky130_fd_sc_hd__clkbuf_1
XTAP_TAPCELL_ROW_0_170 VGND VPWR sky130_fd_sc_hd__tapvpwrvgnd_1
XFILLER_0_50_100 VGND VGND VPWR VPWR sky130_fd_sc_hd__fill_1
XFILLER_0_63_483 VGND VGND VPWR VPWR sky130_fd_sc_hd__fill_1
XFILLER_0_23_325 VGND VGND VPWR VPWR sky130_fd_sc_hd__decap_6
XFILLER_0_35_185 VGND VGND VPWR VPWR sky130_fd_sc_hd__fill_1
XTAP_TAPCELL_ROW_59_681 VGND VPWR sky130_fd_sc_hd__tapvpwrvgnd_1
XFILLER_0_25_32 VGND VGND VPWR VPWR sky130_fd_sc_hd__fill_2
XFILLER_0_25_76 VGND VGND VPWR VPWR sky130_fd_sc_hd__decap_8
X_3921_ _1094_ _1099_ _1145_ VGND VGND VPWR VPWR _1146_ sky130_fd_sc_hd__a21boi_1
XFILLER_0_73_225 VGND VGND VPWR VPWR sky130_fd_sc_hd__fill_1
X_3852_ _0938_ _1077_ _1078_ _0667_ VGND VGND VPWR VPWR _0131_ sky130_fd_sc_hd__o211a_1
X_2803_ _2168_ _2169_ VGND VGND VPWR VPWR _2201_ sky130_fd_sc_hd__nand2_1
XFILLER_0_26_130 VGND VGND VPWR VPWR sky130_fd_sc_hd__fill_1
XFILLER_0_41_53 VGND VGND VPWR VPWR sky130_fd_sc_hd__decap_3
XFILLER_0_14_314 VGND VGND VPWR VPWR sky130_fd_sc_hd__fill_2
XTAP_TAPCELL_ROW_14_294 VGND VPWR sky130_fd_sc_hd__tapvpwrvgnd_1
X_3783_ _0965_ _0967_ VGND VGND VPWR VPWR _1011_ sky130_fd_sc_hd__or2_1
XFILLER_0_14_336 VGND VGND VPWR VPWR sky130_fd_sc_hd__decap_3
XFILLER_0_41_111 VGND VGND VPWR VPWR sky130_fd_sc_hd__fill_1
X_2734_ u_interface.u_compute_core.mac_accum\[27\] u_interface.u_compute_core.mac_accum\[26\]
+ _2067_ VGND VGND VPWR VPWR _2140_ sky130_fd_sc_hd__o21a_1
XFILLER_0_14_369 VGND VGND VPWR VPWR sky130_fd_sc_hd__fill_1
X_2665_ _2074_ _2078_ _2080_ _2003_ VGND VGND VPWR VPWR _2082_ sky130_fd_sc_hd__a31o_1
X_4404_ _0439_ u_interface.u_compute_core.relu_data\[26\] _1618_ VGND VGND VPWR VPWR
+ _1619_ sky130_fd_sc_hd__a21oi_1
X_2596_ u_interface.u_compute_core.u_mac.product_reg\[8\] u_interface.u_compute_core.mac_accum\[8\]
+ VGND VGND VPWR VPWR _2022_ sky130_fd_sc_hd__or2_1
XFILLER_0_41_177 VGND VGND VPWR VPWR sky130_fd_sc_hd__fill_2
XFILLER_0_41_199 VGND VGND VPWR VPWR sky130_fd_sc_hd__decap_4
X_4335_ _1548_ _1551_ VGND VGND VPWR VPWR _1552_ sky130_fd_sc_hd__xnor2_1
XTAP_TAPCELL_ROW_6_229 VGND VPWR sky130_fd_sc_hd__tapvpwrvgnd_1
XFILLER_0_5_86 VGND VGND VPWR VPWR sky130_fd_sc_hd__fill_1
XFILLER_0_5_97 VGND VGND VPWR VPWR sky130_fd_sc_hd__decap_3
XFILLER_0_66_61 VGND VGND VPWR VPWR sky130_fd_sc_hd__fill_1
X_4266_ _0450_ _0446_ _1246_ _1197_ VGND VGND VPWR VPWR _1484_ sky130_fd_sc_hd__and4_1
X_3217_ u_interface.u_compute_core.relu_data\[3\] VGND VGND VPWR VPWR _0458_ sky130_fd_sc_hd__buf_6
X_4197_ _1415_ _1374_ net67 VGND VGND VPWR VPWR _1417_ sky130_fd_sc_hd__nand3_1
X_3148_ _0398_ _0399_ VGND VGND VPWR VPWR _0401_ sky130_fd_sc_hd__and2_1
X_3079_ _2220_ _2244_ net17 net18 VGND VGND VPWR VPWR _0334_ sky130_fd_sc_hd__and4_1
XFILLER_0_49_233 VGND VGND VPWR VPWR sky130_fd_sc_hd__fill_1
XFILLER_0_49_244 VGND VGND VPWR VPWR sky130_fd_sc_hd__decap_6
XPHY_EDGE_ROW_59_Left_141 VGND VGND VPWR VPWR sky130_fd_sc_hd__decap_3
XFILLER_0_49_277 VGND VGND VPWR VPWR sky130_fd_sc_hd__decap_3
XTAP_TAPCELL_ROW_40_518 VGND VPWR sky130_fd_sc_hd__tapvpwrvgnd_1
XFILLER_0_64_247 VGND VGND VPWR VPWR sky130_fd_sc_hd__decap_4
XFILLER_0_17_152 VGND VGND VPWR VPWR sky130_fd_sc_hd__fill_1
XFILLER_0_17_141 VGND VGND VPWR VPWR sky130_fd_sc_hd__decap_4
XFILLER_0_45_461 VGND VGND VPWR VPWR sky130_fd_sc_hd__decap_4
XFILLER_0_45_472 VPWR VGND VPWR VGND sky130_ef_sc_hd__decap_12
XFILLER_0_60_464 VPWR VGND VPWR VGND sky130_ef_sc_hd__decap_12
XFILLER_0_13_380 VGND VGND VPWR VPWR sky130_fd_sc_hd__fill_1
XPHY_EDGE_ROW_68_Left_150 VGND VGND VPWR VPWR sky130_fd_sc_hd__decap_3
XTAP_TAPCELL_ROW_56_651 VGND VPWR sky130_fd_sc_hd__tapvpwrvgnd_1
XFILLER_0_70_206 VGND VGND VPWR VPWR sky130_fd_sc_hd__fill_1
XFILLER_0_23_100 VPWR VGND VPWR VGND sky130_ef_sc_hd__decap_12
XFILLER_0_70_239 VGND VGND VPWR VPWR sky130_fd_sc_hd__decap_4
XFILLER_0_23_144 VGND VGND VPWR VPWR sky130_fd_sc_hd__fill_1
X_2450_ _1909_ _1910_ VGND VGND VPWR VPWR _1911_ sky130_fd_sc_hd__and2_1
X_2381_ u_interface.u_compute_core.scaled_data\[13\] _1849_ _1860_ _1843_ VGND VGND
+ VPWR VPWR _1861_ sky130_fd_sc_hd__o2bb2a_1
X_4120_ _1285_ _1290_ _1340_ VGND VGND VPWR VPWR _1341_ sky130_fd_sc_hd__a21oi_1
X_4051_ net133 _0715_ _0434_ _1273_ VGND VGND VPWR VPWR _0135_ sky130_fd_sc_hd__o211a_1
Xinput5 s_tdata[11] VGND VGND VPWR VPWR net5 sky130_fd_sc_hd__dlymetal6s2s_1
X_3002_ _0258_ _0259_ VGND VGND VPWR VPWR _0260_ sky130_fd_sc_hd__or2_1
XFILLER_0_19_417 VPWR VGND VPWR VGND sky130_ef_sc_hd__decap_12
X_3904_ _1114_ _1112_ VGND VGND VPWR VPWR _1129_ sky130_fd_sc_hd__or2b_1
X_3835_ _1059_ _1061_ VGND VGND VPWR VPWR _1062_ sky130_fd_sc_hd__xor2_1
XFILLER_0_46_269 VGND VGND VPWR VPWR sky130_fd_sc_hd__decap_8
X_3766_ _0551_ _0634_ u_interface.u_compute_core.relu_data\[11\] u_interface.u_compute_core.relu_data\[10\]
+ VGND VGND VPWR VPWR _0994_ sky130_fd_sc_hd__and4_1
XFILLER_0_42_431 VGND VGND VPWR VPWR sky130_fd_sc_hd__decap_4
X_2717_ _2124_ _2121_ _2125_ VGND VGND VPWR VPWR _2126_ sky130_fd_sc_hd__or3_1
XFILLER_0_72_3 VPWR VGND VPWR VGND sky130_ef_sc_hd__decap_12
XFILLER_0_14_177 VPWR VGND VPWR VGND sky130_ef_sc_hd__decap_12
X_3697_ _0924_ _0926_ VGND VGND VPWR VPWR _0927_ sky130_fd_sc_hd__xor2_2
X_2648_ _2066_ VGND VGND VPWR VPWR _2067_ sky130_fd_sc_hd__buf_2
XFILLER_0_10_361 VGND VGND VPWR VPWR sky130_fd_sc_hd__decap_3
X_2579_ _1994_ VGND VGND VPWR VPWR _2007_ sky130_fd_sc_hd__inv_2
XFILLER_0_77_93 VPWR VGND VPWR VGND sky130_ef_sc_hd__decap_12
X_4318_ _0443_ _1887_ VGND VGND VPWR VPWR _1535_ sky130_fd_sc_hd__nand2_1
X_4249_ _1420_ VGND VGND VPWR VPWR _1468_ sky130_fd_sc_hd__inv_2
XFILLER_0_37_203 VGND VGND VPWR VPWR sky130_fd_sc_hd__fill_1
XTAP_TAPCELL_ROW_25_389 VGND VPWR sky130_fd_sc_hd__tapvpwrvgnd_1
XFILLER_0_37_258 VGND VGND VPWR VPWR sky130_fd_sc_hd__fill_2
XFILLER_0_9_193 VGND VGND VPWR VPWR sky130_fd_sc_hd__decap_8
XFILLER_0_18_461 VGND VGND VPWR VPWR sky130_fd_sc_hd__decap_3
XFILLER_0_18_483 VGND VGND VPWR VPWR sky130_fd_sc_hd__fill_1
XFILLER_0_60_261 VGND VGND VPWR VPWR sky130_fd_sc_hd__fill_1
XTAP_TAPCELL_ROW_16_312 VGND VPWR sky130_fd_sc_hd__tapvpwrvgnd_1
XFILLER_0_68_350 VGND VGND VPWR VPWR sky130_fd_sc_hd__fill_1
XFILLER_0_68_383 VGND VGND VPWR VPWR sky130_fd_sc_hd__decap_8
XFILLER_0_7_119 VPWR VGND VPWR VGND sky130_ef_sc_hd__decap_12
X_3620_ _0849_ _0850_ VGND VGND VPWR VPWR _0851_ sky130_fd_sc_hd__or2_1
X_3551_ _0732_ _0734_ VGND VGND VPWR VPWR _0784_ sky130_fd_sc_hd__and2_1
XFILLER_0_24_464 VPWR VGND VPWR VGND sky130_ef_sc_hd__decap_12
XFILLER_0_36_291 VPWR VGND VPWR VGND sky130_ef_sc_hd__decap_12
X_2502_ _1946_ VGND VGND VPWR VPWR _0048_ sky130_fd_sc_hd__clkbuf_1
XFILLER_0_11_125 VGND VGND VPWR VPWR sky130_fd_sc_hd__fill_2
X_3482_ _0670_ _0675_ _0674_ VGND VGND VPWR VPWR _0716_ sky130_fd_sc_hd__a21o_1
XFILLER_0_51_294 VGND VGND VPWR VPWR sky130_fd_sc_hd__decap_4
XFILLER_0_11_169 VPWR VGND VPWR VGND sky130_ef_sc_hd__decap_12
X_2433_ u_interface.u_compute_core.scaled_data\[27\] _1814_ _1817_ _1898_ VGND VGND
+ VPWR VPWR _1899_ sky130_fd_sc_hd__o2bb2a_1
X_2364_ _1820_ _1847_ VGND VGND VPWR VPWR _0009_ sky130_fd_sc_hd__nor2_1
X_4103_ _0438_ u_interface.u_compute_core.relu_data\[19\] _1278_ VGND VGND VPWR VPWR
+ _1324_ sky130_fd_sc_hd__and3_1
X_4034_ _1254_ _1256_ VGND VGND VPWR VPWR _1257_ sky130_fd_sc_hd__xor2_1
XTAP_TAPCELL_ROW_67_746 VGND VPWR sky130_fd_sc_hd__tapvpwrvgnd_1
XFILLER_0_2_65 VPWR VGND VPWR VGND sky130_ef_sc_hd__decap_12
XFILLER_0_63_51 VGND VGND VPWR VPWR sky130_fd_sc_hd__decap_4
XFILLER_0_66_309 VPWR VGND VPWR VGND sky130_ef_sc_hd__decap_12
XFILLER_0_19_225 VPWR VGND VPWR VGND sky130_ef_sc_hd__decap_12
XTAP_TAPCELL_ROW_50_602 VGND VPWR sky130_fd_sc_hd__tapvpwrvgnd_1
XFILLER_0_6_141 VPWR VGND VPWR VGND sky130_ef_sc_hd__decap_12
XTAP_TAPCELL_ROW_22_359 VGND VPWR sky130_fd_sc_hd__tapvpwrvgnd_1
X_3818_ _1044_ _0989_ VGND VGND VPWR VPWR _1045_ sky130_fd_sc_hd__xor2_1
X_4798_ clknet_4_9_0_clk _0163_ VGND VGND VPWR VPWR net33 sky130_fd_sc_hd__dfxtp_1
XFILLER_0_15_475 VGND VGND VPWR VPWR sky130_fd_sc_hd__decap_8
X_3749_ u_interface.core_attn_out\[12\] _0977_ VGND VGND VPWR VPWR _0978_ sky130_fd_sc_hd__nand2_1
XFILLER_0_42_294 VGND VGND VPWR VPWR sky130_fd_sc_hd__fill_1
XFILLER_0_80_345 VGND VGND VPWR VPWR sky130_fd_sc_hd__decap_3
XFILLER_0_21_412 VGND VGND VPWR VPWR sky130_fd_sc_hd__fill_1
XFILLER_0_21_445 VGND VGND VPWR VPWR sky130_fd_sc_hd__decap_3
XFILLER_0_68_29 VPWR VGND VPWR VGND sky130_ef_sc_hd__decap_12
Xclkbuf_4_9_0_clk clknet_0_clk VGND VGND VPWR VPWR clknet_4_9_0_clk sky130_fd_sc_hd__clkbuf_8
XFILLER_0_17_55 VGND VGND VPWR VPWR sky130_fd_sc_hd__fill_1
XTAP_TAPCELL_ROW_64_716 VGND VPWR sky130_fd_sc_hd__tapvpwrvgnd_1
XFILLER_0_48_309 VPWR VGND VPWR VGND sky130_ef_sc_hd__decap_12
XFILLER_0_33_32 VGND VGND VPWR VPWR sky130_fd_sc_hd__fill_1
X_2982_ _0233_ _0239_ VGND VGND VPWR VPWR _0240_ sky130_fd_sc_hd__nand2_1
X_4721_ clknet_4_5_0_clk _0086_ VGND VGND VPWR VPWR u_interface.u_compute_core.mac_accum\[27\]
+ sky130_fd_sc_hd__dfxtp_1
XFILLER_0_16_206 VGND VGND VPWR VPWR sky130_fd_sc_hd__decap_6
X_4652_ clknet_4_6_0_clk _0017_ VGND VGND VPWR VPWR u_interface.u_compute_core.relu_data\[17\]
+ sky130_fd_sc_hd__dfxtp_1
X_3603_ _0621_ _0661_ _0706_ _0834_ VGND VGND VPWR VPWR _0835_ sky130_fd_sc_hd__nand4_4
XFILLER_0_3_111 VGND VGND VPWR VPWR sky130_fd_sc_hd__fill_1
XFILLER_0_71_389 VGND VGND VPWR VPWR sky130_fd_sc_hd__decap_3
XFILLER_0_24_261 VGND VGND VPWR VPWR sky130_fd_sc_hd__fill_2
X_4583_ net35 u_interface.core_attn_out\[15\] _1760_ VGND VGND VPWR VPWR _1776_ sky130_fd_sc_hd__mux2_1
X_3534_ _0765_ _0766_ VGND VGND VPWR VPWR _0767_ sky130_fd_sc_hd__or2_1
X_3465_ _0699_ _0697_ VGND VGND VPWR VPWR _0700_ sky130_fd_sc_hd__xnor2_2
X_2416_ _1879_ _1886_ VGND VGND VPWR VPWR _0022_ sky130_fd_sc_hd__nor2_1
X_3396_ _0625_ _0631_ VGND VGND VPWR VPWR _0632_ sky130_fd_sc_hd__xnor2_1
X_2347_ _1820_ _1834_ VGND VGND VPWR VPWR _0005_ sky130_fd_sc_hd__nor2_1
XFILLER_0_35_3 VPWR VGND VPWR VGND sky130_ef_sc_hd__decap_12
XFILLER_0_79_401 VGND VGND VPWR VPWR sky130_fd_sc_hd__fill_2
XFILLER_0_74_83 VGND VGND VPWR VPWR sky130_fd_sc_hd__fill_1
XTAP_TAPCELL_ROW_27_407 VGND VPWR sky130_fd_sc_hd__tapvpwrvgnd_1
X_4017_ _1238_ _1239_ VGND VGND VPWR VPWR _1240_ sky130_fd_sc_hd__xnor2_1
XFILLER_0_66_117 VGND VGND VPWR VPWR sky130_fd_sc_hd__fill_1
XTAP_TAPCELL_ROW_35_473 VGND VPWR sky130_fd_sc_hd__tapvpwrvgnd_1
XFILLER_0_81_109 VGND VGND VPWR VPWR sky130_fd_sc_hd__decap_3
XFILLER_0_47_364 VGND VGND VPWR VPWR sky130_fd_sc_hd__fill_1
XFILLER_0_38_353 VGND VGND VPWR VPWR sky130_fd_sc_hd__decap_8
XFILLER_0_65_172 VGND VGND VPWR VPWR sky130_fd_sc_hd__decap_8
XFILLER_0_53_367 VGND VGND VPWR VPWR sky130_fd_sc_hd__fill_1
XFILLER_0_80_153 VPWR VGND VPWR VGND sky130_ef_sc_hd__decap_12
XFILLER_0_79_39 VPWR VGND VPWR VGND sky130_ef_sc_hd__decap_12
XFILLER_0_80_197 VPWR VGND VPWR VGND sky130_ef_sc_hd__decap_12
XFILLER_0_0_169 VPWR VGND VPWR VGND sky130_ef_sc_hd__decap_12
X_3250_ _0487_ _0488_ _0469_ VGND VGND VPWR VPWR _0490_ sky130_fd_sc_hd__a21oi_1
X_3181_ _0421_ _0428_ VGND VGND VPWR VPWR _0429_ sky130_fd_sc_hd__or2_1
XTAP_TAPCELL_ROW_77_830 VGND VPWR sky130_fd_sc_hd__tapvpwrvgnd_1
XFILLER_0_44_75 VGND VGND VPWR VPWR sky130_fd_sc_hd__fill_2
XPHY_EDGE_ROW_22_Left_104 VGND VGND VPWR VPWR sky130_fd_sc_hd__decap_3
XFILLER_0_63_109 VGND VGND VPWR VPWR sky130_fd_sc_hd__decap_3
XFILLER_0_29_386 VGND VGND VPWR VPWR sky130_fd_sc_hd__fill_2
X_2965_ _2032_ _0222_ _0223_ _1979_ net95 VGND VGND VPWR VPWR _0099_ sky130_fd_sc_hd__a32o_1
X_4704_ clknet_4_4_0_clk _0069_ VGND VGND VPWR VPWR u_interface.u_compute_core.mac_accum\[10\]
+ sky130_fd_sc_hd__dfxtp_1
X_2896_ _2274_ _2289_ VGND VGND VPWR VPWR _2291_ sky130_fd_sc_hd__or2_1
XFILLER_0_60_85 VGND VGND VPWR VPWR sky130_fd_sc_hd__fill_2
XFILLER_0_71_164 VGND VGND VPWR VPWR sky130_fd_sc_hd__decap_4
X_4635_ clknet_4_3_0_clk _0000_ VGND VGND VPWR VPWR u_interface.u_compute_core.relu_data\[0\]
+ sky130_fd_sc_hd__dfxtp_1
X_4566_ _1764_ VGND VGND VPWR VPWR _0159_ sky130_fd_sc_hd__clkbuf_1
XFILLER_0_12_253 VGND VGND VPWR VPWR sky130_fd_sc_hd__decap_6
X_3517_ net69 _0750_ VGND VGND VPWR VPWR _0751_ sky130_fd_sc_hd__xor2_1
XPHY_EDGE_ROW_31_Left_113 VGND VGND VPWR VPWR sky130_fd_sc_hd__decap_3
X_4497_ _1708_ _1709_ VGND VGND VPWR VPWR _1710_ sky130_fd_sc_hd__xnor2_1
XFILLER_0_12_286 VPWR VGND VPWR VGND sky130_ef_sc_hd__decap_12
X_3448_ _0678_ _0682_ VGND VGND VPWR VPWR _0683_ sky130_fd_sc_hd__xnor2_1
X_3379_ u_interface.core_attn_out\[4\] _0614_ VGND VGND VPWR VPWR _0616_ sky130_fd_sc_hd__or2_1
XPHY_EDGE_ROW_40_Left_122 VGND VGND VPWR VPWR sky130_fd_sc_hd__decap_3
XFILLER_0_35_389 VGND VGND VPWR VPWR sky130_fd_sc_hd__decap_3
XFILLER_0_50_359 VGND VGND VPWR VPWR sky130_fd_sc_hd__decap_4
XFILLER_0_62_197 VGND VGND VPWR VPWR sky130_fd_sc_hd__decap_8
XFILLER_0_81_29 VPWR VGND VPWR VGND sky130_ef_sc_hd__decap_12
XTAP_TAPCELL_ROW_46_568 VGND VPWR sky130_fd_sc_hd__tapvpwrvgnd_1
XFILLER_0_45_109 VGND VGND VPWR VPWR sky130_fd_sc_hd__decap_3
XFILLER_0_5_217 VGND VGND VPWR VPWR sky130_fd_sc_hd__decap_6
X_2750_ _2144_ _2148_ _2147_ _2142_ VGND VGND VPWR VPWR _2154_ sky130_fd_sc_hd__o211a_1
XFILLER_0_30_33 VGND VGND VPWR VPWR sky130_fd_sc_hd__decap_4
XFILLER_0_53_175 VGND VGND VPWR VPWR sky130_fd_sc_hd__fill_1
X_2681_ _2078_ _2080_ _2087_ _2090_ VGND VGND VPWR VPWR _2095_ sky130_fd_sc_hd__nor4b_1
X_4420_ _1585_ _1590_ _1634_ VGND VGND VPWR VPWR _1635_ sky130_fd_sc_hd__a21oi_1
XFILLER_0_41_337 VGND VGND VPWR VPWR sky130_fd_sc_hd__fill_2
X_4351_ _1529_ _1567_ VGND VGND VPWR VPWR _1568_ sky130_fd_sc_hd__and2b_1
X_4282_ _1445_ _1499_ VGND VGND VPWR VPWR _1500_ sky130_fd_sc_hd__or2_1
X_3302_ u_interface.core_attn_out\[2\] _0435_ VGND VGND VPWR VPWR _0541_ sky130_fd_sc_hd__or2_1
XFILLER_0_39_53 VGND VGND VPWR VPWR sky130_fd_sc_hd__decap_3
X_3233_ _1818_ _0472_ _0473_ VGND VGND VPWR VPWR _0474_ sky130_fd_sc_hd__and3_1
X_3164_ _0411_ _0415_ VGND VGND VPWR VPWR _0416_ sky130_fd_sc_hd__xnor2_1
X_3095_ _0344_ _0349_ VGND VGND VPWR VPWR _0350_ sky130_fd_sc_hd__nand2_1
XFILLER_0_76_212 VGND VGND VPWR VPWR sky130_fd_sc_hd__decap_3
XFILLER_0_49_426 VPWR VGND VPWR VGND sky130_ef_sc_hd__decap_12
XTAP_TAPCELL_ROW_80_858 VGND VPWR sky130_fd_sc_hd__tapvpwrvgnd_1
XFILLER_0_71_73 VGND VGND VPWR VPWR sky130_fd_sc_hd__fill_1
XFILLER_0_71_51 VGND VGND VPWR VPWR sky130_fd_sc_hd__decap_4
XFILLER_0_76_289 VGND VGND VPWR VPWR sky130_fd_sc_hd__decap_4
X_3997_ u_interface.core_attn_out\[17\] _1220_ VGND VGND VPWR VPWR _1221_ sky130_fd_sc_hd__and2_1
X_2948_ _0204_ _0206_ VGND VGND VPWR VPWR _0207_ sky130_fd_sc_hd__xor2_1
XFILLER_0_44_175 VGND VGND VPWR VPWR sky130_fd_sc_hd__fill_2
X_4618_ _1901_ _1799_ VGND VGND VPWR VPWR _1800_ sky130_fd_sc_hd__and2_1
X_2879_ _2246_ _2251_ VGND VGND VPWR VPWR _2274_ sky130_fd_sc_hd__or2b_1
XFILLER_0_44_197 VGND VGND VPWR VPWR sky130_fd_sc_hd__fill_1
XTAP_TAPCELL_ROW_9_249 VGND VPWR sky130_fd_sc_hd__tapvpwrvgnd_1
X_4549_ _1752_ VGND VGND VPWR VPWR _0154_ sky130_fd_sc_hd__clkbuf_1
XTAP_TAPCELL_ROW_0_171 VGND VPWR sky130_fd_sc_hd__tapvpwrvgnd_1
XTAP_TAPCELL_ROW_43_538 VGND VPWR sky130_fd_sc_hd__tapvpwrvgnd_1
XFILLER_0_35_153 VGND VGND VPWR VPWR sky130_fd_sc_hd__fill_1
XFILLER_0_2_209 VPWR VGND VPWR VGND sky130_ef_sc_hd__decap_12
XFILLER_0_76_29 VPWR VGND VPWR VGND sky130_ef_sc_hd__decap_12
XFILLER_0_25_11 VGND VGND VPWR VPWR sky130_fd_sc_hd__fill_1
XFILLER_0_25_55 VGND VGND VPWR VPWR sky130_fd_sc_hd__fill_1
X_3920_ _1091_ _1093_ VGND VGND VPWR VPWR _1145_ sky130_fd_sc_hd__nand2_1
X_3851_ u_interface.core_attn_out\[14\] _0713_ VGND VGND VPWR VPWR _1078_ sky130_fd_sc_hd__or2_1
XFILLER_0_46_418 VGND VGND VPWR VPWR sky130_fd_sc_hd__fill_2
XFILLER_0_58_289 VGND VGND VPWR VPWR sky130_fd_sc_hd__fill_1
X_2802_ _2198_ _2199_ VGND VGND VPWR VPWR _2200_ sky130_fd_sc_hd__nand2_1
X_3782_ _1009_ _0992_ VGND VGND VPWR VPWR _1010_ sky130_fd_sc_hd__xor2_1
X_2733_ net129 _2026_ _2138_ _2139_ VGND VGND VPWR VPWR _0086_ sky130_fd_sc_hd__a22o_1
XTAP_TAPCELL_ROW_14_295 VGND VPWR sky130_fd_sc_hd__tapvpwrvgnd_1
XFILLER_0_81_281 VPWR VGND VPWR VGND sky130_ef_sc_hd__decap_12
XFILLER_0_26_197 VPWR VGND VPWR VGND sky130_ef_sc_hd__decap_12
X_2664_ _2074_ _2078_ _2080_ VGND VGND VPWR VPWR _2081_ sky130_fd_sc_hd__a21oi_1
X_4403_ _0454_ _1885_ VGND VGND VPWR VPWR _1618_ sky130_fd_sc_hd__and2_1
X_2595_ u_interface.u_compute_core.u_mac.product_reg\[8\] u_interface.u_compute_core.mac_accum\[8\]
+ VGND VGND VPWR VPWR _2021_ sky130_fd_sc_hd__nand2_1
X_4334_ _1549_ _1550_ VGND VGND VPWR VPWR _1551_ sky130_fd_sc_hd__nor2_1
X_4265_ _0447_ _1246_ _1197_ _0451_ VGND VGND VPWR VPWR _1483_ sky130_fd_sc_hd__a22oi_1
X_3216_ _0456_ VGND VGND VPWR VPWR _0457_ sky130_fd_sc_hd__clkbuf_4
X_4196_ _1374_ net66 _1415_ VGND VGND VPWR VPWR _1416_ sky130_fd_sc_hd__a21o_1
X_3147_ _0398_ _0399_ VGND VGND VPWR VPWR _0400_ sky130_fd_sc_hd__nor2_1
X_3078_ _2244_ _2256_ _2294_ _2220_ VGND VGND VPWR VPWR _0333_ sky130_fd_sc_hd__a22oi_1
XFILLER_0_49_223 VGND VGND VPWR VPWR sky130_fd_sc_hd__fill_1
XTAP_TAPCELL_ROW_40_519 VGND VPWR sky130_fd_sc_hd__tapvpwrvgnd_1
XFILLER_0_60_421 VPWR VGND VPWR VGND sky130_ef_sc_hd__decap_12
XFILLER_0_20_307 VGND VGND VPWR VPWR sky130_fd_sc_hd__fill_1
XTAP_TAPCELL_ROW_56_652 VGND VPWR sky130_fd_sc_hd__tapvpwrvgnd_1
XFILLER_0_55_259 VGND VGND VPWR VPWR sky130_fd_sc_hd__fill_1
XFILLER_0_70_218 VGND VGND VPWR VPWR sky130_fd_sc_hd__fill_2
XFILLER_0_11_57 VPWR VGND VPWR VGND sky130_ef_sc_hd__decap_12
XFILLER_0_63_281 VPWR VGND VPWR VGND sky130_ef_sc_hd__decap_12
XFILLER_0_51_465 VPWR VGND VPWR VGND sky130_ef_sc_hd__decap_12
XFILLER_0_11_307 VGND VGND VPWR VPWR sky130_fd_sc_hd__decap_3
X_2380_ _1859_ VGND VGND VPWR VPWR _1860_ sky130_fd_sc_hd__inv_2
X_4050_ _0421_ _1272_ VGND VGND VPWR VPWR _1273_ sky130_fd_sc_hd__nand2_1
Xinput6 s_tdata[12] VGND VGND VPWR VPWR net6 sky130_fd_sc_hd__dlymetal6s2s_1
X_3001_ _0257_ _0256_ VGND VGND VPWR VPWR _0259_ sky130_fd_sc_hd__and2b_1
XFILLER_0_19_429 VGND VGND VPWR VPWR sky130_fd_sc_hd__fill_2
X_3903_ net146 _0715_ _1127_ _1128_ _0420_ VGND VGND VPWR VPWR _0132_ sky130_fd_sc_hd__o221a_1
X_3834_ _1005_ _0997_ _1060_ VGND VGND VPWR VPWR _1061_ sky130_fd_sc_hd__a21boi_2
XFILLER_0_46_237 VGND VGND VPWR VPWR sky130_fd_sc_hd__decap_6
XTAP_TAPCELL_ROW_62_699 VGND VPWR sky130_fd_sc_hd__tapvpwrvgnd_1
XFILLER_0_27_440 VGND VGND VPWR VPWR sky130_fd_sc_hd__decap_8
XFILLER_0_6_378 VGND VGND VPWR VPWR sky130_fd_sc_hd__decap_4
X_3765_ _0445_ _1853_ _1850_ _0449_ VGND VGND VPWR VPWR _0993_ sky130_fd_sc_hd__a22oi_1
XFILLER_0_42_421 VGND VGND VPWR VPWR sky130_fd_sc_hd__decap_4
X_3696_ _0847_ _0874_ _0925_ VGND VGND VPWR VPWR _0926_ sky130_fd_sc_hd__a21oi_2
X_2716_ _2067_ u_interface.u_compute_core.mac_accum\[25\] VGND VGND VPWR VPWR _2125_
+ sky130_fd_sc_hd__xor2_1
XFILLER_0_14_189 VGND VGND VPWR VPWR sky130_fd_sc_hd__fill_1
X_2647_ _2064_ VGND VGND VPWR VPWR _2066_ sky130_fd_sc_hd__clkbuf_4
XFILLER_0_65_3 VPWR VGND VPWR VGND sky130_ef_sc_hd__decap_12
X_2578_ _2002_ _2005_ net130 _2006_ VGND VGND VPWR VPWR _0064_ sky130_fd_sc_hd__a2bb2o_1
X_4317_ _1532_ _1533_ VGND VGND VPWR VPWR _1534_ sky130_fd_sc_hd__nor2_1
X_4248_ u_interface.core_attn_out\[22\] _1466_ VGND VGND VPWR VPWR _1467_ sky130_fd_sc_hd__xnor2_2
X_4179_ _1395_ _1396_ _1398_ VGND VGND VPWR VPWR _1399_ sky130_fd_sc_hd__and3_1
XPHY_EDGE_ROW_14_Right_14 VGND VGND VPWR VPWR sky130_fd_sc_hd__decap_3
XFILLER_0_18_473 VGND VGND VPWR VPWR sky130_fd_sc_hd__decap_3
XFILLER_0_45_281 VPWR VGND VPWR VGND sky130_ef_sc_hd__decap_12
XFILLER_0_52_218 VGND VGND VPWR VPWR sky130_fd_sc_hd__fill_2
XFILLER_0_52_229 VGND VGND VPWR VPWR sky130_fd_sc_hd__decap_3
XFILLER_0_20_148 VPWR VGND VPWR VGND sky130_ef_sc_hd__decap_12
XPHY_EDGE_ROW_23_Right_23 VGND VGND VPWR VPWR sky130_fd_sc_hd__decap_3
XTAP_TAPCELL_ROW_16_313 VGND VPWR sky130_fd_sc_hd__tapvpwrvgnd_1
XFILLER_0_68_340 VGND VGND VPWR VPWR sky130_fd_sc_hd__fill_1
XPHY_EDGE_ROW_32_Right_32 VGND VGND VPWR VPWR sky130_fd_sc_hd__decap_3
XFILLER_0_28_259 VGND VGND VPWR VPWR sky130_fd_sc_hd__decap_3
XFILLER_0_22_89 VPWR VGND VPWR VGND sky130_ef_sc_hd__decap_12
X_3550_ _0774_ _0782_ VGND VGND VPWR VPWR _0783_ sky130_fd_sc_hd__xnor2_2
XFILLER_0_3_337 VPWR VGND VPWR VGND sky130_ef_sc_hd__decap_12
XFILLER_0_51_262 VGND VGND VPWR VPWR sky130_fd_sc_hd__fill_2
X_2501_ _1931_ _1945_ VGND VGND VPWR VPWR _1946_ sky130_fd_sc_hd__and2_1
X_3481_ _1966_ VGND VGND VPWR VPWR _0715_ sky130_fd_sc_hd__clkbuf_4
XPHY_EDGE_ROW_41_Right_41 VGND VGND VPWR VPWR sky130_fd_sc_hd__decap_3
X_2432_ u_interface.u_compute_core.relu_data\[27\] VGND VGND VPWR VPWR _1898_ sky130_fd_sc_hd__inv_2
X_2363_ net155 _1815_ _1846_ _1843_ VGND VGND VPWR VPWR _1847_ sky130_fd_sc_hd__o2bb2a_1
X_4102_ _1305_ _1303_ VGND VGND VPWR VPWR _1323_ sky130_fd_sc_hd__or2b_1
X_4033_ _1195_ _1204_ _1255_ VGND VGND VPWR VPWR _1256_ sky130_fd_sc_hd__o21a_1
XTAP_TAPCELL_ROW_67_747 VGND VPWR sky130_fd_sc_hd__tapvpwrvgnd_1
XFILLER_0_2_77 VGND VGND VPWR VPWR sky130_fd_sc_hd__decap_6
XPHY_EDGE_ROW_50_Right_50 VGND VGND VPWR VPWR sky130_fd_sc_hd__decap_3
XFILLER_0_19_204 VGND VGND VPWR VPWR sky130_fd_sc_hd__decap_4
XFILLER_0_74_321 VPWR VGND VPWR VGND sky130_ef_sc_hd__decap_12
XFILLER_0_19_237 VGND VGND VPWR VPWR sky130_fd_sc_hd__decap_4
XTAP_TAPCELL_ROW_50_603 VGND VPWR sky130_fd_sc_hd__tapvpwrvgnd_1
XFILLER_0_74_365 VGND VGND VPWR VPWR sky130_fd_sc_hd__decap_6
XFILLER_0_6_153 VPWR VGND VPWR VGND sky130_ef_sc_hd__decap_12
XFILLER_0_6_120 VPWR VGND VPWR VGND sky130_ef_sc_hd__decap_12
XFILLER_0_27_281 VGND VGND VPWR VPWR sky130_fd_sc_hd__fill_2
X_4797_ clknet_4_11_0_clk _0162_ VGND VGND VPWR VPWR net32 sky130_fd_sc_hd__dfxtp_1
X_3817_ _1040_ _1043_ VGND VGND VPWR VPWR _1044_ sky130_fd_sc_hd__xnor2_1
X_3748_ _0974_ _0976_ VGND VGND VPWR VPWR _0977_ sky130_fd_sc_hd__xnor2_1
XFILLER_0_6_197 VPWR VGND VPWR VGND sky130_ef_sc_hd__decap_12
X_3679_ u_interface.u_compute_core.relu_data\[7\] _0596_ VGND VGND VPWR VPWR _0909_
+ sky130_fd_sc_hd__and2b_1
XFILLER_0_10_170 VPWR VGND VPWR VGND sky130_ef_sc_hd__decap_12
XFILLER_0_80_313 VPWR VGND VPWR VGND sky130_ef_sc_hd__decap_12
XFILLER_0_80_368 VPWR VGND VPWR VGND sky130_ef_sc_hd__decap_12
XTAP_TAPCELL_ROW_64_717 VGND VPWR sky130_fd_sc_hd__tapvpwrvgnd_1
X_2981_ _0238_ VGND VGND VPWR VPWR _0239_ sky130_fd_sc_hd__inv_2
XFILLER_0_8_407 VGND VGND VPWR VPWR sky130_fd_sc_hd__decap_3
XFILLER_0_33_44 VGND VGND VPWR VPWR sky130_fd_sc_hd__decap_4
X_4720_ clknet_4_5_0_clk _0085_ VGND VGND VPWR VPWR u_interface.u_compute_core.mac_accum\[26\]
+ sky130_fd_sc_hd__dfxtp_1
XFILLER_0_8_429 VGND VGND VPWR VPWR sky130_fd_sc_hd__fill_2
XFILLER_0_71_324 VPWR VGND VPWR VGND sky130_ef_sc_hd__decap_12
X_4651_ clknet_4_6_0_clk _0016_ VGND VGND VPWR VPWR u_interface.u_compute_core.relu_data\[16\]
+ sky130_fd_sc_hd__dfxtp_1
X_3602_ _0747_ _0792_ VGND VGND VPWR VPWR _0834_ sky130_fd_sc_hd__and2_4
Xinput20 s_tdata[3] VGND VGND VPWR VPWR net20 sky130_fd_sc_hd__buf_1
XFILLER_0_24_251 VGND VGND VPWR VPWR sky130_fd_sc_hd__fill_1
X_4582_ _1811_ VGND VGND VPWR VPWR _1775_ sky130_fd_sc_hd__clkbuf_2
XFILLER_0_3_167 VGND VGND VPWR VPWR sky130_fd_sc_hd__fill_1
X_3533_ _0459_ _0422_ _1853_ _1850_ VGND VGND VPWR VPWR _0766_ sky130_fd_sc_hd__and4_1
X_3464_ _0651_ _0632_ _0698_ VGND VGND VPWR VPWR _0699_ sky130_fd_sc_hd__o21a_1
XFILLER_0_58_41 VGND VGND VPWR VPWR sky130_fd_sc_hd__decap_4
XFILLER_0_58_74 VGND VGND VPWR VPWR sky130_fd_sc_hd__decap_8
X_2415_ u_interface.u_compute_core.scaled_data\[22\] _1814_ _1885_ _1816_ VGND VGND
+ VPWR VPWR _1886_ sky130_fd_sc_hd__o2bb2a_1
X_3395_ _0627_ _0630_ VGND VGND VPWR VPWR _0631_ sky130_fd_sc_hd__xor2_1
XFILLER_0_58_85 VPWR VGND VPWR VGND sky130_ef_sc_hd__decap_12
X_2346_ net151 _1815_ _1833_ _1817_ VGND VGND VPWR VPWR _1834_ sky130_fd_sc_hd__o2bb2a_1
XFILLER_0_79_424 VGND VGND VPWR VPWR sky130_fd_sc_hd__fill_1
XTAP_TAPCELL_ROW_27_408 VGND VPWR sky130_fd_sc_hd__tapvpwrvgnd_1
XFILLER_0_28_3 VGND VGND VPWR VPWR sky130_fd_sc_hd__decap_4
X_4016_ _0431_ _1151_ VGND VGND VPWR VPWR _1239_ sky130_fd_sc_hd__nand2_1
XTAP_TAPCELL_ROW_35_474 VGND VPWR sky130_fd_sc_hd__tapvpwrvgnd_1
XFILLER_0_74_195 VGND VGND VPWR VPWR sky130_fd_sc_hd__fill_1
XFILLER_0_62_368 VGND VGND VPWR VPWR sky130_fd_sc_hd__decap_4
XFILLER_0_38_365 VGND VGND VPWR VPWR sky130_fd_sc_hd__decap_8
XFILLER_0_80_121 VPWR VGND VPWR VGND sky130_ef_sc_hd__decap_12
XFILLER_0_53_335 VGND VGND VPWR VPWR sky130_fd_sc_hd__fill_1
XFILLER_0_80_165 VPWR VGND VPWR VGND sky130_ef_sc_hd__decap_12
XFILLER_0_80_187 VGND VGND VPWR VPWR sky130_fd_sc_hd__decap_8
XFILLER_0_0_104 VGND VGND VPWR VPWR sky130_fd_sc_hd__decap_4
XFILLER_0_28_22 VGND VGND VPWR VPWR sky130_fd_sc_hd__decap_6
X_3180_ _0427_ VGND VGND VPWR VPWR _0428_ sky130_fd_sc_hd__buf_2
XTAP_TAPCELL_ROW_77_831 VGND VPWR sky130_fd_sc_hd__tapvpwrvgnd_1
XFILLER_0_29_321 VGND VGND VPWR VPWR sky130_fd_sc_hd__fill_1
XFILLER_0_48_118 VGND VGND VPWR VPWR sky130_fd_sc_hd__fill_1
X_2964_ _2312_ _2315_ _0221_ VGND VGND VPWR VPWR _0223_ sky130_fd_sc_hd__or3_1
XFILLER_0_29_365 VGND VGND VPWR VPWR sky130_fd_sc_hd__fill_2
XTAP_TAPCELL_ROW_32_444 VGND VPWR sky130_fd_sc_hd__tapvpwrvgnd_1
X_4703_ clknet_4_1_0_clk _0068_ VGND VGND VPWR VPWR u_interface.u_compute_core.mac_accum\[9\]
+ sky130_fd_sc_hd__dfxtp_1
XFILLER_0_56_151 VPWR VGND VPWR VGND sky130_ef_sc_hd__decap_12
X_2895_ _2274_ _2289_ VGND VGND VPWR VPWR _2290_ sky130_fd_sc_hd__nand2_1
X_4634_ _1810_ VGND VGND VPWR VPWR _0181_ sky130_fd_sc_hd__clkbuf_1
XFILLER_0_4_421 VPWR VGND VPWR VGND sky130_ef_sc_hd__decap_12
X_4565_ _1753_ _1763_ VGND VGND VPWR VPWR _1764_ sky130_fd_sc_hd__and2_1
X_3516_ net65 _0661_ _0706_ _0749_ VGND VGND VPWR VPWR _0750_ sky130_fd_sc_hd__a31o_1
XFILLER_0_69_51 VGND VGND VPWR VPWR sky130_fd_sc_hd__fill_1
XFILLER_0_69_84 VGND VGND VPWR VPWR sky130_fd_sc_hd__decap_6
X_4496_ _0443_ u_interface.u_compute_core.relu_data\[27\] VGND VGND VPWR VPWR _1709_
+ sky130_fd_sc_hd__nand2_1
XPHY_EDGE_ROW_4_Right_4 VGND VGND VPWR VPWR sky130_fd_sc_hd__decap_3
XFILLER_0_69_95 VPWR VGND VPWR VGND sky130_ef_sc_hd__decap_12
XFILLER_0_12_298 VGND VGND VPWR VPWR sky130_fd_sc_hd__decap_6
X_3447_ _0679_ _0681_ VGND VGND VPWR VPWR _0682_ sky130_fd_sc_hd__nor2_1
X_3378_ u_interface.core_attn_out\[4\] _0614_ VGND VGND VPWR VPWR _0615_ sky130_fd_sc_hd__and2_1
X_2329_ u_interface.u_compute_core.relu_data\[1\] VGND VGND VPWR VPWR _1821_ sky130_fd_sc_hd__buf_6
XFILLER_0_79_221 VGND VGND VPWR VPWR sky130_fd_sc_hd__decap_3
Xclkbuf_4_8_0_clk clknet_0_clk VGND VGND VPWR VPWR clknet_4_8_0_clk sky130_fd_sc_hd__clkbuf_8
XFILLER_0_62_165 VGND VGND VPWR VPWR sky130_fd_sc_hd__decap_6
XTAP_TAPCELL_ROW_74_801 VGND VPWR sky130_fd_sc_hd__tapvpwrvgnd_1
XTAP_TAPCELL_ROW_46_569 VGND VPWR sky130_fd_sc_hd__tapvpwrvgnd_1
XFILLER_0_58_427 VGND VGND VPWR VPWR sky130_fd_sc_hd__fill_2
XFILLER_0_26_335 VPWR VGND VPWR VGND sky130_ef_sc_hd__decap_12
X_2680_ _2066_ u_interface.u_compute_core.mac_accum\[20\] VGND VGND VPWR VPWR _2094_
+ sky130_fd_sc_hd__xor2_1
XFILLER_0_41_327 VGND VGND VPWR VPWR sky130_fd_sc_hd__fill_2
X_4350_ u_interface.core_attn_out\[24\] _1566_ VGND VGND VPWR VPWR _1567_ sky130_fd_sc_hd__xor2_1
X_3301_ _0537_ _0539_ VGND VGND VPWR VPWR _0540_ sky130_fd_sc_hd__xnor2_1
X_4281_ _1493_ _1498_ VGND VGND VPWR VPWR _1499_ sky130_fd_sc_hd__xnor2_1
X_3232_ _0424_ _1824_ _1821_ _0428_ VGND VGND VPWR VPWR _0473_ sky130_fd_sc_hd__a22o_1
X_3163_ _0412_ _0414_ VGND VGND VPWR VPWR _0415_ sky130_fd_sc_hd__xnor2_1
X_3094_ _0347_ _0348_ VGND VGND VPWR VPWR _0349_ sky130_fd_sc_hd__nand2_2
XFILLER_0_12_6 VGND VGND VPWR VPWR sky130_fd_sc_hd__decap_6
XFILLER_0_49_438 VGND VGND VPWR VPWR sky130_fd_sc_hd__decap_8
XFILLER_0_49_449 VGND VGND VPWR VPWR sky130_fd_sc_hd__fill_2
XTAP_TAPCELL_ROW_80_859 VGND VPWR sky130_fd_sc_hd__tapvpwrvgnd_1
XFILLER_0_29_173 VGND VGND VPWR VPWR sky130_fd_sc_hd__fill_1
X_3996_ _1215_ _1219_ VGND VGND VPWR VPWR _1220_ sky130_fd_sc_hd__xnor2_1
X_2947_ _2161_ _2163_ _0205_ VGND VGND VPWR VPWR _0206_ sky130_fd_sc_hd__a21o_1
X_4617_ net47 u_interface.core_attn_out\[26\] _1782_ VGND VGND VPWR VPWR _1799_ sky130_fd_sc_hd__mux2_1
XFILLER_0_4_251 VGND VGND VPWR VPWR sky130_fd_sc_hd__fill_1
X_2878_ _2032_ _2272_ _2273_ _2100_ net93 VGND VGND VPWR VPWR _0097_ sky130_fd_sc_hd__a32o_1
X_4548_ _1953_ _1751_ VGND VGND VPWR VPWR _1752_ sky130_fd_sc_hd__and2_1
X_4479_ _1690_ _1692_ VGND VGND VPWR VPWR _1693_ sky130_fd_sc_hd__xnor2_1
XPHY_EDGE_ROW_79_Right_79 VGND VGND VPWR VPWR sky130_fd_sc_hd__decap_3
XTAP_TAPCELL_ROW_0_172 VGND VPWR sky130_fd_sc_hd__tapvpwrvgnd_1
XTAP_TAPCELL_ROW_43_539 VGND VPWR sky130_fd_sc_hd__tapvpwrvgnd_1
XFILLER_0_67_246 VGND VGND VPWR VPWR sky130_fd_sc_hd__decap_8
XFILLER_0_35_110 VGND VGND VPWR VPWR sky130_fd_sc_hd__fill_2
XFILLER_0_58_257 VGND VGND VPWR VPWR sky130_fd_sc_hd__fill_1
X_3850_ _1075_ _1076_ VGND VGND VPWR VPWR _1077_ sky130_fd_sc_hd__and2_1
X_2801_ _2183_ _2197_ VGND VGND VPWR VPWR _2199_ sky130_fd_sc_hd__or2_1
X_3781_ _1006_ _1008_ VGND VGND VPWR VPWR _1009_ sky130_fd_sc_hd__xnor2_1
X_2732_ _2136_ _2137_ _2004_ VGND VGND VPWR VPWR _2139_ sky130_fd_sc_hd__a21oi_1
XTAP_TAPCELL_ROW_14_296 VGND VPWR sky130_fd_sc_hd__tapvpwrvgnd_1
XFILLER_0_41_99 VPWR VGND VPWR VGND sky130_ef_sc_hd__decap_12
XFILLER_0_81_293 VPWR VGND VPWR VGND sky130_ef_sc_hd__decap_12
XFILLER_0_81_271 VGND VGND VPWR VPWR sky130_fd_sc_hd__decap_8
XFILLER_0_41_113 VGND VGND VPWR VPWR sky130_fd_sc_hd__fill_2
XFILLER_0_14_349 VPWR VGND VPWR VGND sky130_ef_sc_hd__decap_12
X_2663_ _2066_ u_interface.u_compute_core.mac_accum\[17\] VGND VGND VPWR VPWR _2080_
+ sky130_fd_sc_hd__xnor2_1
X_4402_ _1580_ _1582_ _1579_ VGND VGND VPWR VPWR _1617_ sky130_fd_sc_hd__o21ba_1
X_2594_ _1972_ VGND VGND VPWR VPWR _2020_ sky130_fd_sc_hd__clkbuf_4
X_4333_ _0428_ _0424_ u_interface.u_compute_core.relu_data\[27\] u_interface.u_compute_core.relu_data\[26\]
+ VGND VGND VPWR VPWR _1550_ sky130_fd_sc_hd__and4_1
X_4264_ _1480_ _1481_ VGND VGND VPWR VPWR _1482_ sky130_fd_sc_hd__xnor2_1
X_3215_ u_interface.u_compute_core.u_av.v_extended\[0\] VGND VGND VPWR VPWR _0456_
+ sky130_fd_sc_hd__buf_4
XFILLER_0_5_55 VGND VGND VPWR VPWR sky130_fd_sc_hd__fill_1
XFILLER_0_5_66 VPWR VGND VPWR VGND sky130_ef_sc_hd__decap_12
XFILLER_0_66_41 VPWR VGND VPWR VGND sky130_ef_sc_hd__decap_12
X_4195_ _1413_ _1414_ VGND VGND VPWR VPWR _1415_ sky130_fd_sc_hd__or2_1
X_3146_ _0376_ _0377_ _0379_ VGND VGND VPWR VPWR _0399_ sky130_fd_sc_hd__o21a_1
X_3077_ _0331_ _0332_ net118 _2026_ VGND VGND VPWR VPWR _0102_ sky130_fd_sc_hd__a2bb2o_1
XFILLER_0_10_3 VGND VGND VPWR VPWR sky130_fd_sc_hd__decap_6
XFILLER_0_49_257 VPWR VGND VPWR VGND sky130_ef_sc_hd__decap_12
XFILLER_0_9_343 VGND VGND VPWR VPWR sky130_fd_sc_hd__decap_8
XFILLER_0_64_238 VGND VGND VPWR VPWR sky130_fd_sc_hd__fill_2
X_3979_ _1201_ _1202_ VGND VGND VPWR VPWR _1203_ sky130_fd_sc_hd__nor2_1
XFILLER_0_60_433 VGND VGND VPWR VPWR sky130_fd_sc_hd__decap_4
XFILLER_0_60_477 VGND VGND VPWR VPWR sky130_fd_sc_hd__decap_3
XFILLER_0_13_393 VPWR VGND VPWR VGND sky130_ef_sc_hd__decap_12
XTAP_TAPCELL_ROW_5_220 VGND VPWR sky130_fd_sc_hd__tapvpwrvgnd_1
XTAP_TAPCELL_ROW_56_653 VGND VPWR sky130_fd_sc_hd__tapvpwrvgnd_1
XFILLER_0_28_419 VGND VGND VPWR VPWR sky130_fd_sc_hd__fill_1
XFILLER_0_36_430 VGND VGND VPWR VPWR sky130_fd_sc_hd__fill_1
XFILLER_0_23_113 VGND VGND VPWR VPWR sky130_fd_sc_hd__fill_2
XFILLER_0_63_260 VPWR VGND VPWR VGND sky130_ef_sc_hd__decap_12
XTAP_TAPCELL_ROW_11_266 VGND VPWR sky130_fd_sc_hd__tapvpwrvgnd_1
XFILLER_0_11_69 VGND VGND VPWR VPWR sky130_fd_sc_hd__decap_4
XFILLER_0_23_124 VPWR VGND VPWR VGND sky130_ef_sc_hd__decap_12
XFILLER_0_63_293 VPWR VGND VPWR VGND sky130_ef_sc_hd__decap_12
XFILLER_0_51_477 VGND VGND VPWR VPWR sky130_fd_sc_hd__decap_6
Xinput7 s_tdata[13] VGND VGND VPWR VPWR net7 sky130_fd_sc_hd__clkbuf_2
X_3000_ _0256_ _0257_ VGND VGND VPWR VPWR _0258_ sky130_fd_sc_hd__and2b_1
X_3902_ _1124_ _1126_ _1967_ VGND VGND VPWR VPWR _1128_ sky130_fd_sc_hd__a21o_1
XFILLER_0_46_216 VGND VGND VPWR VPWR sky130_fd_sc_hd__fill_1
XFILLER_0_52_54 VGND VGND VPWR VPWR sky130_fd_sc_hd__fill_1
X_3833_ _1002_ _1004_ VGND VGND VPWR VPWR _1060_ sky130_fd_sc_hd__nand2_1
XFILLER_0_6_335 VGND VGND VPWR VPWR sky130_fd_sc_hd__fill_2
XFILLER_0_61_208 VPWR VGND VPWR VGND sky130_ef_sc_hd__decap_12
X_3764_ _0948_ _0991_ VGND VGND VPWR VPWR _0992_ sky130_fd_sc_hd__xnor2_1
XFILLER_0_42_400 VPWR VGND VPWR VGND sky130_ef_sc_hd__decap_12
X_3695_ _0873_ _0871_ VGND VGND VPWR VPWR _0925_ sky130_fd_sc_hd__and2b_1
X_2715_ _2068_ u_interface.u_compute_core.mac_accum\[24\] VGND VGND VPWR VPWR _2124_
+ sky130_fd_sc_hd__and2_1
X_2646_ _2064_ u_interface.u_compute_core.mac_accum\[15\] VGND VGND VPWR VPWR _2065_
+ sky130_fd_sc_hd__nand2_1
XFILLER_0_77_51 VGND VGND VPWR VPWR sky130_fd_sc_hd__decap_4
XFILLER_0_10_341 VPWR VGND VPWR VGND sky130_ef_sc_hd__decap_12
X_2577_ _1979_ VGND VGND VPWR VPWR _2006_ sky130_fd_sc_hd__buf_2
XFILLER_0_58_3 VPWR VGND VPWR VGND sky130_ef_sc_hd__decap_12
X_4316_ _0439_ _1890_ _1880_ _0454_ VGND VGND VPWR VPWR _1533_ sky130_fd_sc_hd__a22oi_1
XFILLER_0_10_396 VGND VGND VPWR VPWR sky130_fd_sc_hd__decap_4
X_4247_ _1424_ _1462_ _1464_ _1465_ VGND VGND VPWR VPWR _1466_ sky130_fd_sc_hd__o211a_1
X_4178_ _1397_ VGND VGND VPWR VPWR _1398_ sky130_fd_sc_hd__inv_2
X_3129_ _0381_ _0382_ VGND VGND VPWR VPWR _0383_ sky130_fd_sc_hd__or2_1
XTAP_TAPCELL_ROW_53_623 VGND VPWR sky130_fd_sc_hd__tapvpwrvgnd_1
XFILLER_0_77_363 VGND VGND VPWR VPWR sky130_fd_sc_hd__fill_1
XFILLER_0_9_140 VPWR VGND VPWR VGND sky130_ef_sc_hd__decap_12
XFILLER_0_37_238 VPWR VGND VPWR VGND sky130_ef_sc_hd__decap_12
XFILLER_0_45_271 VGND VGND VPWR VPWR sky130_fd_sc_hd__decap_8
XFILLER_0_45_293 VGND VGND VPWR VPWR sky130_fd_sc_hd__decap_6
XFILLER_0_60_230 VGND VGND VPWR VPWR sky130_fd_sc_hd__fill_1
XFILLER_0_20_127 VPWR VGND VPWR VGND sky130_ef_sc_hd__decap_12
XFILLER_0_60_296 VGND VGND VPWR VPWR sky130_fd_sc_hd__fill_1
XTAP_TAPCELL_ROW_16_314 VGND VPWR sky130_fd_sc_hd__tapvpwrvgnd_1
XFILLER_0_28_216 VGND VGND VPWR VPWR sky130_fd_sc_hd__decap_4
XTAP_TAPCELL_ROW_24_380 VGND VPWR sky130_fd_sc_hd__tapvpwrvgnd_1
XFILLER_0_3_305 VPWR VGND VPWR VGND sky130_ef_sc_hd__decap_12
X_3480_ _0480_ _0712_ _0714_ _0667_ VGND VGND VPWR VPWR _0123_ sky130_fd_sc_hd__o211a_1
XFILLER_0_3_349 VPWR VGND VPWR VGND sky130_ef_sc_hd__decap_12
XFILLER_0_24_477 VGND VGND VPWR VPWR sky130_fd_sc_hd__decap_3
XFILLER_0_51_252 VGND VGND VPWR VPWR sky130_fd_sc_hd__fill_1
X_2500_ u_interface.u_compute_core.scaled_data\[19\] u_interface.u_compute_core.mac_accum\[22\]
+ _1944_ VGND VGND VPWR VPWR _1945_ sky130_fd_sc_hd__mux2_1
X_2431_ _1879_ _1897_ VGND VGND VPWR VPWR _0026_ sky130_fd_sc_hd__nor2_1
X_2362_ _1845_ VGND VGND VPWR VPWR _1846_ sky130_fd_sc_hd__inv_2
X_4101_ _0938_ _1321_ _1322_ _0420_ VGND VGND VPWR VPWR _0136_ sky130_fd_sc_hd__o211a_1
X_4032_ _1192_ _1194_ VGND VGND VPWR VPWR _1255_ sky130_fd_sc_hd__or2_1
XTAP_TAPCELL_ROW_67_748 VGND VPWR sky130_fd_sc_hd__tapvpwrvgnd_1
XFILLER_0_74_333 VGND VGND VPWR VPWR sky130_fd_sc_hd__decap_6
XFILLER_0_19_216 VGND VGND VPWR VPWR sky130_fd_sc_hd__decap_8
XTAP_TAPCELL_ROW_50_604 VGND VPWR sky130_fd_sc_hd__tapvpwrvgnd_1
X_4796_ clknet_4_10_0_clk _0161_ VGND VGND VPWR VPWR net31 sky130_fd_sc_hd__dfxtp_1
XFILLER_0_6_132 VGND VGND VPWR VPWR sky130_fd_sc_hd__decap_8
X_3816_ _1041_ _1042_ VGND VGND VPWR VPWR _1043_ sky130_fd_sc_hd__or2_1
XFILLER_0_6_165 VPWR VGND VPWR VGND sky130_ef_sc_hd__decap_12
X_3747_ _0927_ _0930_ _0975_ VGND VGND VPWR VPWR _0976_ sky130_fd_sc_hd__a21oi_1
X_3678_ _0441_ u_interface.u_compute_core.relu_data\[10\] VGND VGND VPWR VPWR _0908_
+ sky130_fd_sc_hd__nand2_1
X_2629_ _2048_ _2050_ _2004_ VGND VGND VPWR VPWR _2051_ sky130_fd_sc_hd__a21oi_1
XFILLER_0_10_182 VPWR VGND VPWR VGND sky130_ef_sc_hd__decap_12
XFILLER_0_80_325 VPWR VGND VPWR VGND sky130_ef_sc_hd__decap_12
XFILLER_0_25_208 VGND VGND VPWR VPWR sky130_fd_sc_hd__fill_2
XFILLER_0_65_399 VPWR VGND VPWR VGND sky130_ef_sc_hd__decap_12
XFILLER_0_33_252 VGND VGND VPWR VPWR sky130_fd_sc_hd__fill_1
XTAP_TAPCELL_ROW_64_718 VGND VPWR sky130_fd_sc_hd__tapvpwrvgnd_1
X_2980_ _0236_ _0237_ VGND VGND VPWR VPWR _0238_ sky130_fd_sc_hd__xor2_1
XFILLER_0_8_419 VGND VGND VPWR VPWR sky130_fd_sc_hd__fill_1
XTAP_TAPCELL_ROW_72_784 VGND VPWR sky130_fd_sc_hd__tapvpwrvgnd_1
X_4650_ clknet_4_6_0_clk _0015_ VGND VGND VPWR VPWR u_interface.u_compute_core.relu_data\[15\]
+ sky130_fd_sc_hd__dfxtp_2
Xinput21 s_tdata[4] VGND VGND VPWR VPWR net21 sky130_fd_sc_hd__buf_1
Xinput10 s_tdata[16] VGND VGND VPWR VPWR net10 sky130_fd_sc_hd__dlymetal6s2s_1
X_3601_ _0830_ _0832_ VGND VGND VPWR VPWR _0833_ sky130_fd_sc_hd__xor2_4
XFILLER_0_3_113 VPWR VGND VPWR VGND sky130_ef_sc_hd__decap_12
X_4581_ _1774_ VGND VGND VPWR VPWR _0164_ sky130_fd_sc_hd__clkbuf_1
XFILLER_0_24_285 VPWR VGND VPWR VGND sky130_ef_sc_hd__decap_12
X_3532_ _0457_ _1853_ _1850_ _0460_ VGND VGND VPWR VPWR _0765_ sky130_fd_sc_hd__a22oi_1
X_3463_ _0648_ _0650_ VGND VGND VPWR VPWR _0698_ sky130_fd_sc_hd__or2_1
X_2414_ _1884_ VGND VGND VPWR VPWR _1885_ sky130_fd_sc_hd__inv_2
X_3394_ _0586_ _0628_ _0629_ VGND VGND VPWR VPWR _0630_ sky130_fd_sc_hd__o21a_1
XFILLER_0_58_97 VGND VGND VPWR VPWR sky130_fd_sc_hd__fill_2
X_2345_ _1832_ VGND VGND VPWR VPWR _1833_ sky130_fd_sc_hd__inv_2
XFILLER_0_74_41 VPWR VGND VPWR VGND sky130_ef_sc_hd__decap_12
XFILLER_0_74_85 VPWR VGND VPWR VGND sky130_ef_sc_hd__decap_12
X_4015_ _1236_ _1237_ VGND VGND VPWR VPWR _1238_ sky130_fd_sc_hd__nor2_1
XTAP_TAPCELL_ROW_27_409 VGND VPWR sky130_fd_sc_hd__tapvpwrvgnd_1
XFILLER_0_74_141 VPWR VGND VPWR VGND sky130_ef_sc_hd__decap_12
XTAP_TAPCELL_ROW_35_475 VGND VPWR sky130_fd_sc_hd__tapvpwrvgnd_1
XFILLER_0_62_325 VPWR VGND VPWR VGND sky130_ef_sc_hd__decap_12
X_4779_ clknet_4_12_0_clk _0144_ VGND VGND VPWR VPWR u_interface.core_attn_out\[27\]
+ sky130_fd_sc_hd__dfxtp_1
XFILLER_0_30_277 VGND VGND VPWR VPWR sky130_fd_sc_hd__fill_2
XFILLER_0_38_300 VGND VGND VPWR VPWR sky130_fd_sc_hd__fill_1
XFILLER_0_65_163 VGND VGND VPWR VPWR sky130_fd_sc_hd__decap_4
XFILLER_0_80_133 VGND VGND VPWR VPWR sky130_fd_sc_hd__decap_6
XFILLER_0_80_177 VGND VGND VPWR VPWR sky130_fd_sc_hd__decap_3
XTAP_TAPCELL_ROW_77_832 VGND VPWR sky130_fd_sc_hd__tapvpwrvgnd_1
XTAP_TAPCELL_ROW_49_589 VGND VPWR sky130_fd_sc_hd__tapvpwrvgnd_1
XFILLER_0_76_417 VGND VGND VPWR VPWR sky130_fd_sc_hd__decap_3
XFILLER_0_29_300 VGND VGND VPWR VPWR sky130_fd_sc_hd__decap_3
X_2963_ _2312_ _2315_ _0221_ VGND VGND VPWR VPWR _0222_ sky130_fd_sc_hd__o21ai_1
XFILLER_0_56_141 VGND VGND VPWR VPWR sky130_fd_sc_hd__fill_1
XTAP_TAPCELL_ROW_32_445 VGND VPWR sky130_fd_sc_hd__tapvpwrvgnd_1
X_4702_ clknet_4_1_0_clk _0067_ VGND VGND VPWR VPWR u_interface.u_compute_core.mac_accum\[8\]
+ sky130_fd_sc_hd__dfxtp_1
XFILLER_0_56_163 VPWR VGND VPWR VGND sky130_ef_sc_hd__decap_12
X_2894_ _2287_ _2288_ VGND VGND VPWR VPWR _2289_ sky130_fd_sc_hd__or2_1
X_4633_ _1901_ _1809_ VGND VGND VPWR VPWR _1810_ sky130_fd_sc_hd__and2_1
XFILLER_0_8_11 VGND VGND VPWR VPWR sky130_fd_sc_hd__fill_2
XFILLER_0_4_433 VPWR VGND VPWR VGND sky130_ef_sc_hd__decap_12
X_4564_ net60 u_interface.core_attn_out\[9\] _1760_ VGND VGND VPWR VPWR _1763_ sky130_fd_sc_hd__mux2_1
XFILLER_0_12_244 VGND VGND VPWR VPWR sky130_fd_sc_hd__decap_8
X_3515_ _0659_ _0748_ _0705_ VGND VGND VPWR VPWR _0749_ sky130_fd_sc_hd__a21o_1
XFILLER_0_4_477 VGND VGND VPWR VPWR sky130_fd_sc_hd__decap_6
X_4495_ _0454_ _1891_ VGND VGND VPWR VPWR _1708_ sky130_fd_sc_hd__nand2_1
X_3446_ _0445_ _1829_ _0458_ _0680_ VGND VGND VPWR VPWR _0681_ sky130_fd_sc_hd__a22oi_1
X_3377_ net68 _0613_ VGND VGND VPWR VPWR _0614_ sky130_fd_sc_hd__xor2_1
XFILLER_0_40_3 VGND VGND VPWR VPWR sky130_fd_sc_hd__decap_3
X_2328_ net2 VGND VGND VPWR VPWR _1820_ sky130_fd_sc_hd__buf_2
XFILLER_0_79_200 VGND VGND VPWR VPWR sky130_fd_sc_hd__decap_3
XFILLER_0_67_439 VGND VGND VPWR VPWR sky130_fd_sc_hd__fill_1
XFILLER_0_35_358 VGND VGND VPWR VPWR sky130_fd_sc_hd__decap_4
XFILLER_0_43_391 VGND VGND VPWR VPWR sky130_fd_sc_hd__fill_1
XTAP_TAPCELL_ROW_74_802 VGND VPWR sky130_fd_sc_hd__tapvpwrvgnd_1
XFILLER_0_14_25 VGND VGND VPWR VPWR sky130_fd_sc_hd__decap_3
XFILLER_0_14_69 VGND VGND VPWR VPWR sky130_fd_sc_hd__fill_1
XFILLER_0_26_347 VPWR VGND VPWR VGND sky130_ef_sc_hd__decap_12
XFILLER_0_66_483 VGND VGND VPWR VPWR sky130_fd_sc_hd__fill_1
XFILLER_0_81_475 VGND VGND VPWR VPWR sky130_fd_sc_hd__fill_1
XFILLER_0_30_79 VGND VGND VPWR VPWR sky130_fd_sc_hd__decap_4
XFILLER_0_1_447 VGND VGND VPWR VPWR sky130_fd_sc_hd__fill_1
X_3300_ _0478_ _0502_ _0538_ VGND VGND VPWR VPWR _0539_ sky130_fd_sc_hd__o21ai_1
XFILLER_0_39_22 VGND VGND VPWR VPWR sky130_fd_sc_hd__decap_6
X_4280_ _1496_ _1497_ VGND VGND VPWR VPWR _1498_ sky130_fd_sc_hd__nor2_1
X_3231_ _0424_ _1825_ _0432_ VGND VGND VPWR VPWR _0472_ sky130_fd_sc_hd__a21o_1
X_3162_ _0347_ _0413_ VGND VGND VPWR VPWR _0414_ sky130_fd_sc_hd__xnor2_1
X_3093_ _0345_ _0346_ VGND VGND VPWR VPWR _0348_ sky130_fd_sc_hd__nand2_2
XFILLER_0_29_141 VGND VGND VPWR VPWR sky130_fd_sc_hd__decap_8
X_3995_ _1080_ _1217_ _1218_ VGND VGND VPWR VPWR _1219_ sky130_fd_sc_hd__a21oi_1
XFILLER_0_17_325 VGND VGND VPWR VPWR sky130_fd_sc_hd__decap_3
X_2946_ net25 _2163_ _2294_ VGND VGND VPWR VPWR _0205_ sky130_fd_sc_hd__o21ai_2
XFILLER_0_72_475 VGND VGND VPWR VPWR sky130_fd_sc_hd__fill_1
X_2877_ _2238_ _2239_ _2270_ _2271_ VGND VGND VPWR VPWR _2273_ sky130_fd_sc_hd__a22o_1
X_4616_ _1798_ VGND VGND VPWR VPWR _0175_ sky130_fd_sc_hd__clkbuf_1
X_4547_ net55 u_interface.core_attn_out\[4\] _1742_ VGND VGND VPWR VPWR _1751_ sky130_fd_sc_hd__mux2_1
X_4478_ _1656_ _1658_ _1691_ VGND VGND VPWR VPWR _1692_ sky130_fd_sc_hd__o21a_1
X_3429_ _0663_ _0664_ VGND VGND VPWR VPWR _0665_ sky130_fd_sc_hd__xor2_1
XTAP_TAPCELL_ROW_0_173 VGND VPWR sky130_fd_sc_hd__tapvpwrvgnd_1
XFILLER_0_48_483 VGND VGND VPWR VPWR sky130_fd_sc_hd__fill_1
XFILLER_0_35_144 VGND VGND VPWR VPWR sky130_fd_sc_hd__fill_1
XFILLER_0_50_125 VPWR VGND VPWR VGND sky130_ef_sc_hd__decap_12
XTAP_TAPCELL_ROW_8_240 VGND VPWR sky130_fd_sc_hd__tapvpwrvgnd_1
XFILLER_0_25_24 VGND VGND VPWR VPWR sky130_fd_sc_hd__decap_8
XFILLER_0_25_57 VGND VGND VPWR VPWR sky130_fd_sc_hd__fill_2
XFILLER_0_58_203 VGND VGND VPWR VPWR sky130_fd_sc_hd__fill_1
XFILLER_0_39_461 VPWR VGND VPWR VGND sky130_ef_sc_hd__decap_12
XFILLER_0_58_269 VPWR VGND VPWR VGND sky130_ef_sc_hd__decap_12
X_2800_ _2183_ _2197_ VGND VGND VPWR VPWR _2198_ sky130_fd_sc_hd__nand2_1
X_3780_ _0964_ _0956_ _1007_ VGND VGND VPWR VPWR _1008_ sky130_fd_sc_hd__a21oi_1
XFILLER_0_41_34 VGND VGND VPWR VPWR sky130_fd_sc_hd__decap_3
X_2731_ _2136_ _2137_ VGND VGND VPWR VPWR _2138_ sky130_fd_sc_hd__or2_1
XTAP_TAPCELL_ROW_14_297 VGND VPWR sky130_fd_sc_hd__tapvpwrvgnd_1
XFILLER_0_26_155 VPWR VGND VPWR VGND sky130_ef_sc_hd__decap_12
XFILLER_0_54_453 VGND VGND VPWR VPWR sky130_fd_sc_hd__decap_3
XFILLER_0_54_464 VPWR VGND VPWR VGND sky130_ef_sc_hd__decap_12
X_4401_ _1586_ _1589_ _1587_ VGND VGND VPWR VPWR _1616_ sky130_fd_sc_hd__o21ba_1
X_2662_ _2020_ _2078_ _2079_ _1980_ net138 VGND VGND VPWR VPWR _0075_ sky130_fd_sc_hd__a32o_1
X_2593_ _1973_ _2018_ _2019_ _1980_ net108 VGND VGND VPWR VPWR _0066_ sky130_fd_sc_hd__a32o_1
XFILLER_0_41_169 VGND VGND VPWR VPWR sky130_fd_sc_hd__decap_8
X_4332_ _0424_ u_interface.u_compute_core.relu_data\[27\] u_interface.u_compute_core.relu_data\[26\]
+ _0428_ VGND VGND VPWR VPWR _1549_ sky130_fd_sc_hd__a22oi_1
X_4263_ _1426_ _1429_ _1427_ VGND VGND VPWR VPWR _1481_ sky130_fd_sc_hd__o21ba_1
XFILLER_0_5_78 VGND VGND VPWR VPWR sky130_fd_sc_hd__decap_8
X_3214_ _1968_ net24 _0434_ _0455_ VGND VGND VPWR VPWR _0116_ sky130_fd_sc_hd__o211a_1
XFILLER_0_66_53 VGND VGND VPWR VPWR sky130_fd_sc_hd__decap_8
Xclkbuf_4_7_0_clk clknet_0_clk VGND VGND VPWR VPWR clknet_4_7_0_clk sky130_fd_sc_hd__clkbuf_8
XPHY_EDGE_ROW_19_Left_101 VGND VGND VPWR VPWR sky130_fd_sc_hd__decap_3
X_4194_ _1410_ _1412_ VGND VGND VPWR VPWR _1414_ sky130_fd_sc_hd__and2_1
X_3145_ _0349_ _0397_ VGND VGND VPWR VPWR _0398_ sky130_fd_sc_hd__xnor2_1
X_3076_ _0297_ _0295_ _0330_ _2032_ VGND VGND VPWR VPWR _0332_ sky130_fd_sc_hd__o31ai_1
XFILLER_0_49_225 VGND VGND VPWR VPWR sky130_fd_sc_hd__decap_8
XFILLER_0_9_333 VGND VGND VPWR VPWR sky130_fd_sc_hd__decap_3
XFILLER_0_37_409 VPWR VGND VPWR VGND sky130_ef_sc_hd__decap_12
XFILLER_0_49_269 VGND VGND VPWR VPWR sky130_fd_sc_hd__decap_8
XFILLER_0_64_217 VGND VGND VPWR VPWR sky130_fd_sc_hd__fill_2
XFILLER_0_17_111 VGND VGND VPWR VPWR sky130_fd_sc_hd__fill_1
XFILLER_0_17_100 VGND VGND VPWR VPWR sky130_fd_sc_hd__decap_8
X_3978_ _1198_ _1200_ _1196_ VGND VGND VPWR VPWR _1202_ sky130_fd_sc_hd__a21oi_1
XFILLER_0_9_388 VGND VGND VPWR VPWR sky130_fd_sc_hd__decap_4
X_2929_ _2164_ _0186_ net9 _0184_ VGND VGND VPWR VPWR _0188_ sky130_fd_sc_hd__and4bb_1
XPHY_EDGE_ROW_28_Left_110 VGND VGND VPWR VPWR sky130_fd_sc_hd__decap_3
XFILLER_0_20_309 VPWR VGND VPWR VGND sky130_ef_sc_hd__decap_12
XFILLER_0_13_372 VGND VGND VPWR VPWR sky130_fd_sc_hd__decap_8
XFILLER_0_40_191 VGND VGND VPWR VPWR sky130_fd_sc_hd__fill_2
XTAP_TAPCELL_ROW_5_221 VGND VPWR sky130_fd_sc_hd__tapvpwrvgnd_1
XTAP_TAPCELL_ROW_56_654 VGND VPWR sky130_fd_sc_hd__tapvpwrvgnd_1
XFILLER_0_36_442 VGND VGND VPWR VPWR sky130_fd_sc_hd__decap_3
XFILLER_0_48_291 VGND VGND VPWR VPWR sky130_fd_sc_hd__decap_4
XFILLER_0_36_475 VGND VGND VPWR VPWR sky130_fd_sc_hd__fill_1
XFILLER_0_63_272 VGND VGND VPWR VPWR sky130_fd_sc_hd__decap_8
XTAP_TAPCELL_ROW_11_267 VGND VPWR sky130_fd_sc_hd__tapvpwrvgnd_1
XFILLER_0_23_136 VGND VGND VPWR VPWR sky130_fd_sc_hd__decap_8
XFILLER_0_23_169 VGND VGND VPWR VPWR sky130_fd_sc_hd__decap_4
XFILLER_0_31_191 VGND VGND VPWR VPWR sky130_fd_sc_hd__decap_3
Xinput8 s_tdata[14] VGND VGND VPWR VPWR net8 sky130_fd_sc_hd__buf_1
XFILLER_0_78_309 VPWR VGND VPWR VGND sky130_ef_sc_hd__decap_12
XFILLER_0_36_56 VGND VGND VPWR VPWR sky130_fd_sc_hd__decap_4
XTAP_TAPCELL_ROW_19_334 VGND VPWR sky130_fd_sc_hd__tapvpwrvgnd_1
X_3901_ _1124_ _1126_ VGND VGND VPWR VPWR _1127_ sky130_fd_sc_hd__nor2_1
X_3832_ _1053_ _1058_ VGND VGND VPWR VPWR _1059_ sky130_fd_sc_hd__xnor2_1
XFILLER_0_6_303 VGND VGND VPWR VPWR sky130_fd_sc_hd__decap_4
X_3763_ _0987_ _0990_ VGND VGND VPWR VPWR _0991_ sky130_fd_sc_hd__xnor2_1
XFILLER_0_42_412 VGND VGND VPWR VPWR sky130_fd_sc_hd__decap_8
X_3694_ _0896_ _0923_ VGND VGND VPWR VPWR _0924_ sky130_fd_sc_hd__xnor2_2
XFILLER_0_42_445 VGND VGND VPWR VPWR sky130_fd_sc_hd__decap_6
X_2714_ _2020_ _2122_ _2123_ _2100_ net139 VGND VGND VPWR VPWR _0083_ sky130_fd_sc_hd__a32o_1
X_2645_ u_interface.u_compute_core.u_mac.product_reg\[15\] VGND VGND VPWR VPWR _2064_
+ sky130_fd_sc_hd__buf_2
XFILLER_0_10_353 VGND VGND VPWR VPWR sky130_fd_sc_hd__decap_8
X_2576_ _1994_ _1997_ _2001_ _2004_ VGND VGND VPWR VPWR _2005_ sky130_fd_sc_hd__a31o_1
X_4315_ _0453_ _0438_ u_interface.u_compute_core.relu_data\[24\] _1880_ VGND VGND
+ VPWR VPWR _1532_ sky130_fd_sc_hd__and4_1
XFILLER_0_10_375 VGND VGND VPWR VPWR sky130_fd_sc_hd__fill_1
X_4246_ _1413_ _1461_ VGND VGND VPWR VPWR _1465_ sky130_fd_sc_hd__nand2_1
X_4177_ _0427_ _0424_ _1890_ _1887_ VGND VGND VPWR VPWR _1397_ sky130_fd_sc_hd__and4_1
X_3128_ _0342_ _0343_ _0351_ VGND VGND VPWR VPWR _0382_ sky130_fd_sc_hd__o21a_1
X_3059_ _2256_ _0271_ _0273_ _0237_ VGND VGND VPWR VPWR _0315_ sky130_fd_sc_hd__o2bb2a_1
XTAP_TAPCELL_ROW_53_624 VGND VPWR sky130_fd_sc_hd__tapvpwrvgnd_1
XFILLER_0_9_152 VPWR VGND VPWR VGND sky130_ef_sc_hd__decap_12
XFILLER_0_20_106 VGND VGND VPWR VPWR sky130_fd_sc_hd__decap_4
XFILLER_0_60_253 VGND VGND VPWR VPWR sky130_fd_sc_hd__decap_8
XFILLER_0_20_139 VGND VGND VPWR VPWR sky130_fd_sc_hd__fill_1
XTAP_TAPCELL_ROW_16_315 VGND VPWR sky130_fd_sc_hd__tapvpwrvgnd_1
XFILLER_0_22_25 VGND VGND VPWR VPWR sky130_fd_sc_hd__decap_3
XTAP_TAPCELL_ROW_24_381 VGND VPWR sky130_fd_sc_hd__tapvpwrvgnd_1
XFILLER_0_36_261 VGND VGND VPWR VPWR sky130_fd_sc_hd__decap_3
XFILLER_0_3_317 VPWR VGND VPWR VGND sky130_ef_sc_hd__decap_12
XFILLER_0_51_220 VGND VGND VPWR VPWR sky130_fd_sc_hd__decap_4
X_2430_ net154 _1814_ _1896_ _1816_ VGND VGND VPWR VPWR _1897_ sky130_fd_sc_hd__o2bb2a_1
X_2361_ u_interface.u_compute_core.relu_data\[9\] VGND VGND VPWR VPWR _1845_ sky130_fd_sc_hd__clkbuf_4
X_4100_ u_interface.core_attn_out\[19\] _0713_ VGND VGND VPWR VPWR _1322_ sky130_fd_sc_hd__or2_1
X_4031_ _1244_ _1253_ VGND VGND VPWR VPWR _1254_ sky130_fd_sc_hd__xor2_1
XTAP_TAPCELL_ROW_67_749 VGND VPWR sky130_fd_sc_hd__tapvpwrvgnd_1
XFILLER_0_78_139 VGND VGND VPWR VPWR sky130_fd_sc_hd__fill_1
XFILLER_0_59_320 VPWR VGND VPWR VGND sky130_ef_sc_hd__decap_12
XFILLER_0_74_301 VGND VGND VPWR VPWR sky130_fd_sc_hd__fill_1
XTAP_TAPCELL_ROW_50_605 VGND VPWR sky130_fd_sc_hd__tapvpwrvgnd_1
XFILLER_0_15_401 VGND VGND VPWR VPWR sky130_fd_sc_hd__fill_1
X_4795_ clknet_4_10_0_clk _0160_ VGND VGND VPWR VPWR net30 sky130_fd_sc_hd__dfxtp_1
X_3815_ _0426_ _0422_ u_interface.u_compute_core.relu_data\[17\] u_interface.u_compute_core.relu_data\[16\]
+ VGND VGND VPWR VPWR _1042_ sky130_fd_sc_hd__and4_1
XFILLER_0_15_445 VGND VGND VPWR VPWR sky130_fd_sc_hd__decap_3
XFILLER_0_12_80 VGND VGND VPWR VPWR sky130_fd_sc_hd__decap_4
XFILLER_0_6_177 VPWR VGND VPWR VGND sky130_ef_sc_hd__decap_12
X_3746_ _0924_ _0926_ VGND VGND VPWR VPWR _0975_ sky130_fd_sc_hd__nor2_1
XFILLER_0_42_253 VPWR VGND VPWR VGND sky130_ef_sc_hd__decap_12
X_3677_ _0905_ _0906_ VGND VGND VPWR VPWR _0907_ sky130_fd_sc_hd__xnor2_2
XFILLER_0_42_286 VGND VGND VPWR VPWR sky130_fd_sc_hd__decap_8
XFILLER_0_70_3 VPWR VGND VPWR VGND sky130_ef_sc_hd__decap_12
X_2628_ _2040_ _2045_ _2042_ VGND VGND VPWR VPWR _2050_ sky130_fd_sc_hd__a21o_1
X_2559_ _1982_ _1984_ _1981_ VGND VGND VPWR VPWR _1990_ sky130_fd_sc_hd__a21bo_1
XFILLER_0_10_194 VGND VGND VPWR VPWR sky130_fd_sc_hd__fill_2
X_4229_ _1444_ _1446_ _1443_ VGND VGND VPWR VPWR _1448_ sky130_fd_sc_hd__a21oi_1
XTAP_TAPCELL_ROW_38_495 VGND VPWR sky130_fd_sc_hd__tapvpwrvgnd_1
XFILLER_0_77_172 VPWR VGND VPWR VGND sky130_ef_sc_hd__decap_12
XFILLER_0_77_161 VGND VGND VPWR VPWR sky130_fd_sc_hd__decap_6
XFILLER_0_65_345 VGND VGND VPWR VPWR sky130_fd_sc_hd__decap_3
XFILLER_0_80_337 VGND VGND VPWR VPWR sky130_fd_sc_hd__decap_8
XTAP_TAPCELL_ROW_21_351 VGND VPWR sky130_fd_sc_hd__tapvpwrvgnd_1
XFILLER_0_0_309 VPWR VGND VPWR VGND sky130_ef_sc_hd__decap_12
XFILLER_0_17_69 VGND VGND VPWR VPWR sky130_fd_sc_hd__fill_1
XTAP_TAPCELL_ROW_64_719 VGND VPWR sky130_fd_sc_hd__tapvpwrvgnd_1
XFILLER_0_33_57 VGND VGND VPWR VPWR sky130_fd_sc_hd__decap_6
XFILLER_0_56_312 VPWR VGND VPWR VGND sky130_ef_sc_hd__decap_12
XFILLER_0_68_183 VGND VGND VPWR VPWR sky130_fd_sc_hd__fill_1
XTAP_TAPCELL_ROW_72_785 VGND VPWR sky130_fd_sc_hd__tapvpwrvgnd_1
XFILLER_0_71_337 VPWR VGND VPWR VGND sky130_ef_sc_hd__decap_12
Xinput22 s_tdata[5] VGND VGND VPWR VPWR net22 sky130_fd_sc_hd__buf_1
Xinput11 s_tdata[17] VGND VGND VPWR VPWR net11 sky130_fd_sc_hd__clkbuf_1
X_3600_ _0763_ net77 _0831_ VGND VGND VPWR VPWR _0832_ sky130_fd_sc_hd__a21oi_4
X_4580_ _1753_ _1773_ VGND VGND VPWR VPWR _1774_ sky130_fd_sc_hd__and2_1
XFILLER_0_3_125 VPWR VGND VPWR VGND sky130_ef_sc_hd__decap_12
XFILLER_0_24_253 VGND VGND VPWR VPWR sky130_fd_sc_hd__decap_8
X_3531_ _0626_ _1841_ _0726_ _0724_ VGND VGND VPWR VPWR _0764_ sky130_fd_sc_hd__a31o_1
XFILLER_0_3_169 VPWR VGND VPWR VGND sky130_ef_sc_hd__decap_12
XFILLER_0_24_297 VGND VGND VPWR VPWR sky130_fd_sc_hd__decap_8
X_3462_ _0677_ _0696_ VGND VGND VPWR VPWR _0697_ sky130_fd_sc_hd__xor2_2
X_3393_ _0457_ _1841_ _1838_ _0460_ VGND VGND VPWR VPWR _0629_ sky130_fd_sc_hd__a22o_1
XFILLER_0_58_54 VGND VGND VPWR VPWR sky130_fd_sc_hd__decap_6
X_2413_ u_interface.u_compute_core.relu_data\[22\] VGND VGND VPWR VPWR _1884_ sky130_fd_sc_hd__clkbuf_4
X_2344_ u_interface.u_compute_core.relu_data\[5\] VGND VGND VPWR VPWR _1832_ sky130_fd_sc_hd__clkbuf_4
XFILLER_0_42_7 VPWR VGND VPWR VGND sky130_ef_sc_hd__decap_12
XFILLER_0_74_53 VPWR VGND VPWR VGND sky130_ef_sc_hd__decap_12
X_4014_ _0449_ _0445_ u_interface.u_compute_core.relu_data\[16\] u_interface.u_compute_core.relu_data\[15\]
+ VGND VGND VPWR VPWR _1237_ sky130_fd_sc_hd__and4_1
XFILLER_0_74_97 VGND VGND VPWR VPWR sky130_fd_sc_hd__decap_8
XTAP_TAPCELL_ROW_35_476 VGND VPWR sky130_fd_sc_hd__tapvpwrvgnd_1
XFILLER_0_74_153 VPWR VGND VPWR VGND sky130_ef_sc_hd__decap_12
XFILLER_0_62_304 VGND VGND VPWR VPWR sky130_fd_sc_hd__fill_1
XFILLER_0_62_337 VPWR VGND VPWR VGND sky130_ef_sc_hd__decap_12
X_4778_ clknet_4_13_0_clk _0143_ VGND VGND VPWR VPWR u_interface.core_attn_out\[26\]
+ sky130_fd_sc_hd__dfxtp_1
X_3729_ u_interface.u_compute_core.relu_data\[8\] _0596_ VGND VGND VPWR VPWR _0958_
+ sky130_fd_sc_hd__and2b_1
XFILLER_0_21_223 VGND VGND VPWR VPWR sky130_fd_sc_hd__fill_1
XFILLER_0_21_245 VGND VGND VPWR VPWR sky130_fd_sc_hd__decap_4
XFILLER_0_0_128 VPWR VGND VPWR VGND sky130_ef_sc_hd__decap_12
XTAP_TAPCELL_ROW_77_833 VGND VPWR sky130_fd_sc_hd__tapvpwrvgnd_1
XFILLER_0_28_68 VPWR VGND VPWR VGND sky130_ef_sc_hd__decap_12
X_2962_ _0219_ _0220_ VGND VGND VPWR VPWR _0221_ sky130_fd_sc_hd__and2_1
XTAP_TAPCELL_ROW_32_446 VGND VPWR sky130_fd_sc_hd__tapvpwrvgnd_1
X_4701_ clknet_4_0_0_clk _0066_ VGND VGND VPWR VPWR u_interface.u_compute_core.mac_accum\[7\]
+ sky130_fd_sc_hd__dfxtp_1
X_4632_ net53 u_interface.core_attn_out\[31\] u_interface.core_valid_out VGND VGND
+ VPWR VPWR _1809_ sky130_fd_sc_hd__mux2_1
X_2893_ _2280_ _2286_ VGND VGND VPWR VPWR _2288_ sky130_fd_sc_hd__and2_1
XFILLER_0_56_175 VGND VGND VPWR VPWR sky130_fd_sc_hd__fill_2
XFILLER_0_56_197 VGND VGND VPWR VPWR sky130_fd_sc_hd__decap_8
XFILLER_0_71_145 VGND VGND VPWR VPWR sky130_fd_sc_hd__fill_1
XFILLER_0_4_401 VPWR VGND VPWR VGND sky130_ef_sc_hd__decap_12
XFILLER_0_8_56 VPWR VGND VPWR VGND sky130_ef_sc_hd__decap_12
X_4563_ _1762_ VGND VGND VPWR VPWR _0158_ sky130_fd_sc_hd__clkbuf_1
XFILLER_0_4_445 VPWR VGND VPWR VGND sky130_ef_sc_hd__decap_12
X_4494_ _1664_ _1667_ _1665_ VGND VGND VPWR VPWR _1707_ sky130_fd_sc_hd__o21ba_1
X_3514_ _0701_ _0703_ VGND VGND VPWR VPWR _0748_ sky130_fd_sc_hd__or2b_1
X_3445_ _0551_ VGND VGND VPWR VPWR _0680_ sky130_fd_sc_hd__clkbuf_4
X_3376_ _0611_ _0612_ VGND VGND VPWR VPWR _0613_ sky130_fd_sc_hd__nor2_1
X_2327_ net94 _1813_ _1815_ _1819_ VGND VGND VPWR VPWR _0000_ sky130_fd_sc_hd__a31o_1
XFILLER_0_33_3 VGND VGND VPWR VPWR sky130_fd_sc_hd__decap_4
XFILLER_0_79_245 VGND VGND VPWR VPWR sky130_fd_sc_hd__fill_1
XFILLER_0_79_289 VGND VGND VPWR VPWR sky130_fd_sc_hd__fill_1
XFILLER_0_79_278 VGND VGND VPWR VPWR sky130_fd_sc_hd__fill_2
XFILLER_0_35_337 VGND VGND VPWR VPWR sky130_fd_sc_hd__fill_2
XFILLER_0_7_294 VGND VGND VPWR VPWR sky130_fd_sc_hd__fill_1
XTAP_TAPCELL_ROW_74_803 VGND VPWR sky130_fd_sc_hd__tapvpwrvgnd_1
XFILLER_0_58_418 VGND VGND VPWR VPWR sky130_fd_sc_hd__fill_2
XFILLER_0_14_48 VGND VGND VPWR VPWR sky130_fd_sc_hd__fill_1
XFILLER_0_66_451 VPWR VGND VPWR VGND sky130_ef_sc_hd__decap_12
XFILLER_0_26_359 VGND VGND VPWR VPWR sky130_fd_sc_hd__decap_4
XFILLER_0_41_307 VPWR VGND VPWR VGND sky130_ef_sc_hd__decap_12
XFILLER_0_53_156 VGND VGND VPWR VPWR sky130_fd_sc_hd__decap_8
XFILLER_0_39_45 VGND VGND VPWR VPWR sky130_fd_sc_hd__decap_8
X_3230_ _0466_ _0470_ VGND VGND VPWR VPWR _0471_ sky130_fd_sc_hd__xor2_1
X_3161_ _0308_ _0393_ VGND VGND VPWR VPWR _0413_ sky130_fd_sc_hd__nand2_1
X_3092_ _0345_ _0346_ VGND VGND VPWR VPWR _0347_ sky130_fd_sc_hd__or2_1
XTAP_TAPCELL_ROW_45_560 VGND VPWR sky130_fd_sc_hd__tapvpwrvgnd_1
X_3994_ _1117_ _1119_ _1164_ _1163_ VGND VGND VPWR VPWR _1218_ sky130_fd_sc_hd__a31o_1
X_2945_ _2276_ _2279_ _2277_ VGND VGND VPWR VPWR _0204_ sky130_fd_sc_hd__o21ba_1
X_2876_ _2238_ _2239_ _2270_ _2271_ VGND VGND VPWR VPWR _2272_ sky130_fd_sc_hd__nand4_1
XFILLER_0_44_134 VGND VGND VPWR VPWR sky130_fd_sc_hd__decap_6
XFILLER_0_32_307 VGND VGND VPWR VPWR sky130_fd_sc_hd__fill_1
X_4615_ _1901_ _1797_ VGND VGND VPWR VPWR _1798_ sky130_fd_sc_hd__and2_1
XFILLER_0_4_253 VPWR VGND VPWR VGND sky130_ef_sc_hd__decap_12
X_4546_ _1750_ VGND VGND VPWR VPWR _0153_ sky130_fd_sc_hd__clkbuf_1
XFILLER_0_20_91 VGND VGND VPWR VPWR sky130_fd_sc_hd__decap_8
X_4477_ u_interface.core_attn_out\[26\] _1655_ VGND VGND VPWR VPWR _1691_ sky130_fd_sc_hd__nand2_1
X_3428_ _0616_ _0618_ _0615_ VGND VGND VPWR VPWR _0664_ sky130_fd_sc_hd__a21oi_1
X_3359_ u_interface.u_compute_core.u_av.v_extended\[10\] VGND VGND VPWR VPWR _0596_
+ sky130_fd_sc_hd__buf_6
XPHY_EDGE_ROW_13_Left_95 VGND VGND VPWR VPWR sky130_fd_sc_hd__decap_3
XTAP_TAPCELL_ROW_0_174 VGND VPWR sky130_fd_sc_hd__tapvpwrvgnd_1
XFILLER_0_48_451 VGND VGND VPWR VPWR sky130_fd_sc_hd__decap_4
XFILLER_0_75_281 VGND VGND VPWR VPWR sky130_fd_sc_hd__decap_4
XFILLER_0_35_189 VGND VGND VPWR VPWR sky130_fd_sc_hd__fill_1
XFILLER_0_50_137 VGND VGND VPWR VPWR sky130_fd_sc_hd__decap_3
XFILLER_0_31_351 VGND VGND VPWR VPWR sky130_fd_sc_hd__fill_1
XFILLER_0_50_159 VPWR VGND VPWR VGND sky130_ef_sc_hd__decap_12
XTAP_TAPCELL_ROW_8_241 VGND VPWR sky130_fd_sc_hd__tapvpwrvgnd_1
XTAP_TAPCELL_ROW_59_674 VGND VPWR sky130_fd_sc_hd__tapvpwrvgnd_1
XFILLER_0_58_226 VPWR VGND VPWR VGND sky130_ef_sc_hd__decap_12
XTAP_TAPCELL_ROW_42_530 VGND VPWR sky130_fd_sc_hd__tapvpwrvgnd_1
XFILLER_0_26_101 VGND VGND VPWR VPWR sky130_fd_sc_hd__decap_3
XFILLER_0_39_473 VGND VGND VPWR VPWR sky130_fd_sc_hd__decap_6
XFILLER_0_54_421 VPWR VGND VPWR VGND sky130_ef_sc_hd__decap_12
X_2730_ _2131_ _2134_ VGND VGND VPWR VPWR _2137_ sky130_fd_sc_hd__nand2_1
XTAP_TAPCELL_ROW_14_298 VGND VPWR sky130_fd_sc_hd__tapvpwrvgnd_1
XFILLER_0_26_167 VGND VGND VPWR VPWR sky130_fd_sc_hd__decap_6
X_2661_ _2075_ _2077_ VGND VGND VPWR VPWR _2079_ sky130_fd_sc_hd__nand2_1
X_4400_ net124 _0715_ _0434_ _1615_ VGND VGND VPWR VPWR _0142_ sky130_fd_sc_hd__o211a_1
XFILLER_0_1_223 VGND VGND VPWR VPWR sky130_fd_sc_hd__fill_1
XFILLER_0_22_340 VGND VGND VPWR VPWR sky130_fd_sc_hd__decap_8
X_2592_ _2014_ _2015_ _2016_ VGND VGND VPWR VPWR _2019_ sky130_fd_sc_hd__a21o_1
X_4331_ _1484_ _1487_ VGND VGND VPWR VPWR _1548_ sky130_fd_sc_hd__nor2_1
XFILLER_0_22_384 VPWR VGND VPWR VGND sky130_ef_sc_hd__decap_12
X_4262_ _1478_ _1479_ VGND VGND VPWR VPWR _1480_ sky130_fd_sc_hd__xnor2_1
XFILLER_0_5_57 VGND VGND VPWR VPWR sky130_fd_sc_hd__decap_6
X_3213_ _0435_ _0454_ VGND VGND VPWR VPWR _0455_ sky130_fd_sc_hd__or2_1
X_4193_ _1410_ _1412_ VGND VGND VPWR VPWR _1413_ sky130_fd_sc_hd__nor2_1
X_3144_ _0395_ _0396_ VGND VGND VPWR VPWR _0397_ sky130_fd_sc_hd__nand2_1
X_3075_ _0297_ _0295_ _0330_ VGND VGND VPWR VPWR _0331_ sky130_fd_sc_hd__o21a_1
XFILLER_0_15_91 VGND VGND VPWR VPWR sky130_fd_sc_hd__decap_8
X_3977_ _1196_ _1198_ _1200_ VGND VGND VPWR VPWR _1201_ sky130_fd_sc_hd__and3_1
XFILLER_0_57_281 VPWR VGND VPWR VGND sky130_ef_sc_hd__decap_12
XFILLER_0_17_145 VGND VGND VPWR VPWR sky130_fd_sc_hd__fill_1
X_2928_ _2164_ _2275_ _0185_ _0186_ VGND VGND VPWR VPWR _0187_ sky130_fd_sc_hd__o22a_1
XFILLER_0_45_465 VGND VGND VPWR VPWR sky130_fd_sc_hd__fill_1
X_2859_ net25 net17 _2224_ VGND VGND VPWR VPWR _2255_ sky130_fd_sc_hd__and3_1
XFILLER_0_60_446 VGND VGND VPWR VPWR sky130_fd_sc_hd__fill_2
X_4529_ _1731_ _1735_ _1738_ VGND VGND VPWR VPWR _1739_ sky130_fd_sc_hd__and3_1
XTAP_TAPCELL_ROW_5_222 VGND VPWR sky130_fd_sc_hd__tapvpwrvgnd_1
XTAP_TAPCELL_ROW_56_655 VGND VPWR sky130_fd_sc_hd__tapvpwrvgnd_1
XFILLER_0_11_16 VGND VGND VPWR VPWR sky130_fd_sc_hd__decap_4
XFILLER_0_51_402 VGND VGND VPWR VPWR sky130_fd_sc_hd__decap_8
XTAP_TAPCELL_ROW_11_268 VGND VPWR sky130_fd_sc_hd__tapvpwrvgnd_1
Xinput9 s_tdata[15] VGND VGND VPWR VPWR net9 sky130_fd_sc_hd__buf_1
XTAP_TAPCELL_ROW_19_335 VGND VPWR sky130_fd_sc_hd__tapvpwrvgnd_1
X_3900_ _1125_ _1075_ VGND VGND VPWR VPWR _1126_ sky130_fd_sc_hd__nand2_1
X_3831_ _1056_ _1057_ VGND VGND VPWR VPWR _1058_ sky130_fd_sc_hd__xnor2_1
XFILLER_0_52_78 VGND VGND VPWR VPWR sky130_fd_sc_hd__decap_3
XFILLER_0_52_89 VGND VGND VPWR VPWR sky130_fd_sc_hd__fill_1
XFILLER_0_39_281 VGND VGND VPWR VPWR sky130_fd_sc_hd__decap_4
X_3762_ _0988_ _0989_ VGND VGND VPWR VPWR _0990_ sky130_fd_sc_hd__or2_1
X_3693_ _0920_ _0922_ VGND VGND VPWR VPWR _0923_ sky130_fd_sc_hd__xor2_2
XFILLER_0_42_435 VGND VGND VPWR VPWR sky130_fd_sc_hd__fill_1
X_2713_ _2119_ _2120_ _2117_ _2118_ _2096_ VGND VGND VPWR VPWR _2123_ sky130_fd_sc_hd__a2111o_1
X_2644_ _2020_ _2062_ _2063_ _1980_ net114 VGND VGND VPWR VPWR _0073_ sky130_fd_sc_hd__a32o_1
X_2575_ _2003_ VGND VGND VPWR VPWR _2004_ sky130_fd_sc_hd__clkbuf_4
X_4314_ _1492_ _1502_ _1530_ VGND VGND VPWR VPWR _1531_ sky130_fd_sc_hd__o21a_1
XFILLER_0_10_365 VGND VGND VPWR VPWR sky130_fd_sc_hd__decap_6
X_4245_ _1375_ _1374_ _1463_ _1415_ VGND VGND VPWR VPWR _1464_ sky130_fd_sc_hd__a211o_4
X_4176_ _0424_ _1890_ _1887_ _0428_ VGND VGND VPWR VPWR _1396_ sky130_fd_sc_hd__a22o_1
X_3127_ _0379_ _0380_ VGND VGND VPWR VPWR _0381_ sky130_fd_sc_hd__nand2_1
X_3058_ _0312_ _0313_ VGND VGND VPWR VPWR _0314_ sky130_fd_sc_hd__nor2_1
XTAP_TAPCELL_ROW_53_625 VGND VPWR sky130_fd_sc_hd__tapvpwrvgnd_1
XFILLER_0_77_376 VPWR VGND VPWR VGND sky130_ef_sc_hd__decap_12
XFILLER_0_9_131 VGND VGND VPWR VPWR sky130_fd_sc_hd__fill_1
XFILLER_0_9_164 VGND VGND VPWR VPWR sky130_fd_sc_hd__decap_4
XFILLER_0_18_421 VPWR VGND VPWR VGND sky130_ef_sc_hd__decap_12
XFILLER_0_18_454 VGND VGND VPWR VPWR sky130_fd_sc_hd__fill_2
XFILLER_0_33_413 VGND VGND VPWR VPWR sky130_fd_sc_hd__fill_1
XTAP_TAPCELL_ROW_61_691 VGND VPWR sky130_fd_sc_hd__tapvpwrvgnd_1
XFILLER_0_60_265 VPWR VGND VPWR VGND sky130_ef_sc_hd__decap_12
XFILLER_0_13_181 VPWR VGND VPWR VGND sky130_ef_sc_hd__decap_12
XFILLER_0_68_321 VGND VGND VPWR VPWR sky130_fd_sc_hd__fill_1
XTAP_TAPCELL_ROW_16_316 VGND VPWR sky130_fd_sc_hd__tapvpwrvgnd_1
XTAP_TAPCELL_ROW_24_382 VGND VPWR sky130_fd_sc_hd__tapvpwrvgnd_1
Xclkbuf_4_6_0_clk clknet_0_clk VGND VGND VPWR VPWR clknet_4_6_0_clk sky130_fd_sc_hd__clkbuf_8
XFILLER_0_24_446 VPWR VGND VPWR VGND sky130_ef_sc_hd__decap_12
XFILLER_0_36_273 VGND VGND VPWR VPWR sky130_fd_sc_hd__fill_1
XFILLER_0_3_329 VGND VGND VPWR VPWR sky130_fd_sc_hd__decap_6
XFILLER_0_51_232 VPWR VGND VPWR VGND sky130_ef_sc_hd__decap_12
XPHY_EDGE_ROW_47_Left_129 VGND VGND VPWR VPWR sky130_fd_sc_hd__decap_3
X_2360_ _1820_ _1844_ VGND VGND VPWR VPWR _0008_ sky130_fd_sc_hd__nor2_1
XPHY_EDGE_ROW_10_Right_10 VGND VGND VPWR VPWR sky130_fd_sc_hd__decap_3
X_4030_ _1199_ _1252_ VGND VGND VPWR VPWR _1253_ sky130_fd_sc_hd__xnor2_1
XPHY_EDGE_ROW_56_Left_138 VGND VGND VPWR VPWR sky130_fd_sc_hd__decap_3
XFILLER_0_59_332 VGND VGND VPWR VPWR sky130_fd_sc_hd__decap_4
XFILLER_0_63_55 VGND VGND VPWR VPWR sky130_fd_sc_hd__fill_1
XFILLER_0_74_379 VGND VGND VPWR VPWR sky130_fd_sc_hd__decap_4
X_4794_ clknet_4_10_0_clk _0159_ VGND VGND VPWR VPWR net60 sky130_fd_sc_hd__dfxtp_1
X_3814_ _0457_ _1871_ _1868_ _0426_ VGND VGND VPWR VPWR _1041_ sky130_fd_sc_hd__a22oi_1
X_3745_ _0943_ _0973_ VGND VGND VPWR VPWR _0974_ sky130_fd_sc_hd__xor2_2
XFILLER_0_6_189 VGND VGND VPWR VPWR sky130_fd_sc_hd__decap_6
XPHY_EDGE_ROW_65_Left_147 VGND VGND VPWR VPWR sky130_fd_sc_hd__decap_3
X_3676_ _0483_ _1856_ VGND VGND VPWR VPWR _0906_ sky130_fd_sc_hd__nand2_1
XFILLER_0_42_265 VGND VGND VPWR VPWR sky130_fd_sc_hd__fill_2
X_2627_ _2040_ _2045_ _2042_ _2048_ VGND VGND VPWR VPWR _2049_ sky130_fd_sc_hd__a211o_1
XFILLER_0_63_3 VPWR VGND VPWR VGND sky130_ef_sc_hd__decap_12
X_2558_ u_interface.u_compute_core.u_mac.product_reg\[3\] u_interface.u_compute_core.mac_accum\[3\]
+ VGND VGND VPWR VPWR _1989_ sky130_fd_sc_hd__or2_1
X_2489_ _1937_ VGND VGND VPWR VPWR _0044_ sky130_fd_sc_hd__clkbuf_1
X_4228_ _1443_ _1444_ _1446_ VGND VGND VPWR VPWR _1447_ sky130_fd_sc_hd__and3_1
XPHY_EDGE_ROW_74_Left_156 VGND VGND VPWR VPWR sky130_fd_sc_hd__decap_3
X_4159_ _0438_ _1246_ _1378_ VGND VGND VPWR VPWR _1379_ sky130_fd_sc_hd__a21oi_1
XFILLER_0_69_107 VGND VGND VPWR VPWR sky130_fd_sc_hd__decap_4
XTAP_TAPCELL_ROW_38_496 VGND VPWR sky130_fd_sc_hd__tapvpwrvgnd_1
XFILLER_0_77_184 VGND VGND VPWR VPWR sky130_fd_sc_hd__fill_1
XFILLER_0_18_251 VGND VGND VPWR VPWR sky130_fd_sc_hd__fill_1
XFILLER_0_65_379 VPWR VGND VPWR VGND sky130_ef_sc_hd__decap_12
XTAP_TAPCELL_ROW_21_352 VGND VPWR sky130_fd_sc_hd__tapvpwrvgnd_1
XFILLER_0_33_210 VGND VGND VPWR VPWR sky130_fd_sc_hd__decap_4
XFILLER_0_33_221 VGND VGND VPWR VPWR sky130_fd_sc_hd__decap_3
XFILLER_0_21_405 VGND VGND VPWR VPWR sky130_fd_sc_hd__fill_1
XFILLER_0_21_449 VGND VGND VPWR VPWR sky130_fd_sc_hd__fill_2
XPHY_EDGE_ROW_1_Left_83 VGND VGND VPWR VPWR sky130_fd_sc_hd__decap_3
XFILLER_0_68_162 VPWR VGND VPWR VGND sky130_ef_sc_hd__decap_12
XTAP_TAPCELL_ROW_72_786 VGND VPWR sky130_fd_sc_hd__tapvpwrvgnd_1
XFILLER_0_56_324 VGND VGND VPWR VPWR sky130_fd_sc_hd__fill_1
XFILLER_0_56_379 VGND VGND VPWR VPWR sky130_fd_sc_hd__fill_2
XFILLER_0_71_349 VPWR VGND VPWR VGND sky130_ef_sc_hd__decap_12
Xinput12 s_tdata[18] VGND VGND VPWR VPWR net12 sky130_fd_sc_hd__buf_1
XFILLER_0_24_221 VGND VGND VPWR VPWR sky130_fd_sc_hd__fill_1
Xinput23 s_tdata[6] VGND VGND VPWR VPWR net23 sky130_fd_sc_hd__buf_1
X_3530_ _0672_ _0721_ _0762_ VGND VGND VPWR VPWR _0763_ sky130_fd_sc_hd__a21o_1
XFILLER_0_24_243 VGND VGND VPWR VPWR sky130_fd_sc_hd__decap_8
XFILLER_0_3_137 VPWR VGND VPWR VGND sky130_ef_sc_hd__decap_12
X_3461_ _0695_ _0693_ VGND VGND VPWR VPWR _0696_ sky130_fd_sc_hd__xnor2_2
X_3392_ _0459_ _1841_ VGND VGND VPWR VPWR _0628_ sky130_fd_sc_hd__nand2_1
XFILLER_0_58_33 VGND VGND VPWR VPWR sky130_fd_sc_hd__fill_1
X_2412_ _1879_ _1883_ VGND VGND VPWR VPWR _0021_ sky130_fd_sc_hd__nor2_1
X_2343_ _1820_ _1831_ VGND VGND VPWR VPWR _0004_ sky130_fd_sc_hd__nor2_1
X_4013_ _0511_ u_interface.u_compute_core.relu_data\[16\] _1865_ _0680_ VGND VGND
+ VPWR VPWR _1236_ sky130_fd_sc_hd__a22oi_1
XFILLER_0_74_65 VPWR VGND VPWR VGND sky130_ef_sc_hd__decap_12
XTAP_TAPCELL_ROW_35_477 VGND VPWR sky130_fd_sc_hd__tapvpwrvgnd_1
XFILLER_0_47_335 VGND VGND VPWR VPWR sky130_fd_sc_hd__fill_1
XFILLER_0_59_184 VPWR VGND VPWR VGND sky130_ef_sc_hd__decap_12
XFILLER_0_74_165 VGND VGND VPWR VPWR sky130_fd_sc_hd__decap_3
XFILLER_0_23_80 VGND VGND VPWR VPWR sky130_fd_sc_hd__decap_8
XFILLER_0_62_349 VGND VGND VPWR VPWR sky130_fd_sc_hd__decap_3
X_4777_ clknet_4_12_0_clk _0142_ VGND VGND VPWR VPWR u_interface.core_attn_out\[25\]
+ sky130_fd_sc_hd__dfxtp_1
X_3728_ _0639_ u_interface.u_compute_core.relu_data\[11\] VGND VGND VPWR VPWR _0957_
+ sky130_fd_sc_hd__nand2_1
X_3659_ u_interface.core_attn_out\[9\] _0841_ _0795_ u_interface.core_attn_out\[8\]
+ VGND VGND VPWR VPWR _0890_ sky130_fd_sc_hd__o211a_1
XFILLER_0_30_257 VGND VGND VPWR VPWR sky130_fd_sc_hd__decap_8
XTAP_TAPCELL_ROW_26_400 VGND VPWR sky130_fd_sc_hd__tapvpwrvgnd_1
XFILLER_0_38_313 VGND VGND VPWR VPWR sky130_fd_sc_hd__fill_1
XFILLER_0_38_346 VGND VGND VPWR VPWR sky130_fd_sc_hd__fill_1
XFILLER_0_65_132 VGND VGND VPWR VPWR sky130_fd_sc_hd__decap_4
XFILLER_0_53_305 VPWR VGND VPWR VGND sky130_ef_sc_hd__decap_12
XFILLER_0_21_279 VGND VGND VPWR VPWR sky130_fd_sc_hd__fill_1
XTAP_TAPCELL_ROW_77_834 VGND VPWR sky130_fd_sc_hd__tapvpwrvgnd_1
XFILLER_0_69_460 VPWR VGND VPWR VGND sky130_ef_sc_hd__decap_12
X_2961_ _0214_ _0215_ _0218_ VGND VGND VPWR VPWR _0220_ sky130_fd_sc_hd__o21ai_1
XFILLER_0_29_335 VGND VGND VPWR VPWR sky130_fd_sc_hd__fill_1
XTAP_TAPCELL_ROW_32_447 VGND VPWR sky130_fd_sc_hd__tapvpwrvgnd_1
X_4700_ clknet_4_3_0_clk _0065_ VGND VGND VPWR VPWR u_interface.u_compute_core.mac_accum\[6\]
+ sky130_fd_sc_hd__dfxtp_1
X_4631_ _1808_ VGND VGND VPWR VPWR _0180_ sky130_fd_sc_hd__clkbuf_1
X_2892_ _2280_ _2286_ VGND VGND VPWR VPWR _2287_ sky130_fd_sc_hd__nor2_1
XFILLER_0_44_338 VGND VGND VPWR VPWR sky130_fd_sc_hd__decap_3
XFILLER_0_4_413 VGND VGND VPWR VPWR sky130_fd_sc_hd__decap_6
XFILLER_0_37_390 VGND VGND VPWR VPWR sky130_fd_sc_hd__fill_2
X_4562_ _1753_ _1761_ VGND VGND VPWR VPWR _1762_ sky130_fd_sc_hd__and2_1
XFILLER_0_4_457 VGND VGND VPWR VPWR sky130_fd_sc_hd__decap_3
X_4493_ _1670_ _1671_ _1673_ _1705_ _1668_ VGND VGND VPWR VPWR _1706_ sky130_fd_sc_hd__a32o_1
XFILLER_0_8_68 VGND VGND VPWR VPWR sky130_fd_sc_hd__fill_2
X_3513_ _0746_ _0744_ VGND VGND VPWR VPWR _0747_ sky130_fd_sc_hd__xor2_2
X_3444_ _0551_ _0634_ u_interface.u_compute_core.relu_data\[4\] _0458_ VGND VGND VPWR
+ VPWR _0679_ sky130_fd_sc_hd__and4_1
X_3375_ _0581_ _0582_ _0610_ VGND VGND VPWR VPWR _0612_ sky130_fd_sc_hd__nor3_1
X_2326_ _1817_ _1818_ _1812_ VGND VGND VPWR VPWR _1819_ sky130_fd_sc_hd__and3b_1
XFILLER_0_26_3 VPWR VGND VPWR VGND sky130_ef_sc_hd__decap_12
XTAP_TAPCELL_ROW_48_580 VGND VPWR sky130_fd_sc_hd__tapvpwrvgnd_1
XFILLER_0_47_121 VGND VGND VPWR VPWR sky130_fd_sc_hd__fill_1
XFILLER_0_75_452 VPWR VGND VPWR VGND sky130_ef_sc_hd__decap_12
XFILLER_0_47_143 VPWR VGND VPWR VGND sky130_ef_sc_hd__decap_12
XFILLER_0_43_360 VPWR VGND VPWR VGND sky130_ef_sc_hd__decap_12
XFILLER_0_43_393 VGND VGND VPWR VPWR sky130_fd_sc_hd__fill_1
XTAP_TAPCELL_ROW_74_804 VGND VPWR sky130_fd_sc_hd__tapvpwrvgnd_1
XFILLER_0_66_430 VPWR VGND VPWR VGND sky130_ef_sc_hd__decap_12
XFILLER_0_66_463 VPWR VGND VPWR VGND sky130_ef_sc_hd__decap_12
XFILLER_0_53_113 VGND VGND VPWR VPWR sky130_fd_sc_hd__fill_1
XFILLER_0_30_15 VGND VGND VPWR VPWR sky130_fd_sc_hd__decap_6
XFILLER_0_30_37 VGND VGND VPWR VPWR sky130_fd_sc_hd__fill_1
XFILLER_0_81_477 VGND VGND VPWR VPWR sky130_fd_sc_hd__decap_6
XFILLER_0_41_319 VGND VGND VPWR VPWR sky130_fd_sc_hd__decap_8
XFILLER_0_1_405 VPWR VGND VPWR VGND sky130_ef_sc_hd__decap_12
XFILLER_0_1_449 VPWR VGND VPWR VGND sky130_ef_sc_hd__decap_12
XFILLER_0_39_57 VGND VGND VPWR VPWR sky130_fd_sc_hd__decap_6
XFILLER_0_39_79 VGND VGND VPWR VPWR sky130_fd_sc_hd__fill_2
X_3160_ _0349_ _0397_ _0395_ VGND VGND VPWR VPWR _0412_ sky130_fd_sc_hd__o21a_1
X_3091_ _2168_ _2294_ _0306_ _0271_ VGND VGND VPWR VPWR _0346_ sky130_fd_sc_hd__a31o_1
XFILLER_0_76_205 VGND VGND VPWR VPWR sky130_fd_sc_hd__fill_1
XFILLER_0_71_55 VGND VGND VPWR VPWR sky130_fd_sc_hd__fill_1
XPHY_EDGE_ROW_8_Right_8 VGND VGND VPWR VPWR sky130_fd_sc_hd__decap_3
XFILLER_0_29_110 VGND VGND VPWR VPWR sky130_fd_sc_hd__fill_2
XTAP_TAPCELL_ROW_45_561 VGND VPWR sky130_fd_sc_hd__tapvpwrvgnd_1
X_3993_ _1082_ _1164_ _1216_ VGND VGND VPWR VPWR _1217_ sky130_fd_sc_hd__and3_1
X_2944_ _2297_ _2299_ VGND VGND VPWR VPWR _0203_ sky130_fd_sc_hd__nor2_1
X_2875_ _2241_ _2242_ _2269_ VGND VGND VPWR VPWR _2271_ sky130_fd_sc_hd__nand3_1
XFILLER_0_72_477 VGND VGND VPWR VPWR sky130_fd_sc_hd__decap_3
XFILLER_0_4_221 VPWR VGND VPWR VGND sky130_ef_sc_hd__decap_12
XFILLER_0_32_319 VGND VGND VPWR VPWR sky130_fd_sc_hd__decap_4
XFILLER_0_44_168 VGND VGND VPWR VPWR sky130_fd_sc_hd__decap_4
X_4614_ net46 u_interface.core_attn_out\[25\] _1782_ VGND VGND VPWR VPWR _1797_ sky130_fd_sc_hd__mux2_1
XFILLER_0_4_265 VPWR VGND VPWR VGND sky130_ef_sc_hd__decap_12
X_4545_ _1953_ _1749_ VGND VGND VPWR VPWR _1750_ sky130_fd_sc_hd__and2_1
XFILLER_0_40_341 VGND VGND VPWR VPWR sky130_fd_sc_hd__fill_1
XFILLER_0_40_363 VGND VGND VPWR VPWR sky130_fd_sc_hd__fill_1
X_4476_ _1688_ _1689_ VGND VGND VPWR VPWR _1690_ sky130_fd_sc_hd__or2_4
X_3427_ u_interface.core_attn_out\[5\] _0662_ VGND VGND VPWR VPWR _0663_ sky130_fd_sc_hd__xnor2_1
XPHY_EDGE_ROW_39_Right_39 VGND VGND VPWR VPWR sky130_fd_sc_hd__decap_3
X_3358_ _0591_ _0594_ VGND VGND VPWR VPWR _0595_ sky130_fd_sc_hd__xnor2_1
XFILLER_0_29_90 VPWR VGND VPWR VGND sky130_ef_sc_hd__decap_12
X_3289_ _0506_ _0526_ _0527_ VGND VGND VPWR VPWR _0528_ sky130_fd_sc_hd__nand3_2
XTAP_TAPCELL_ROW_0_164 VGND VPWR sky130_fd_sc_hd__tapvpwrvgnd_1
XTAP_TAPCELL_ROW_0_175 VGND VPWR sky130_fd_sc_hd__tapvpwrvgnd_1
XPHY_EDGE_ROW_48_Right_48 VGND VGND VPWR VPWR sky130_fd_sc_hd__decap_3
XFILLER_0_35_113 VPWR VGND VPWR VGND sky130_ef_sc_hd__decap_12
XFILLER_0_50_149 VGND VGND VPWR VPWR sky130_fd_sc_hd__fill_1
XPHY_EDGE_ROW_57_Right_57 VGND VGND VPWR VPWR sky130_fd_sc_hd__decap_3
XTAP_TAPCELL_ROW_8_242 VGND VPWR sky130_fd_sc_hd__tapvpwrvgnd_1
XTAP_TAPCELL_ROW_59_675 VGND VPWR sky130_fd_sc_hd__tapvpwrvgnd_1
XFILLER_0_58_238 VPWR VGND VPWR VGND sky130_ef_sc_hd__decap_12
XPHY_EDGE_ROW_66_Right_66 VGND VGND VPWR VPWR sky130_fd_sc_hd__decap_3
XTAP_TAPCELL_ROW_42_531 VGND VPWR sky130_fd_sc_hd__tapvpwrvgnd_1
XFILLER_0_54_433 VPWR VGND VPWR VGND sky130_ef_sc_hd__decap_12
XTAP_TAPCELL_ROW_14_299 VGND VPWR sky130_fd_sc_hd__tapvpwrvgnd_1
XFILLER_0_54_477 VGND VGND VPWR VPWR sky130_fd_sc_hd__decap_3
X_2660_ _2075_ _2077_ VGND VGND VPWR VPWR _2078_ sky130_fd_sc_hd__or2_1
XPHY_EDGE_ROW_75_Right_75 VGND VGND VPWR VPWR sky130_fd_sc_hd__decap_3
X_2591_ _2017_ VGND VGND VPWR VPWR _2018_ sky130_fd_sc_hd__inv_2
X_4330_ _1544_ _1546_ VGND VGND VPWR VPWR _1547_ sky130_fd_sc_hd__xnor2_1
XFILLER_0_22_396 VGND VGND VPWR VPWR sky130_fd_sc_hd__decap_8
XFILLER_0_1_279 VGND VGND VPWR VPWR sky130_fd_sc_hd__fill_1
X_4261_ _0443_ _1884_ VGND VGND VPWR VPWR _1479_ sky130_fd_sc_hd__nand2_1
X_3212_ _0453_ VGND VGND VPWR VPWR _0454_ sky130_fd_sc_hd__clkbuf_4
X_4192_ _1354_ _1355_ _1411_ VGND VGND VPWR VPWR _1412_ sky130_fd_sc_hd__o21a_1
XFILLER_0_66_66 VGND VGND VPWR VPWR sky130_fd_sc_hd__decap_8
X_3143_ _0371_ _0374_ _0394_ VGND VGND VPWR VPWR _0396_ sky130_fd_sc_hd__nand3_1
X_3074_ _0328_ _0329_ VGND VGND VPWR VPWR _0330_ sky130_fd_sc_hd__nor2_1
XFILLER_0_45_400 VPWR VGND VPWR VGND sky130_ef_sc_hd__decap_12
X_3976_ _1199_ VGND VGND VPWR VPWR _1200_ sky130_fd_sc_hd__inv_2
XFILLER_0_9_379 VGND VGND VPWR VPWR sky130_fd_sc_hd__fill_2
X_2927_ net12 net13 net7 net8 VGND VGND VPWR VPWR _0186_ sky130_fd_sc_hd__and4_1
XFILLER_0_45_433 VGND VGND VPWR VPWR sky130_fd_sc_hd__decap_3
XFILLER_0_45_444 VGND VGND VPWR VPWR sky130_fd_sc_hd__decap_4
XFILLER_0_57_293 VGND VGND VPWR VPWR sky130_fd_sc_hd__decap_4
X_2858_ _2168_ _2182_ _2216_ _2215_ VGND VGND VPWR VPWR _2254_ sky130_fd_sc_hd__a31o_1
XFILLER_0_32_138 VGND VGND VPWR VPWR sky130_fd_sc_hd__fill_2
X_2789_ _2187_ VGND VGND VPWR VPWR _2188_ sky130_fd_sc_hd__inv_2
X_4528_ u_interface.core_attn_out\[31\] net86 VGND VGND VPWR VPWR _1738_ sky130_fd_sc_hd__xnor2_1
X_4459_ _1628_ _1672_ VGND VGND VPWR VPWR _1673_ sky130_fd_sc_hd__or2_1
XTAP_TAPCELL_ROW_56_656 VGND VPWR sky130_fd_sc_hd__tapvpwrvgnd_1
XFILLER_0_55_208 VPWR VGND VPWR VGND sky130_ef_sc_hd__decap_12
XFILLER_0_63_241 VGND VGND VPWR VPWR sky130_fd_sc_hd__fill_1
XTAP_TAPCELL_ROW_11_269 VGND VPWR sky130_fd_sc_hd__tapvpwrvgnd_1
XFILLER_0_36_69 VPWR VGND VPWR VGND sky130_ef_sc_hd__decap_12
XTAP_TAPCELL_ROW_19_336 VGND VPWR sky130_fd_sc_hd__tapvpwrvgnd_1
XFILLER_0_52_46 VGND VGND VPWR VPWR sky130_fd_sc_hd__decap_8
X_3830_ _0483_ _1865_ VGND VGND VPWR VPWR _1057_ sky130_fd_sc_hd__nand2_1
XFILLER_0_46_208 VGND VGND VPWR VPWR sky130_fd_sc_hd__decap_8
X_3761_ _0426_ _0422_ _1868_ _1865_ VGND VGND VPWR VPWR _0989_ sky130_fd_sc_hd__and4_1
X_2712_ _2121_ VGND VGND VPWR VPWR _2122_ sky130_fd_sc_hd__inv_2
X_3692_ _0853_ net80 _0921_ VGND VGND VPWR VPWR _0922_ sky130_fd_sc_hd__o21ai_2
X_2643_ _2059_ _2061_ VGND VGND VPWR VPWR _2063_ sky130_fd_sc_hd__nand2_1
X_2574_ _1811_ _1969_ VGND VGND VPWR VPWR _2003_ sky130_fd_sc_hd__nand2_2
X_4313_ _1489_ _1491_ VGND VGND VPWR VPWR _1530_ sky130_fd_sc_hd__or2_1
X_4244_ _1461_ VGND VGND VPWR VPWR _1463_ sky130_fd_sc_hd__inv_2
X_4175_ _0432_ _1246_ _1336_ _1335_ VGND VGND VPWR VPWR _1395_ sky130_fd_sc_hd__a31o_1
X_3126_ _0349_ _0378_ VGND VGND VPWR VPWR _0380_ sky130_fd_sc_hd__nand2_1
XFILLER_0_77_311 VGND VGND VPWR VPWR sky130_fd_sc_hd__decap_4
X_3057_ _0268_ _0275_ _0311_ VGND VGND VPWR VPWR _0313_ sky130_fd_sc_hd__nor3_1
XFILLER_0_77_355 VGND VGND VPWR VPWR sky130_fd_sc_hd__decap_8
XTAP_TAPCELL_ROW_53_626 VGND VPWR sky130_fd_sc_hd__tapvpwrvgnd_1
XFILLER_0_77_388 VGND VGND VPWR VPWR sky130_fd_sc_hd__decap_4
XFILLER_0_18_433 VGND VGND VPWR VPWR sky130_fd_sc_hd__decap_4
XFILLER_0_18_477 VGND VGND VPWR VPWR sky130_fd_sc_hd__decap_6
X_3959_ _1181_ _1182_ VGND VGND VPWR VPWR _1183_ sky130_fd_sc_hd__xnor2_1
XTAP_TAPCELL_ROW_61_692 VGND VPWR sky130_fd_sc_hd__tapvpwrvgnd_1
XFILLER_0_5_393 VPWR VGND VPWR VGND sky130_ef_sc_hd__decap_12
XFILLER_0_60_277 VPWR VGND VPWR VGND sky130_ef_sc_hd__decap_12
XFILLER_0_13_193 VGND VGND VPWR VPWR sky130_fd_sc_hd__fill_2
XFILLER_0_68_344 VGND VGND VPWR VPWR sky130_fd_sc_hd__decap_3
XTAP_TAPCELL_ROW_24_383 VGND VPWR sky130_fd_sc_hd__tapvpwrvgnd_1
XFILLER_0_24_414 VGND VGND VPWR VPWR sky130_fd_sc_hd__fill_1
XFILLER_0_24_458 VGND VGND VPWR VPWR sky130_fd_sc_hd__decap_3
XFILLER_0_51_244 VGND VGND VPWR VPWR sky130_fd_sc_hd__decap_8
XFILLER_0_2_15 VPWR VGND VPWR VGND sky130_ef_sc_hd__decap_12
XFILLER_0_63_78 VPWR VGND VPWR VGND sky130_ef_sc_hd__decap_12
XFILLER_0_19_208 VGND VGND VPWR VPWR sky130_fd_sc_hd__fill_1
X_3813_ _0430_ _1862_ _0995_ _0994_ VGND VGND VPWR VPWR _1040_ sky130_fd_sc_hd__a31o_1
X_4793_ clknet_4_10_0_clk _0158_ VGND VGND VPWR VPWR net59 sky130_fd_sc_hd__dfxtp_1
X_3744_ _0945_ _0972_ VGND VGND VPWR VPWR _0973_ sky130_fd_sc_hd__xnor2_2
X_3675_ _0903_ _0904_ VGND VGND VPWR VPWR _0905_ sky130_fd_sc_hd__nor2_1
XFILLER_0_30_428 VGND VGND VPWR VPWR sky130_fd_sc_hd__fill_2
X_2626_ _2046_ _2047_ VGND VGND VPWR VPWR _2048_ sky130_fd_sc_hd__nand2_1
XFILLER_0_2_363 VGND VGND VPWR VPWR sky130_fd_sc_hd__fill_1
X_2557_ u_interface.u_compute_core.u_mac.product_reg\[3\] u_interface.u_compute_core.mac_accum\[3\]
+ VGND VGND VPWR VPWR _1988_ sky130_fd_sc_hd__nand2_1
XFILLER_0_56_3 VPWR VGND VPWR VGND sky130_ef_sc_hd__decap_12
X_2488_ _1931_ _1936_ VGND VGND VPWR VPWR _1937_ sky130_fd_sc_hd__and2_1
X_4227_ _1445_ VGND VGND VPWR VPWR _1446_ sky130_fd_sc_hd__inv_2
X_4158_ u_interface.u_compute_core.relu_data\[17\] _0453_ VGND VGND VPWR VPWR _1378_
+ sky130_fd_sc_hd__and2b_1
X_3109_ _0328_ _0331_ _0362_ _2032_ VGND VGND VPWR VPWR _0364_ sky130_fd_sc_hd__o31ai_1
X_4089_ _1277_ _1259_ _1310_ VGND VGND VPWR VPWR _1311_ sky130_fd_sc_hd__a21oi_1
XTAP_TAPCELL_ROW_66_740 VGND VPWR sky130_fd_sc_hd__tapvpwrvgnd_1
XTAP_TAPCELL_ROW_38_497 VGND VPWR sky130_fd_sc_hd__tapvpwrvgnd_1
XTAP_TAPCELL_ROW_21_353 VGND VPWR sky130_fd_sc_hd__tapvpwrvgnd_1
XTAP_TAPCELL_ROW_29_420 VGND VPWR sky130_fd_sc_hd__tapvpwrvgnd_1
XFILLER_0_33_26 VGND VGND VPWR VPWR sky130_fd_sc_hd__fill_1
XFILLER_0_33_48 VGND VGND VPWR VPWR sky130_fd_sc_hd__fill_1
XFILLER_0_68_141 VGND VGND VPWR VPWR sky130_fd_sc_hd__decap_8
XFILLER_0_68_174 VGND VGND VPWR VPWR sky130_fd_sc_hd__fill_1
XTAP_TAPCELL_ROW_72_787 VGND VPWR sky130_fd_sc_hd__tapvpwrvgnd_1
Xinput13 s_tdata[19] VGND VGND VPWR VPWR net13 sky130_fd_sc_hd__dlymetal6s2s_1
Xinput24 s_tdata[7] VGND VGND VPWR VPWR net24 sky130_fd_sc_hd__buf_1
XFILLER_0_3_105 VGND VGND VPWR VPWR sky130_fd_sc_hd__decap_6
XFILLER_0_3_149 VPWR VGND VPWR VGND sky130_ef_sc_hd__decap_12
XFILLER_0_24_277 VGND VGND VPWR VPWR sky130_fd_sc_hd__fill_1
X_3460_ _0647_ _0638_ _0694_ VGND VGND VPWR VPWR _0695_ sky130_fd_sc_hd__a21oi_1
X_3391_ _0626_ _1832_ _0593_ _0592_ VGND VGND VPWR VPWR _0627_ sky130_fd_sc_hd__a31o_1
XFILLER_0_58_45 VGND VGND VPWR VPWR sky130_fd_sc_hd__fill_1
X_2411_ u_interface.u_compute_core.scaled_data\[21\] _1814_ _1882_ _1816_ VGND VGND
+ VPWR VPWR _1883_ sky130_fd_sc_hd__o2bb2a_1
X_2342_ u_interface.u_compute_core.scaled_data\[4\] _1815_ _1830_ _1817_ VGND VGND
+ VPWR VPWR _1831_ sky130_fd_sc_hd__o2bb2a_1
X_4012_ _1232_ _1234_ VGND VGND VPWR VPWR _1235_ sky130_fd_sc_hd__xor2_1
XFILLER_0_74_77 VGND VGND VPWR VPWR sky130_fd_sc_hd__decap_6
XFILLER_0_79_439 VGND VGND VPWR VPWR sky130_fd_sc_hd__decap_4
XTAP_TAPCELL_ROW_63_710 VGND VPWR sky130_fd_sc_hd__tapvpwrvgnd_1
XFILLER_0_47_314 VGND VGND VPWR VPWR sky130_fd_sc_hd__decap_4
XFILLER_0_59_152 VPWR VGND VPWR VGND sky130_ef_sc_hd__decap_12
XFILLER_0_59_196 VPWR VGND VPWR VGND sky130_ef_sc_hd__decap_12
XFILLER_0_15_200 VPWR VGND VPWR VGND sky130_ef_sc_hd__decap_12
X_4776_ clknet_4_13_0_clk _0141_ VGND VGND VPWR VPWR u_interface.core_attn_out\[24\]
+ sky130_fd_sc_hd__dfxtp_1
X_3727_ _0954_ _0955_ VGND VGND VPWR VPWR _0956_ sky130_fd_sc_hd__xnor2_1
XFILLER_0_55_391 VGND VGND VPWR VPWR sky130_fd_sc_hd__fill_1
X_3658_ _0796_ _0842_ VGND VGND VPWR VPWR _0889_ sky130_fd_sc_hd__nand2_1
X_3589_ _0818_ _0820_ VGND VGND VPWR VPWR _0821_ sky130_fd_sc_hd__xor2_2
X_2609_ u_interface.u_compute_core.u_mac.product_reg\[10\] u_interface.u_compute_core.mac_accum\[10\]
+ VGND VGND VPWR VPWR _2033_ sky130_fd_sc_hd__nand2_1
XFILLER_0_11_483 VGND VGND VPWR VPWR sky130_fd_sc_hd__fill_1
Xclkbuf_4_5_0_clk clknet_0_clk VGND VGND VPWR VPWR clknet_4_5_0_clk sky130_fd_sc_hd__clkbuf_8
XTAP_TAPCELL_ROW_26_401 VGND VPWR sky130_fd_sc_hd__tapvpwrvgnd_1
XFILLER_0_78_483 VGND VGND VPWR VPWR sky130_fd_sc_hd__fill_1
XFILLER_0_65_111 VGND VGND VPWR VPWR sky130_fd_sc_hd__fill_1
XFILLER_0_53_317 VPWR VGND VPWR VGND sky130_ef_sc_hd__decap_12
XFILLER_0_65_199 VGND VGND VPWR VPWR sky130_fd_sc_hd__decap_4
XFILLER_0_28_48 VPWR VGND VPWR VGND sky130_ef_sc_hd__decap_12
XFILLER_0_69_472 VGND VGND VPWR VPWR sky130_fd_sc_hd__decap_8
X_2960_ _0214_ _0215_ _0218_ VGND VGND VPWR VPWR _0219_ sky130_fd_sc_hd__or3_1
XFILLER_0_56_100 VPWR VGND VPWR VGND sky130_ef_sc_hd__decap_12
X_2891_ _2284_ _2285_ VGND VGND VPWR VPWR _2286_ sky130_fd_sc_hd__xnor2_1
XTAP_TAPCELL_ROW_32_448 VGND VPWR sky130_fd_sc_hd__tapvpwrvgnd_1
X_4630_ _1901_ _1807_ VGND VGND VPWR VPWR _1808_ sky130_fd_sc_hd__and2_1
XFILLER_0_71_169 VGND VGND VPWR VPWR sky130_fd_sc_hd__decap_8
XFILLER_0_8_36 VPWR VGND VPWR VGND sky130_ef_sc_hd__decap_12
X_4561_ net59 u_interface.core_attn_out\[8\] _1760_ VGND VGND VPWR VPWR _1761_ sky130_fd_sc_hd__mux2_1
X_4492_ _1669_ VGND VGND VPWR VPWR _1705_ sky130_fd_sc_hd__inv_2
X_3512_ _0669_ _0700_ _0745_ VGND VGND VPWR VPWR _0746_ sky130_fd_sc_hd__a21oi_2
X_3443_ _0483_ _1838_ VGND VGND VPWR VPWR _0678_ sky130_fd_sc_hd__nand2_1
X_3374_ _0581_ _0582_ _0610_ VGND VGND VPWR VPWR _0611_ sky130_fd_sc_hd__o21a_1
X_2325_ u_interface.u_compute_core.relu_data\[0\] VGND VGND VPWR VPWR _1818_ sky130_fd_sc_hd__buf_4
XFILLER_0_79_225 VPWR VGND VPWR VGND sky130_ef_sc_hd__decap_12
XFILLER_0_79_214 VGND VGND VPWR VPWR sky130_fd_sc_hd__fill_1
XTAP_TAPCELL_ROW_48_581 VGND VPWR sky130_fd_sc_hd__tapvpwrvgnd_1
XFILLER_0_75_464 VPWR VGND VPWR VGND sky130_ef_sc_hd__decap_12
XFILLER_0_47_155 VGND VGND VPWR VPWR sky130_fd_sc_hd__decap_4
XFILLER_0_62_136 VGND VGND VPWR VPWR sky130_fd_sc_hd__decap_4
X_4759_ clknet_4_11_0_clk _0124_ VGND VGND VPWR VPWR u_interface.core_attn_out\[7\]
+ sky130_fd_sc_hd__dfxtp_1
XFILLER_0_50_309 VGND VGND VPWR VPWR sky130_fd_sc_hd__decap_4
XFILLER_0_43_372 VGND VGND VPWR VPWR sky130_fd_sc_hd__decap_6
XTAP_TAPCELL_ROW_74_805 VGND VPWR sky130_fd_sc_hd__tapvpwrvgnd_1
XFILLER_0_14_39 VGND VGND VPWR VPWR sky130_fd_sc_hd__fill_1
XFILLER_0_66_442 VGND VGND VPWR VPWR sky130_fd_sc_hd__decap_6
XFILLER_0_26_306 VGND VGND VPWR VPWR sky130_fd_sc_hd__fill_2
XFILLER_0_66_475 VGND VGND VPWR VPWR sky130_fd_sc_hd__fill_1
XFILLER_0_30_27 VGND VGND VPWR VPWR sky130_fd_sc_hd__fill_1
XFILLER_0_30_49 VGND VGND VPWR VPWR sky130_fd_sc_hd__decap_3
XFILLER_0_53_169 VGND VGND VPWR VPWR sky130_fd_sc_hd__decap_6
XFILLER_0_1_417 VPWR VGND VPWR VGND sky130_ef_sc_hd__decap_12
X_3090_ _2161_ _2163_ _2294_ VGND VGND VPWR VPWR _0345_ sky130_fd_sc_hd__o21a_1
X_3992_ _1117_ _1163_ VGND VGND VPWR VPWR _1216_ sky130_fd_sc_hd__or2_1
XTAP_TAPCELL_ROW_45_562 VGND VPWR sky130_fd_sc_hd__tapvpwrvgnd_1
X_2943_ _0200_ _0201_ VGND VGND VPWR VPWR _0202_ sky130_fd_sc_hd__nor2_1
XFILLER_0_69_291 VGND VGND VPWR VPWR sky130_fd_sc_hd__decap_6
XFILLER_0_17_317 VGND VGND VPWR VPWR sky130_fd_sc_hd__fill_1
XFILLER_0_44_114 VGND VGND VPWR VPWR sky130_fd_sc_hd__fill_1
X_2874_ _2241_ _2242_ _2269_ VGND VGND VPWR VPWR _2270_ sky130_fd_sc_hd__a21o_1
XFILLER_0_44_147 VGND VGND VPWR VPWR sky130_fd_sc_hd__fill_1
XFILLER_0_4_233 VPWR VGND VPWR VGND sky130_ef_sc_hd__decap_12
XFILLER_0_25_350 VGND VGND VPWR VPWR sky130_fd_sc_hd__fill_1
XFILLER_0_32_309 VGND VGND VPWR VPWR sky130_fd_sc_hd__decap_4
X_4613_ _1796_ VGND VGND VPWR VPWR _0174_ sky130_fd_sc_hd__clkbuf_1
X_4544_ net54 u_interface.core_attn_out\[3\] _1742_ VGND VGND VPWR VPWR _1749_ sky130_fd_sc_hd__mux2_1
XFILLER_0_4_277 VPWR VGND VPWR VGND sky130_ef_sc_hd__decap_12
XFILLER_0_20_82 VGND VGND VPWR VPWR sky130_fd_sc_hd__fill_2
X_4475_ net76 _1687_ u_interface.core_attn_out\[27\] VGND VGND VPWR VPWR _1689_ sky130_fd_sc_hd__a21oi_2
X_3426_ _0621_ _0661_ VGND VGND VPWR VPWR _0662_ sky130_fd_sc_hd__xor2_1
XFILLER_0_0_461 VPWR VGND VPWR VGND sky130_ef_sc_hd__decap_12
X_3357_ _0592_ _0593_ VGND VGND VPWR VPWR _0594_ sky130_fd_sc_hd__nor2b_1
XFILLER_0_0_483 VGND VGND VPWR VPWR sky130_fd_sc_hd__fill_1
X_3288_ _0523_ _0524_ _0525_ VGND VGND VPWR VPWR _0527_ sky130_fd_sc_hd__a21o_1
XTAP_TAPCELL_ROW_0_165 VGND VPWR sky130_fd_sc_hd__tapvpwrvgnd_1
XTAP_TAPCELL_ROW_0_176 VGND VPWR sky130_fd_sc_hd__tapvpwrvgnd_1
XFILLER_0_48_464 VPWR VGND VPWR VGND sky130_ef_sc_hd__decap_12
XFILLER_0_35_125 VGND VGND VPWR VPWR sky130_fd_sc_hd__decap_3
XFILLER_0_63_467 VPWR VGND VPWR VGND sky130_ef_sc_hd__decap_12
XFILLER_0_9_90 VGND VGND VPWR VPWR sky130_fd_sc_hd__decap_6
XTAP_TAPCELL_ROW_8_243 VGND VPWR sky130_fd_sc_hd__tapvpwrvgnd_1
XFILLER_0_8_3 VGND VGND VPWR VPWR sky130_fd_sc_hd__decap_8
XTAP_TAPCELL_ROW_59_676 VGND VPWR sky130_fd_sc_hd__tapvpwrvgnd_1
XFILLER_0_73_209 VGND VGND VPWR VPWR sky130_fd_sc_hd__fill_1
XFILLER_0_41_15 VGND VGND VPWR VPWR sky130_fd_sc_hd__fill_1
XTAP_TAPCELL_ROW_42_532 VGND VPWR sky130_fd_sc_hd__tapvpwrvgnd_1
XFILLER_0_26_147 VGND VGND VPWR VPWR sky130_fd_sc_hd__decap_3
XFILLER_0_54_445 VGND VGND VPWR VPWR sky130_fd_sc_hd__decap_8
XFILLER_0_81_253 VPWR VGND VPWR VGND sky130_ef_sc_hd__decap_12
XFILLER_0_1_225 VPWR VGND VPWR VGND sky130_ef_sc_hd__decap_12
XFILLER_0_34_191 VGND VGND VPWR VPWR sky130_fd_sc_hd__decap_4
X_2590_ _2014_ _2015_ _2016_ VGND VGND VPWR VPWR _2017_ sky130_fd_sc_hd__and3_1
XFILLER_0_5_15 VPWR VGND VPWR VGND sky130_ef_sc_hd__decap_12
X_4260_ _1476_ _1477_ VGND VGND VPWR VPWR _1478_ sky130_fd_sc_hd__nor2_1
X_3211_ u_interface.u_compute_core.u_av.v_extended\[10\] VGND VGND VPWR VPWR _0453_
+ sky130_fd_sc_hd__clkbuf_4
X_4191_ _1353_ _1351_ VGND VGND VPWR VPWR _1411_ sky130_fd_sc_hd__or2b_1
X_3142_ _0371_ _0374_ _0394_ VGND VGND VPWR VPWR _0395_ sky130_fd_sc_hd__a21o_1
X_3073_ _0287_ _0290_ _0327_ VGND VGND VPWR VPWR _0329_ sky130_fd_sc_hd__and3_1
XFILLER_0_49_206 VGND VGND VPWR VPWR sky130_fd_sc_hd__decap_3
XFILLER_0_9_325 VGND VGND VPWR VPWR sky130_fd_sc_hd__fill_1
XFILLER_0_45_412 VGND VGND VPWR VPWR sky130_fd_sc_hd__decap_3
XFILLER_0_57_261 VGND VGND VPWR VPWR sky130_fd_sc_hd__decap_4
X_3975_ _0460_ _0457_ u_interface.u_compute_core.relu_data\[20\] u_interface.u_compute_core.relu_data\[19\]
+ VGND VGND VPWR VPWR _1199_ sky130_fd_sc_hd__and4_1
XFILLER_0_64_209 VGND VGND VPWR VPWR sky130_fd_sc_hd__decap_8
XFILLER_0_17_125 VGND VGND VPWR VPWR sky130_fd_sc_hd__fill_1
X_2926_ _0184_ VGND VGND VPWR VPWR _0185_ sky130_fd_sc_hd__inv_2
XFILLER_0_72_253 VPWR VGND VPWR VGND sky130_ef_sc_hd__decap_12
XFILLER_0_17_169 VPWR VGND VPWR VGND sky130_ef_sc_hd__decap_12
X_2857_ _2219_ _2252_ VGND VGND VPWR VPWR _2253_ sky130_fd_sc_hd__xor2_1
XFILLER_0_72_297 VGND VGND VPWR VPWR sky130_fd_sc_hd__fill_1
XFILLER_0_60_437 VGND VGND VPWR VPWR sky130_fd_sc_hd__fill_1
XFILLER_0_13_320 VPWR VGND VPWR VGND sky130_ef_sc_hd__decap_12
X_2788_ _2179_ _2181_ _2185_ _2186_ VGND VGND VPWR VPWR _2187_ sky130_fd_sc_hd__and4_1
X_4527_ net119 _0715_ _1813_ _1737_ VGND VGND VPWR VPWR _0147_ sky130_fd_sc_hd__o211a_1
X_4458_ _0451_ _1893_ VGND VGND VPWR VPWR _1672_ sky130_fd_sc_hd__nand2_1
X_3409_ _0597_ _0598_ _0639_ _0458_ VGND VGND VPWR VPWR _0645_ sky130_fd_sc_hd__o211a_1
X_4389_ _1603_ _1604_ VGND VGND VPWR VPWR _1605_ sky130_fd_sc_hd__nand2_1
XFILLER_0_8_380 VGND VGND VPWR VPWR sky130_fd_sc_hd__fill_1
XFILLER_0_51_426 VGND VGND VPWR VPWR sky130_fd_sc_hd__fill_1
XFILLER_0_16_180 VPWR VGND VPWR VGND sky130_ef_sc_hd__decap_12
XFILLER_0_31_183 VGND VGND VPWR VPWR sky130_fd_sc_hd__decap_8
XTAP_TAPCELL_ROW_19_337 VGND VPWR sky130_fd_sc_hd__tapvpwrvgnd_1
XFILLER_0_52_58 VPWR VGND VPWR VGND sky130_ef_sc_hd__decap_12
XFILLER_0_39_294 VGND VGND VPWR VPWR sky130_fd_sc_hd__fill_1
X_3760_ _0457_ _1868_ _1865_ _0460_ VGND VGND VPWR VPWR _0988_ sky130_fd_sc_hd__a22oi_1
XFILLER_0_27_467 VPWR VGND VPWR VGND sky130_ef_sc_hd__decap_12
XFILLER_0_54_253 VPWR VGND VPWR VGND sky130_ef_sc_hd__decap_12
X_2711_ _2096_ _2117_ _2118_ _2119_ _2120_ VGND VGND VPWR VPWR _2121_ sky130_fd_sc_hd__o311a_1
XFILLER_0_14_106 VGND VGND VPWR VPWR sky130_fd_sc_hd__decap_3
X_3691_ _0867_ _0869_ VGND VGND VPWR VPWR _0921_ sky130_fd_sc_hd__or2_1
XFILLER_0_14_139 VGND VGND VPWR VPWR sky130_fd_sc_hd__fill_1
X_2642_ _2059_ _2061_ VGND VGND VPWR VPWR _2062_ sky130_fd_sc_hd__or2_1
X_2573_ _1994_ _1997_ _2001_ VGND VGND VPWR VPWR _2002_ sky130_fd_sc_hd__a21oi_1
XFILLER_0_77_55 VGND VGND VPWR VPWR sky130_fd_sc_hd__fill_1
X_4312_ _1368_ _1526_ _1527_ _1528_ VGND VGND VPWR VPWR _1529_ sky130_fd_sc_hd__o211a_1
X_4243_ _1413_ _1461_ VGND VGND VPWR VPWR _1462_ sky130_fd_sc_hd__or2_1
X_4174_ _1392_ _1393_ VGND VGND VPWR VPWR _1394_ sky130_fd_sc_hd__xnor2_1
X_3125_ _0349_ _0378_ VGND VGND VPWR VPWR _0379_ sky130_fd_sc_hd__or2_1
X_3056_ _0268_ _0275_ _0311_ VGND VGND VPWR VPWR _0312_ sky130_fd_sc_hd__o21a_1
XTAP_TAPCELL_ROW_53_627 VGND VPWR sky130_fd_sc_hd__tapvpwrvgnd_1
X_3958_ _0442_ _1868_ VGND VGND VPWR VPWR _1182_ sky130_fd_sc_hd__nand2_1
XTAP_TAPCELL_ROW_61_693 VGND VPWR sky130_fd_sc_hd__tapvpwrvgnd_1
X_2909_ _2302_ _2303_ VGND VGND VPWR VPWR _2304_ sky130_fd_sc_hd__nand2_1
X_3889_ _1112_ _1114_ VGND VGND VPWR VPWR _1115_ sky130_fd_sc_hd__xor2_1
XFILLER_0_41_481 VGND VGND VPWR VPWR sky130_fd_sc_hd__decap_3
XTAP_TAPCELL_ROW_69_760 VGND VPWR sky130_fd_sc_hd__tapvpwrvgnd_1
XTAP_TAPCELL_ROW_24_384 VGND VPWR sky130_fd_sc_hd__tapvpwrvgnd_1
XFILLER_0_36_253 VGND VGND VPWR VPWR sky130_fd_sc_hd__decap_8
XFILLER_0_51_278 VGND VGND VPWR VPWR sky130_fd_sc_hd__fill_2
XFILLER_0_78_109 VPWR VGND VPWR VGND sky130_ef_sc_hd__decap_12
XFILLER_0_2_27 VGND VGND VPWR VPWR sky130_fd_sc_hd__fill_1
X_3812_ _0948_ _0991_ _1038_ VGND VGND VPWR VPWR _1039_ sky130_fd_sc_hd__a21o_1
X_4792_ clknet_4_11_0_clk _0157_ VGND VGND VPWR VPWR net58 sky130_fd_sc_hd__dfxtp_1
XFILLER_0_12_72 VGND VGND VPWR VPWR sky130_fd_sc_hd__decap_3
X_3743_ _0969_ _0971_ VGND VGND VPWR VPWR _0972_ sky130_fd_sc_hd__xnor2_1
XFILLER_0_42_201 VGND VGND VPWR VPWR sky130_fd_sc_hd__fill_1
X_3674_ _0551_ _0634_ u_interface.u_compute_core.relu_data\[9\] u_interface.u_compute_core.relu_data\[8\]
+ VGND VGND VPWR VPWR _0904_ sky130_fd_sc_hd__and4_1
XFILLER_0_30_418 VGND VGND VPWR VPWR sky130_fd_sc_hd__fill_2
X_2625_ u_interface.u_compute_core.u_mac.product_reg\[12\] u_interface.u_compute_core.mac_accum\[12\]
+ VGND VGND VPWR VPWR _2047_ sky130_fd_sc_hd__or2_1
XFILLER_0_23_481 VGND VGND VPWR VPWR sky130_fd_sc_hd__decap_3
X_2556_ _1973_ _1986_ _1987_ _1980_ net96 VGND VGND VPWR VPWR _0061_ sky130_fd_sc_hd__a32o_1
X_2487_ u_interface.u_compute_core.scaled_data\[15\] u_interface.u_compute_core.mac_accum\[18\]
+ _1922_ VGND VGND VPWR VPWR _1936_ sky130_fd_sc_hd__mux2_1
XFILLER_0_10_197 VPWR VGND VPWR VGND sky130_ef_sc_hd__decap_12
XFILLER_0_49_3 VGND VGND VPWR VPWR sky130_fd_sc_hd__decap_6
X_4226_ _0427_ _0423_ u_interface.u_compute_core.relu_data\[25\] u_interface.u_compute_core.relu_data\[24\]
+ VGND VGND VPWR VPWR _1445_ sky130_fd_sc_hd__and4_1
X_4157_ _1342_ _1350_ _1376_ VGND VGND VPWR VPWR _1377_ sky130_fd_sc_hd__o21a_1
X_3108_ _0328_ _0331_ _0362_ VGND VGND VPWR VPWR _0363_ sky130_fd_sc_hd__o21a_1
X_4088_ _1308_ _1309_ VGND VGND VPWR VPWR _1310_ sky130_fd_sc_hd__nand2_1
XTAP_TAPCELL_ROW_66_741 VGND VPWR sky130_fd_sc_hd__tapvpwrvgnd_1
X_3039_ _0258_ _0261_ _0294_ _2032_ VGND VGND VPWR VPWR _0296_ sky130_fd_sc_hd__o31ai_1
XTAP_TAPCELL_ROW_38_498 VGND VPWR sky130_fd_sc_hd__tapvpwrvgnd_1
XFILLER_0_53_90 VGND VGND VPWR VPWR sky130_fd_sc_hd__decap_3
XFILLER_0_65_337 VGND VGND VPWR VPWR sky130_fd_sc_hd__decap_8
XFILLER_0_80_307 VGND VGND VPWR VPWR sky130_fd_sc_hd__fill_1
XFILLER_0_65_359 VPWR VGND VPWR VGND sky130_ef_sc_hd__decap_12
XFILLER_0_18_264 VPWR VGND VPWR VGND sky130_ef_sc_hd__decap_12
XTAP_TAPCELL_ROW_21_354 VGND VPWR sky130_fd_sc_hd__tapvpwrvgnd_1
XTAP_TAPCELL_ROW_29_421 VGND VPWR sky130_fd_sc_hd__tapvpwrvgnd_1
XTAP_TAPCELL_ROW_72_788 VGND VPWR sky130_fd_sc_hd__tapvpwrvgnd_1
XFILLER_0_56_337 VPWR VGND VPWR VGND sky130_ef_sc_hd__decap_12
Xinput14 s_tdata[1] VGND VGND VPWR VPWR net14 sky130_fd_sc_hd__buf_1
Xinput25 s_tdata[8] VGND VGND VPWR VPWR net25 sky130_fd_sc_hd__buf_2
X_2410_ u_interface.u_compute_core.relu_data\[21\] VGND VGND VPWR VPWR _1882_ sky130_fd_sc_hd__inv_2
X_3390_ _0483_ VGND VGND VPWR VPWR _0626_ sky130_fd_sc_hd__clkbuf_4
X_2341_ _1829_ VGND VGND VPWR VPWR _1830_ sky130_fd_sc_hd__inv_2
X_4011_ _0442_ _1868_ _1181_ _1233_ VGND VGND VPWR VPWR _1234_ sky130_fd_sc_hd__a31o_1
XTAP_TAPCELL_ROW_63_711 VGND VPWR sky130_fd_sc_hd__tapvpwrvgnd_1
XFILLER_0_59_164 VGND VGND VPWR VPWR sky130_fd_sc_hd__decap_4
XFILLER_0_47_337 VPWR VGND VPWR VGND sky130_ef_sc_hd__decap_12
XFILLER_0_59_175 VGND VGND VPWR VPWR sky130_fd_sc_hd__fill_1
X_4775_ clknet_4_13_0_clk _0140_ VGND VGND VPWR VPWR u_interface.core_attn_out\[23\]
+ sky130_fd_sc_hd__dfxtp_1
XFILLER_0_15_223 VGND VGND VPWR VPWR sky130_fd_sc_hd__fill_1
XFILLER_0_15_212 VGND VGND VPWR VPWR sky130_fd_sc_hd__decap_6
X_3726_ _0430_ _1859_ VGND VGND VPWR VPWR _0955_ sky130_fd_sc_hd__nand2_1
XFILLER_0_70_362 VGND VGND VPWR VPWR sky130_fd_sc_hd__fill_2
XFILLER_0_15_278 VGND VGND VPWR VPWR sky130_fd_sc_hd__fill_2
X_3657_ _0886_ _0887_ VGND VGND VPWR VPWR _0888_ sky130_fd_sc_hd__or2_1
X_3588_ _0778_ _1838_ _0689_ _0819_ VGND VGND VPWR VPWR _0820_ sky130_fd_sc_hd__a31o_1
X_2608_ _1972_ VGND VGND VPWR VPWR _2032_ sky130_fd_sc_hd__clkbuf_4
X_2539_ _1811_ net28 VGND VGND VPWR VPWR _1972_ sky130_fd_sc_hd__and2_1
XFILLER_0_48_90 VGND VGND VPWR VPWR sky130_fd_sc_hd__decap_4
X_4209_ _1426_ _1427_ VGND VGND VPWR VPWR _1428_ sky130_fd_sc_hd__nor2_1
XFILLER_0_3_81 VPWR VGND VPWR VGND sky130_ef_sc_hd__decap_12
XFILLER_0_65_145 VPWR VGND VPWR VGND sky130_ef_sc_hd__decap_12
XFILLER_0_53_329 VGND VGND VPWR VPWR sky130_fd_sc_hd__decap_6
XFILLER_0_65_167 VGND VGND VPWR VPWR sky130_fd_sc_hd__fill_1
XFILLER_0_44_48 VGND VGND VPWR VPWR sky130_fd_sc_hd__decap_3
XFILLER_0_8_209 VGND VGND VPWR VPWR sky130_fd_sc_hd__decap_4
XFILLER_0_56_112 VGND VGND VPWR VPWR sky130_fd_sc_hd__decap_4
X_2890_ _2213_ _2243_ VGND VGND VPWR VPWR _2285_ sky130_fd_sc_hd__nand2_1
XTAP_TAPCELL_ROW_32_449 VGND VPWR sky130_fd_sc_hd__tapvpwrvgnd_1
XFILLER_0_37_381 VGND VGND VPWR VPWR sky130_fd_sc_hd__decap_6
X_4560_ u_interface.core_valid_out VGND VGND VPWR VPWR _1760_ sky130_fd_sc_hd__clkbuf_4
X_4491_ _1675_ _1676_ _1703_ VGND VGND VPWR VPWR _1704_ sky130_fd_sc_hd__o21ai_1
XFILLER_0_12_204 VPWR VGND VPWR VGND sky130_ef_sc_hd__decap_12
X_3511_ _0699_ _0697_ VGND VGND VPWR VPWR _0745_ sky130_fd_sc_hd__and2b_1
XFILLER_0_12_259 VGND VGND VPWR VPWR sky130_fd_sc_hd__fill_1
X_3442_ _0676_ _0670_ VGND VGND VPWR VPWR _0677_ sky130_fd_sc_hd__xnor2_2
X_3373_ _0583_ _0609_ VGND VGND VPWR VPWR _0610_ sky130_fd_sc_hd__xnor2_1
X_2324_ _1816_ VGND VGND VPWR VPWR _1817_ sky130_fd_sc_hd__clkbuf_2
XFILLER_0_18_82 VGND VGND VPWR VPWR sky130_fd_sc_hd__fill_2
XFILLER_0_79_237 VGND VGND VPWR VPWR sky130_fd_sc_hd__decap_8
XTAP_TAPCELL_ROW_48_582 VGND VPWR sky130_fd_sc_hd__tapvpwrvgnd_1
XFILLER_0_75_476 VGND VGND VPWR VPWR sky130_fd_sc_hd__decap_8
XFILLER_0_7_264 VGND VGND VPWR VPWR sky130_fd_sc_hd__decap_3
XFILLER_0_62_148 VGND VGND VPWR VPWR sky130_fd_sc_hd__fill_1
X_4758_ clknet_4_10_0_clk _0123_ VGND VGND VPWR VPWR u_interface.core_attn_out\[6\]
+ sky130_fd_sc_hd__dfxtp_1
X_3709_ _1967_ VGND VGND VPWR VPWR _0938_ sky130_fd_sc_hd__clkbuf_4
X_4689_ clknet_4_7_0_clk _0054_ VGND VGND VPWR VPWR u_interface.u_compute_core.scaled_data\[25\]
+ sky130_fd_sc_hd__dfxtp_1
XFILLER_0_3_481 VGND VGND VPWR VPWR sky130_fd_sc_hd__decap_3
XFILLER_0_11_281 VGND VGND VPWR VPWR sky130_fd_sc_hd__fill_2
XTAP_TAPCELL_ROW_74_806 VGND VPWR sky130_fd_sc_hd__tapvpwrvgnd_1
XFILLER_0_38_101 VGND VGND VPWR VPWR sky130_fd_sc_hd__fill_2
XFILLER_0_34_373 VGND VGND VPWR VPWR sky130_fd_sc_hd__fill_2
XFILLER_0_1_429 VPWR VGND VPWR VGND sky130_ef_sc_hd__decap_12
XFILLER_0_76_218 VPWR VGND VPWR VGND sky130_ef_sc_hd__decap_12
X_3991_ _1213_ _1214_ VGND VGND VPWR VPWR _1215_ sky130_fd_sc_hd__nand2_1
XFILLER_0_69_281 VGND VGND VPWR VPWR sky130_fd_sc_hd__decap_3
XFILLER_0_71_57 VPWR VGND VPWR VGND sky130_ef_sc_hd__decap_12
X_2942_ _2287_ _0199_ _0183_ VGND VGND VPWR VPWR _0201_ sky130_fd_sc_hd__nor3_1
XFILLER_0_57_465 VPWR VGND VPWR VGND sky130_ef_sc_hd__decap_12
X_2873_ _2267_ _2268_ VGND VGND VPWR VPWR _2269_ sky130_fd_sc_hd__nand2_1
Xclkbuf_4_4_0_clk clknet_0_clk VGND VGND VPWR VPWR clknet_4_4_0_clk sky130_fd_sc_hd__clkbuf_8
X_4612_ _1775_ _1795_ VGND VGND VPWR VPWR _1796_ sky130_fd_sc_hd__and2_1
XFILLER_0_4_245 VGND VGND VPWR VPWR sky130_fd_sc_hd__decap_6
X_4543_ _1748_ VGND VGND VPWR VPWR _0152_ sky130_fd_sc_hd__clkbuf_1
XFILLER_0_40_321 VPWR VGND VPWR VGND sky130_ef_sc_hd__decap_12
XFILLER_0_4_289 VPWR VGND VPWR VGND sky130_ef_sc_hd__decap_12
X_4474_ _1685_ u_interface.core_attn_out\[27\] _1687_ VGND VGND VPWR VPWR _1688_ sky130_fd_sc_hd__and3_1
XFILLER_0_40_365 VPWR VGND VPWR VGND sky130_ef_sc_hd__decap_12
X_3425_ _0659_ _0660_ VGND VGND VPWR VPWR _0661_ sky130_fd_sc_hd__nor2_2
XFILLER_0_0_473 VGND VGND VPWR VPWR sky130_fd_sc_hd__decap_3
X_3356_ u_interface.u_compute_core.u_av.v_extended\[5\] u_interface.u_compute_core.relu_data\[2\]
+ u_interface.u_compute_core.relu_data\[1\] u_interface.u_compute_core.u_av.v_extended\[6\]
+ VGND VGND VPWR VPWR _0593_ sky130_fd_sc_hd__a22o_1
X_3287_ _0523_ _0524_ _0525_ VGND VGND VPWR VPWR _0526_ sky130_fd_sc_hd__nand3_2
XFILLER_0_31_3 VGND VGND VPWR VPWR sky130_fd_sc_hd__decap_6
XTAP_TAPCELL_ROW_0_166 VGND VPWR sky130_fd_sc_hd__tapvpwrvgnd_1
XTAP_TAPCELL_ROW_0_177 VGND VPWR sky130_fd_sc_hd__tapvpwrvgnd_1
XFILLER_0_0_71 VGND VGND VPWR VPWR sky130_fd_sc_hd__fill_2
XFILLER_0_63_413 VPWR VGND VPWR VGND sky130_ef_sc_hd__decap_12
XFILLER_0_16_340 VGND VGND VPWR VPWR sky130_fd_sc_hd__decap_8
XFILLER_0_63_479 VGND VGND VPWR VPWR sky130_fd_sc_hd__decap_4
XFILLER_0_16_362 VGND VGND VPWR VPWR sky130_fd_sc_hd__fill_2
XFILLER_0_31_332 VGND VGND VPWR VPWR sky130_fd_sc_hd__decap_4
XFILLER_0_43_181 VPWR VGND VPWR VGND sky130_ef_sc_hd__decap_12
XTAP_TAPCELL_ROW_8_244 VGND VPWR sky130_fd_sc_hd__tapvpwrvgnd_1
XTAP_TAPCELL_ROW_59_677 VGND VPWR sky130_fd_sc_hd__tapvpwrvgnd_1
XFILLER_0_39_421 VGND VGND VPWR VPWR sky130_fd_sc_hd__fill_1
XFILLER_0_41_27 VGND VGND VPWR VPWR sky130_fd_sc_hd__decap_4
XTAP_TAPCELL_ROW_42_533 VGND VPWR sky130_fd_sc_hd__tapvpwrvgnd_1
XFILLER_0_81_221 VGND VGND VPWR VPWR sky130_fd_sc_hd__decap_3
XFILLER_0_66_284 VPWR VGND VPWR VGND sky130_ef_sc_hd__decap_12
XFILLER_0_81_265 VGND VGND VPWR VPWR sky130_fd_sc_hd__decap_3
XFILLER_0_1_237 VPWR VGND VPWR VGND sky130_ef_sc_hd__decap_12
XFILLER_0_5_27 VPWR VGND VPWR VGND sky130_ef_sc_hd__decap_12
X_3210_ _1968_ net23 _0434_ _0452_ VGND VGND VPWR VPWR _0115_ sky130_fd_sc_hd__o211a_1
X_4190_ _1408_ _1409_ VGND VGND VPWR VPWR _1410_ sky130_fd_sc_hd__nand2_1
X_3141_ _0308_ _0393_ VGND VGND VPWR VPWR _0394_ sky130_fd_sc_hd__xnor2_1
X_3072_ _0287_ _0290_ _0327_ VGND VGND VPWR VPWR _0328_ sky130_fd_sc_hd__a21oi_1
XFILLER_0_9_359 VGND VGND VPWR VPWR sky130_fd_sc_hd__fill_1
X_3974_ _0424_ _1197_ _1151_ _0427_ VGND VGND VPWR VPWR _1198_ sky130_fd_sc_hd__a22o_1
X_2925_ net13 net7 net8 net12 VGND VGND VPWR VPWR _0184_ sky130_fd_sc_hd__a22o_1
XFILLER_0_57_273 VGND VGND VPWR VPWR sky130_fd_sc_hd__decap_6
XFILLER_0_72_265 VPWR VGND VPWR VGND sky130_ef_sc_hd__decap_12
XPHY_EDGE_ROW_17_Left_99 VGND VGND VPWR VPWR sky130_fd_sc_hd__decap_3
X_2856_ _2246_ _2251_ VGND VGND VPWR VPWR _2252_ sky130_fd_sc_hd__xnor2_1
XTAP_TAPCELL_ROW_13_290 VGND VPWR sky130_fd_sc_hd__tapvpwrvgnd_1
XFILLER_0_31_93 VGND VGND VPWR VPWR sky130_fd_sc_hd__decap_6
XFILLER_0_60_416 VGND VGND VPWR VPWR sky130_fd_sc_hd__decap_4
XFILLER_0_79_3 VPWR VGND VPWR VGND sky130_ef_sc_hd__decap_12
XFILLER_0_13_332 VGND VGND VPWR VPWR sky130_fd_sc_hd__decap_4
X_2787_ _2183_ _2184_ _2171_ VGND VGND VPWR VPWR _2186_ sky130_fd_sc_hd__a21bo_1
X_4526_ _1735_ _1736_ _1967_ VGND VGND VPWR VPWR _1737_ sky130_fd_sc_hd__a21o_1
X_4457_ _0447_ _1893_ _1890_ _0451_ VGND VGND VPWR VPWR _1671_ sky130_fd_sc_hd__a22o_1
X_3408_ _0640_ _0643_ VGND VGND VPWR VPWR _0644_ sky130_fd_sc_hd__xnor2_1
XFILLER_0_0_281 VGND VGND VPWR VPWR sky130_fd_sc_hd__decap_8
X_4388_ _1601_ _1602_ VGND VGND VPWR VPWR _1604_ sky130_fd_sc_hd__nand2_1
X_3339_ _0575_ _0576_ VGND VGND VPWR VPWR _0577_ sky130_fd_sc_hd__xnor2_1
XFILLER_0_48_295 VGND VGND VPWR VPWR sky130_fd_sc_hd__fill_1
XFILLER_0_16_192 VGND VGND VPWR VPWR sky130_fd_sc_hd__decap_4
XFILLER_0_36_27 VGND VGND VPWR VPWR sky130_fd_sc_hd__fill_1
XTAP_TAPCELL_ROW_19_338 VGND VPWR sky130_fd_sc_hd__tapvpwrvgnd_1
XFILLER_0_52_26 VGND VGND VPWR VPWR sky130_fd_sc_hd__fill_2
XFILLER_0_39_240 VGND VGND VPWR VPWR sky130_fd_sc_hd__fill_1
XFILLER_0_39_251 VPWR VGND VPWR VGND sky130_ef_sc_hd__decap_12
XFILLER_0_6_307 VGND VGND VPWR VPWR sky130_fd_sc_hd__fill_1
XFILLER_0_27_479 VGND VGND VPWR VPWR sky130_fd_sc_hd__fill_1
XFILLER_0_54_232 VPWR VGND VPWR VGND sky130_ef_sc_hd__decap_12
X_2710_ _2066_ u_interface.u_compute_core.mac_accum\[24\] VGND VGND VPWR VPWR _2120_
+ sky130_fd_sc_hd__nand2_1
X_3690_ _0902_ _0919_ VGND VGND VPWR VPWR _0920_ sky130_fd_sc_hd__xor2_2
XFILLER_0_54_265 VPWR VGND VPWR VGND sky130_ef_sc_hd__decap_12
XTAP_TAPCELL_ROW_10_260 VGND VPWR sky130_fd_sc_hd__tapvpwrvgnd_1
X_2641_ _2046_ _2049_ _2052_ _2060_ VGND VGND VPWR VPWR _2061_ sky130_fd_sc_hd__a31o_1
XFILLER_0_10_302 VGND VGND VPWR VPWR sky130_fd_sc_hd__decap_6
X_2572_ _1999_ _2000_ VGND VGND VPWR VPWR _2001_ sky130_fd_sc_hd__nand2_1
XFILLER_0_22_173 VGND VGND VPWR VPWR sky130_fd_sc_hd__fill_1
X_4311_ _1521_ _1518_ _1525_ _1469_ _1517_ VGND VGND VPWR VPWR _1528_ sky130_fd_sc_hd__a221oi_1
X_4242_ _1459_ _1460_ VGND VGND VPWR VPWR _1461_ sky130_fd_sc_hd__and2_1
X_4173_ _1333_ _1338_ _1331_ VGND VGND VPWR VPWR _1393_ sky130_fd_sc_hd__a21oi_1
X_3124_ _0376_ _0377_ VGND VGND VPWR VPWR _0378_ sky130_fd_sc_hd__xnor2_1
X_3055_ _0309_ _0310_ VGND VGND VPWR VPWR _0311_ sky130_fd_sc_hd__nor2_1
XFILLER_0_26_93 VGND VGND VPWR VPWR sky130_fd_sc_hd__decap_8
XFILLER_0_77_335 VGND VGND VPWR VPWR sky130_fd_sc_hd__fill_1
XTAP_TAPCELL_ROW_53_628 VGND VPWR sky130_fd_sc_hd__tapvpwrvgnd_1
XFILLER_0_9_123 VGND VGND VPWR VPWR sky130_fd_sc_hd__decap_8
X_3957_ _1179_ _1180_ VGND VGND VPWR VPWR _1181_ sky130_fd_sc_hd__xnor2_1
X_2908_ _2255_ _2301_ VGND VGND VPWR VPWR _2303_ sky130_fd_sc_hd__nand2_1
XTAP_TAPCELL_ROW_61_694 VGND VPWR sky130_fd_sc_hd__tapvpwrvgnd_1
XFILLER_0_33_405 VGND VGND VPWR VPWR sky130_fd_sc_hd__decap_8
X_3888_ _1045_ _1062_ _1113_ VGND VGND VPWR VPWR _1114_ sky130_fd_sc_hd__a21oi_1
X_2839_ _2212_ _2235_ VGND VGND VPWR VPWR _2236_ sky130_fd_sc_hd__xnor2_1
XFILLER_0_13_140 VGND VGND VPWR VPWR sky130_fd_sc_hd__decap_3
X_4509_ u_interface.core_attn_out\[28\] _1966_ VGND VGND VPWR VPWR _1722_ sky130_fd_sc_hd__or2_1
XTAP_TAPCELL_ROW_69_761 VGND VPWR sky130_fd_sc_hd__tapvpwrvgnd_1
XFILLER_0_68_302 VGND VGND VPWR VPWR sky130_fd_sc_hd__fill_2
XTAP_TAPCELL_ROW_16_308 VGND VPWR sky130_fd_sc_hd__tapvpwrvgnd_1
XFILLER_0_22_29 VPWR VGND VPWR VGND sky130_ef_sc_hd__decap_12
XFILLER_0_47_15 VPWR VGND VPWR VGND sky130_ef_sc_hd__decap_12
XFILLER_0_59_368 VPWR VGND VPWR VGND sky130_ef_sc_hd__decap_12
XPHY_EDGE_ROW_25_Left_107 VGND VGND VPWR VPWR sky130_fd_sc_hd__decap_3
X_3811_ _0990_ _0987_ VGND VGND VPWR VPWR _1038_ sky130_fd_sc_hd__and2b_1
X_4791_ clknet_4_10_0_clk _0156_ VGND VGND VPWR VPWR net57 sky130_fd_sc_hd__dfxtp_1
XFILLER_0_67_390 VGND VGND VPWR VPWR sky130_fd_sc_hd__fill_2
XFILLER_0_15_416 VPWR VGND VPWR VGND sky130_ef_sc_hd__decap_12
X_3742_ _0902_ _0919_ _0970_ VGND VGND VPWR VPWR _0971_ sky130_fd_sc_hd__o21a_1
XFILLER_0_15_449 VPWR VGND VPWR VGND sky130_ef_sc_hd__decap_12
XFILLER_0_27_298 VPWR VGND VPWR VGND sky130_ef_sc_hd__decap_12
X_3673_ _0445_ _1845_ _1841_ _0449_ VGND VGND VPWR VPWR _0903_ sky130_fd_sc_hd__a22oi_1
XFILLER_0_42_224 VPWR VGND VPWR VGND sky130_ef_sc_hd__decap_12
XFILLER_0_2_321 VPWR VGND VPWR VGND sky130_ef_sc_hd__decap_12
X_2624_ u_interface.u_compute_core.u_mac.product_reg\[12\] u_interface.u_compute_core.mac_accum\[12\]
+ VGND VGND VPWR VPWR _2046_ sky130_fd_sc_hd__nand2_1
XFILLER_0_2_365 VPWR VGND VPWR VGND sky130_ef_sc_hd__decap_12
XPHY_EDGE_ROW_34_Left_116 VGND VGND VPWR VPWR sky130_fd_sc_hd__decap_3
X_2555_ _1981_ _1982_ _1984_ VGND VGND VPWR VPWR _1987_ sky130_fd_sc_hd__a21o_1
X_2486_ _1935_ VGND VGND VPWR VPWR _0043_ sky130_fd_sc_hd__clkbuf_1
X_4225_ _0424_ _1893_ _1890_ _0428_ VGND VGND VPWR VPWR _1444_ sky130_fd_sc_hd__a22o_1
X_4156_ _1339_ _1341_ VGND VGND VPWR VPWR _1376_ sky130_fd_sc_hd__or2_1
X_3107_ _0360_ _0361_ VGND VGND VPWR VPWR _0362_ sky130_fd_sc_hd__nor2_1
XFILLER_0_37_81 VGND VGND VPWR VPWR sky130_fd_sc_hd__decap_3
XFILLER_0_37_92 VGND VGND VPWR VPWR sky130_fd_sc_hd__decap_4
X_4087_ _1306_ _1307_ VGND VGND VPWR VPWR _1309_ sky130_fd_sc_hd__nand2_1
X_3038_ _0258_ _0261_ _0294_ VGND VGND VPWR VPWR _0295_ sky130_fd_sc_hd__o21a_1
XTAP_TAPCELL_ROW_38_499 VGND VPWR sky130_fd_sc_hd__tapvpwrvgnd_1
XPHY_EDGE_ROW_43_Left_125 VGND VGND VPWR VPWR sky130_fd_sc_hd__decap_3
XFILLER_0_77_198 VGND VGND VPWR VPWR sky130_fd_sc_hd__decap_4
XFILLER_0_65_316 VPWR VGND VPWR VGND sky130_ef_sc_hd__decap_12
XFILLER_0_18_276 VPWR VGND VPWR VGND sky130_ef_sc_hd__decap_12
XFILLER_0_18_298 VGND VGND VPWR VPWR sky130_fd_sc_hd__decap_8
XTAP_TAPCELL_ROW_21_355 VGND VPWR sky130_fd_sc_hd__tapvpwrvgnd_1
XFILLER_0_5_181 VPWR VGND VPWR VGND sky130_ef_sc_hd__decap_12
XFILLER_0_33_279 VGND VGND VPWR VPWR sky130_fd_sc_hd__fill_1
XPHY_EDGE_ROW_52_Left_134 VGND VGND VPWR VPWR sky130_fd_sc_hd__decap_3
XTAP_TAPCELL_ROW_29_422 VGND VPWR sky130_fd_sc_hd__tapvpwrvgnd_1
XPHY_EDGE_ROW_61_Left_143 VGND VGND VPWR VPWR sky130_fd_sc_hd__decap_3
XFILLER_0_56_305 VGND VGND VPWR VPWR sky130_fd_sc_hd__decap_3
XTAP_TAPCELL_ROW_72_789 VGND VPWR sky130_fd_sc_hd__tapvpwrvgnd_1
XFILLER_0_49_390 VGND VGND VPWR VPWR sky130_fd_sc_hd__fill_2
XFILLER_0_56_349 VPWR VGND VPWR VGND sky130_ef_sc_hd__decap_12
Xinput15 s_tdata[20] VGND VGND VPWR VPWR net15 sky130_fd_sc_hd__buf_1
Xinput26 s_tdata[9] VGND VGND VPWR VPWR net26 sky130_fd_sc_hd__buf_1
XFILLER_0_12_419 VGND VGND VPWR VPWR sky130_fd_sc_hd__fill_1
XPHY_EDGE_ROW_70_Left_152 VGND VGND VPWR VPWR sky130_fd_sc_hd__decap_3
XFILLER_0_20_452 VGND VGND VPWR VPWR sky130_fd_sc_hd__decap_8
X_2340_ u_interface.u_compute_core.relu_data\[4\] VGND VGND VPWR VPWR _1829_ sky130_fd_sc_hd__clkbuf_4
X_4010_ _0438_ u_interface.u_compute_core.relu_data\[17\] _1179_ VGND VGND VPWR VPWR
+ _1233_ sky130_fd_sc_hd__and3_1
XFILLER_0_59_110 VGND VGND VPWR VPWR sky130_fd_sc_hd__fill_2
XTAP_TAPCELL_ROW_63_712 VGND VPWR sky130_fd_sc_hd__tapvpwrvgnd_1
XFILLER_0_74_113 VGND VGND VPWR VPWR sky130_fd_sc_hd__decap_8
XFILLER_0_47_349 VGND VGND VPWR VPWR sky130_fd_sc_hd__decap_4
X_4774_ clknet_4_15_0_clk _0139_ VGND VGND VPWR VPWR u_interface.core_attn_out\[22\]
+ sky130_fd_sc_hd__dfxtp_1
X_3725_ _0952_ _0953_ VGND VGND VPWR VPWR _0954_ sky130_fd_sc_hd__nor2_1
X_3656_ u_interface.core_attn_out\[10\] _0884_ VGND VGND VPWR VPWR _0887_ sky130_fd_sc_hd__nor2_1
XFILLER_0_30_205 VPWR VGND VPWR VGND sky130_ef_sc_hd__decap_12
X_3587_ _0468_ _1841_ _0776_ VGND VGND VPWR VPWR _0819_ sky130_fd_sc_hd__and3_1
X_2607_ net148 _2026_ _2031_ _1973_ VGND VGND VPWR VPWR _0068_ sky130_fd_sc_hd__a22o_1
XFILLER_0_61_3 VPWR VGND VPWR VGND sky130_ef_sc_hd__decap_12
XFILLER_0_2_195 VGND VGND VPWR VPWR sky130_fd_sc_hd__fill_1
X_2538_ net117 _1971_ VGND VGND VPWR VPWR _0059_ sky130_fd_sc_hd__nor2_1
X_2469_ _1909_ _1923_ VGND VGND VPWR VPWR _1924_ sky130_fd_sc_hd__and2_1
X_4208_ _0438_ u_interface.u_compute_core.relu_data\[22\] _1425_ VGND VGND VPWR VPWR
+ _1427_ sky130_fd_sc_hd__and3_1
X_4139_ _1311_ VGND VGND VPWR VPWR _1360_ sky130_fd_sc_hd__inv_2
XFILLER_0_3_93 VPWR VGND VPWR VGND sky130_ef_sc_hd__decap_12
XFILLER_0_65_157 VGND VGND VPWR VPWR sky130_fd_sc_hd__decap_3
XFILLER_0_14_290 VGND VGND VPWR VPWR sky130_fd_sc_hd__decap_3
XPHY_EDGE_ROW_5_Left_87 VGND VGND VPWR VPWR sky130_fd_sc_hd__decap_3
XFILLER_0_44_27 VGND VGND VPWR VPWR sky130_fd_sc_hd__fill_1
XFILLER_0_69_441 VGND VGND VPWR VPWR sky130_fd_sc_hd__decap_6
XFILLER_0_60_15 VPWR VGND VPWR VGND sky130_ef_sc_hd__decap_12
XFILLER_0_71_149 VGND VGND VPWR VPWR sky130_fd_sc_hd__decap_4
XFILLER_0_37_393 VGND VGND VPWR VPWR sky130_fd_sc_hd__decap_3
XFILLER_0_8_16 VPWR VGND VPWR VGND sky130_ef_sc_hd__decap_12
X_3510_ _0743_ _0716_ VGND VGND VPWR VPWR _0744_ sky130_fd_sc_hd__xnor2_2
XFILLER_0_52_363 VGND VGND VPWR VPWR sky130_fd_sc_hd__fill_1
X_4490_ _1678_ _1677_ VGND VGND VPWR VPWR _1703_ sky130_fd_sc_hd__or2b_1
XFILLER_0_12_216 VGND VGND VPWR VPWR sky130_fd_sc_hd__decap_8
XFILLER_0_52_385 VPWR VGND VPWR VGND sky130_ef_sc_hd__decap_12
XFILLER_0_69_57 VGND VGND VPWR VPWR sky130_fd_sc_hd__decap_4
X_3441_ _0674_ _0675_ VGND VGND VPWR VPWR _0676_ sky130_fd_sc_hd__and2b_1
X_3372_ _0606_ _0608_ VGND VGND VPWR VPWR _0609_ sky130_fd_sc_hd__xor2_1
X_2323_ u_interface.u_compute_core.scaled_valid VGND VGND VPWR VPWR _1816_ sky130_fd_sc_hd__clkbuf_2
XTAP_TAPCELL_ROW_48_583 VGND VPWR sky130_fd_sc_hd__tapvpwrvgnd_1
XFILLER_0_47_113 VGND VGND VPWR VPWR sky130_fd_sc_hd__decap_8
XFILLER_0_75_444 VGND VGND VPWR VPWR sky130_fd_sc_hd__decap_4
XFILLER_0_34_93 VGND VGND VPWR VPWR sky130_fd_sc_hd__decap_4
XFILLER_0_28_360 VGND VGND VPWR VPWR sky130_fd_sc_hd__decap_4
X_4757_ clknet_4_10_0_clk _0122_ VGND VGND VPWR VPWR u_interface.core_attn_out\[5\]
+ sky130_fd_sc_hd__dfxtp_1
X_4688_ clknet_4_7_0_clk _0053_ VGND VGND VPWR VPWR u_interface.u_compute_core.scaled_data\[24\]
+ sky130_fd_sc_hd__dfxtp_1
X_3708_ _0480_ _0936_ _0937_ _0667_ VGND VGND VPWR VPWR _0128_ sky130_fd_sc_hd__o211a_1
XFILLER_0_70_171 VGND VGND VPWR VPWR sky130_fd_sc_hd__fill_1
X_3639_ _0867_ _0869_ VGND VGND VPWR VPWR _0870_ sky130_fd_sc_hd__xnor2_1
XFILLER_0_59_90 VGND VGND VPWR VPWR sky130_fd_sc_hd__decap_4
XTAP_TAPCELL_ROW_74_807 VGND VPWR sky130_fd_sc_hd__tapvpwrvgnd_1
XFILLER_0_38_157 VGND VGND VPWR VPWR sky130_fd_sc_hd__fill_1
XFILLER_0_53_105 VGND VGND VPWR VPWR sky130_fd_sc_hd__decap_4
XFILLER_0_66_477 VGND VGND VPWR VPWR sky130_fd_sc_hd__decap_6
XFILLER_0_81_447 VGND VGND VPWR VPWR sky130_fd_sc_hd__fill_1
XFILLER_0_19_371 VGND VGND VPWR VPWR sky130_fd_sc_hd__decap_8
XFILLER_0_19_393 VGND VGND VPWR VPWR sky130_fd_sc_hd__fill_2
XFILLER_0_34_341 VGND VGND VPWR VPWR sky130_fd_sc_hd__fill_1
XFILLER_0_34_363 VGND VGND VPWR VPWR sky130_fd_sc_hd__fill_1
XFILLER_0_61_182 VGND VGND VPWR VPWR sky130_fd_sc_hd__fill_2
XFILLER_0_55_15 VPWR VGND VPWR VGND sky130_ef_sc_hd__decap_12
XFILLER_0_29_102 VGND VGND VPWR VPWR sky130_fd_sc_hd__decap_8
X_3990_ _1210_ _1212_ VGND VGND VPWR VPWR _1214_ sky130_fd_sc_hd__nand2_1
XFILLER_0_71_69 VGND VGND VPWR VPWR sky130_fd_sc_hd__decap_4
X_2941_ _2287_ _0183_ _0199_ VGND VGND VPWR VPWR _0200_ sky130_fd_sc_hd__o21a_1
XFILLER_0_57_477 VGND VGND VPWR VPWR sky130_fd_sc_hd__decap_3
X_2872_ _2263_ _2264_ _2266_ VGND VGND VPWR VPWR _2268_ sky130_fd_sc_hd__a21o_1
X_4611_ net45 u_interface.core_attn_out\[24\] _1782_ VGND VGND VPWR VPWR _1795_ sky130_fd_sc_hd__mux2_1
XFILLER_0_72_469 VGND VGND VPWR VPWR sky130_fd_sc_hd__decap_6
X_4542_ _1953_ _1747_ VGND VGND VPWR VPWR _1748_ sky130_fd_sc_hd__and2_1
XFILLER_0_40_300 VGND VGND VPWR VPWR sky130_fd_sc_hd__decap_8
X_4473_ _1653_ _1650_ _1686_ _1684_ _1661_ VGND VGND VPWR VPWR _1687_ sky130_fd_sc_hd__o2111ai_1
XFILLER_0_40_333 VGND VGND VPWR VPWR sky130_fd_sc_hd__decap_8
X_3424_ _0656_ _0658_ VGND VGND VPWR VPWR _0660_ sky130_fd_sc_hd__and2_1
XFILLER_0_40_377 VPWR VGND VPWR VGND sky130_ef_sc_hd__decap_12
X_3355_ u_interface.u_compute_core.u_av.v_extended\[6\] u_interface.u_compute_core.u_av.v_extended\[5\]
+ u_interface.u_compute_core.relu_data\[2\] u_interface.u_compute_core.relu_data\[1\]
+ VGND VGND VPWR VPWR _0592_ sky130_fd_sc_hd__and4_1
X_3286_ _0489_ _0496_ VGND VGND VPWR VPWR _0525_ sky130_fd_sc_hd__or2b_1
XFILLER_0_24_3 VGND VGND VPWR VPWR sky130_fd_sc_hd__decap_6
XFILLER_0_45_81 VGND VGND VPWR VPWR sky130_fd_sc_hd__decap_3
XTAP_TAPCELL_ROW_0_167 VGND VPWR sky130_fd_sc_hd__tapvpwrvgnd_1
XTAP_TAPCELL_ROW_0_178 VGND VPWR sky130_fd_sc_hd__tapvpwrvgnd_1
XFILLER_0_48_400 VPWR VGND VPWR VGND sky130_ef_sc_hd__decap_12
XFILLER_0_0_83 VGND VGND VPWR VPWR sky130_fd_sc_hd__fill_1
XFILLER_0_48_455 VGND VGND VPWR VPWR sky130_fd_sc_hd__fill_1
XFILLER_0_48_477 VGND VGND VPWR VPWR sky130_fd_sc_hd__decap_6
XFILLER_0_75_285 VGND VGND VPWR VPWR sky130_fd_sc_hd__fill_1
XFILLER_0_75_274 VGND VGND VPWR VPWR sky130_fd_sc_hd__decap_6
XFILLER_0_63_425 VPWR VGND VPWR VGND sky130_ef_sc_hd__decap_12
XPHY_EDGE_ROW_17_Right_17 VGND VGND VPWR VPWR sky130_fd_sc_hd__decap_3
X_4809_ clknet_4_15_0_clk _0174_ VGND VGND VPWR VPWR net45 sky130_fd_sc_hd__dfxtp_1
XFILLER_0_43_193 VGND VGND VPWR VPWR sky130_fd_sc_hd__fill_1
XFILLER_0_31_377 VGND VGND VPWR VPWR sky130_fd_sc_hd__fill_1
XTAP_TAPCELL_ROW_8_245 VGND VPWR sky130_fd_sc_hd__tapvpwrvgnd_1
XPHY_EDGE_ROW_26_Right_26 VGND VGND VPWR VPWR sky130_fd_sc_hd__decap_3
XTAP_TAPCELL_ROW_59_678 VGND VPWR sky130_fd_sc_hd__tapvpwrvgnd_1
XTAP_TAPCELL_ROW_42_534 VGND VPWR sky130_fd_sc_hd__tapvpwrvgnd_1
XFILLER_0_26_138 VGND VGND VPWR VPWR sky130_fd_sc_hd__fill_2
XPHY_EDGE_ROW_35_Right_35 VGND VGND VPWR VPWR sky130_fd_sc_hd__decap_3
XFILLER_0_66_274 VGND VGND VPWR VPWR sky130_fd_sc_hd__decap_3
XFILLER_0_1_205 VPWR VGND VPWR VGND sky130_ef_sc_hd__decap_12
XFILLER_0_1_249 VPWR VGND VPWR VGND sky130_ef_sc_hd__decap_12
XFILLER_0_5_39 VPWR VGND VPWR VGND sky130_ef_sc_hd__decap_12
XPHY_EDGE_ROW_44_Right_44 VGND VGND VPWR VPWR sky130_fd_sc_hd__decap_3
X_3140_ _0366_ _0392_ _0369_ VGND VGND VPWR VPWR _0393_ sky130_fd_sc_hd__a21bo_1
XPHY_EDGE_ROW_8_Left_90 VGND VGND VPWR VPWR sky130_fd_sc_hd__decap_3
X_3071_ _0325_ _0326_ VGND VGND VPWR VPWR _0327_ sky130_fd_sc_hd__nand2_1
XFILLER_0_49_219 VGND VGND VPWR VPWR sky130_fd_sc_hd__decap_4
XFILLER_0_9_305 VPWR VGND VPWR VGND sky130_ef_sc_hd__decap_12
XPHY_EDGE_ROW_53_Right_53 VGND VGND VPWR VPWR sky130_fd_sc_hd__decap_3
X_3973_ u_interface.u_compute_core.relu_data\[20\] VGND VGND VPWR VPWR _1197_ sky130_fd_sc_hd__buf_2
X_2924_ _2213_ _2243_ _2284_ VGND VGND VPWR VPWR _0183_ sky130_fd_sc_hd__and3b_1
X_2855_ _2249_ _2250_ VGND VGND VPWR VPWR _2251_ sky130_fd_sc_hd__xnor2_1
XFILLER_0_72_277 VPWR VGND VPWR VGND sky130_ef_sc_hd__decap_12
X_4525_ _1724_ _1728_ _1734_ _1730_ VGND VGND VPWR VPWR _1736_ sky130_fd_sc_hd__or4_1
XFILLER_0_13_311 VGND VGND VPWR VPWR sky130_fd_sc_hd__fill_2
X_2786_ _2171_ _2183_ _2184_ VGND VGND VPWR VPWR _2185_ sky130_fd_sc_hd__nand3b_1
XFILLER_0_40_152 VGND VGND VPWR VPWR sky130_fd_sc_hd__fill_1
X_4456_ _1668_ _1669_ VGND VGND VPWR VPWR _1670_ sky130_fd_sc_hd__xnor2_1
XFILLER_0_13_388 VGND VGND VPWR VPWR sky130_fd_sc_hd__decap_4
XPHY_EDGE_ROW_62_Right_62 VGND VGND VPWR VPWR sky130_fd_sc_hd__decap_3
X_4387_ _1601_ _1602_ VGND VGND VPWR VPWR _1603_ sky130_fd_sc_hd__or2_1
X_3407_ _0641_ _0642_ VGND VGND VPWR VPWR _0643_ sky130_fd_sc_hd__xnor2_2
XFILLER_0_0_293 VPWR VGND VPWR VGND sky130_ef_sc_hd__decap_12
XTAP_TAPCELL_ROW_5_215 VGND VPWR sky130_fd_sc_hd__tapvpwrvgnd_1
X_3338_ _0536_ _0539_ _0535_ VGND VGND VPWR VPWR _0576_ sky130_fd_sc_hd__a21o_1
X_3269_ _0423_ _1832_ _1829_ _0460_ VGND VGND VPWR VPWR _0508_ sky130_fd_sc_hd__a22o_1
XTAP_TAPCELL_ROW_56_648 VGND VPWR sky130_fd_sc_hd__tapvpwrvgnd_1
XPHY_EDGE_ROW_71_Right_71 VGND VGND VPWR VPWR sky130_fd_sc_hd__decap_3
XFILLER_0_51_417 VGND VGND VPWR VPWR sky130_fd_sc_hd__fill_1
XPHY_EDGE_ROW_80_Right_80 VGND VGND VPWR VPWR sky130_fd_sc_hd__decap_3
Xclkbuf_4_3_0_clk clknet_0_clk VGND VGND VPWR VPWR clknet_4_3_0_clk sky130_fd_sc_hd__clkbuf_8
XTAP_TAPCELL_ROW_19_339 VGND VPWR sky130_fd_sc_hd__tapvpwrvgnd_1
XFILLER_0_39_263 VPWR VGND VPWR VGND sky130_ef_sc_hd__decap_12
XFILLER_0_39_285 VGND VGND VPWR VPWR sky130_fd_sc_hd__fill_1
XFILLER_0_54_244 VGND VGND VPWR VPWR sky130_fd_sc_hd__decap_8
XFILLER_0_14_119 VPWR VGND VPWR VGND sky130_ef_sc_hd__decap_12
X_2640_ u_interface.u_compute_core.u_mac.product_reg\[13\] u_interface.u_compute_core.mac_accum\[13\]
+ VGND VGND VPWR VPWR _2060_ sky130_fd_sc_hd__nor2_1
XFILLER_0_54_277 VPWR VGND VPWR VGND sky130_ef_sc_hd__decap_12
XTAP_TAPCELL_ROW_10_261 VGND VPWR sky130_fd_sc_hd__tapvpwrvgnd_1
XFILLER_0_22_141 VGND VGND VPWR VPWR sky130_fd_sc_hd__decap_4
X_2571_ u_interface.u_compute_core.u_mac.product_reg\[5\] u_interface.u_compute_core.mac_accum\[5\]
+ VGND VGND VPWR VPWR _2000_ sky130_fd_sc_hd__nand2_1
XFILLER_0_50_483 VGND VGND VPWR VPWR sky130_fd_sc_hd__fill_1
X_4310_ _1363_ _1366_ _1468_ _1525_ VGND VGND VPWR VPWR _1527_ sky130_fd_sc_hd__nand4_1
XFILLER_0_77_57 VPWR VGND VPWR VGND sky130_ef_sc_hd__decap_12
X_4241_ _1404_ _1408_ _1458_ VGND VGND VPWR VPWR _1460_ sky130_fd_sc_hd__nand3_1
X_4172_ _1386_ _1391_ VGND VGND VPWR VPWR _1392_ sky130_fd_sc_hd__xnor2_1
X_3123_ _0308_ _0341_ _0339_ VGND VGND VPWR VPWR _0377_ sky130_fd_sc_hd__o21a_1
X_3054_ _0305_ _0308_ VGND VGND VPWR VPWR _0310_ sky130_fd_sc_hd__nor2_1
XTAP_TAPCELL_ROW_53_629 VGND VPWR sky130_fd_sc_hd__tapvpwrvgnd_1
XFILLER_0_9_113 VGND VGND VPWR VPWR sky130_fd_sc_hd__decap_3
X_3956_ _0468_ u_interface.u_compute_core.relu_data\[17\] VGND VGND VPWR VPWR _1180_
+ sky130_fd_sc_hd__nand2_1
X_2907_ _2255_ _2301_ VGND VGND VPWR VPWR _2302_ sky130_fd_sc_hd__or2_1
XTAP_TAPCELL_ROW_61_695 VGND VPWR sky130_fd_sc_hd__tapvpwrvgnd_1
X_3887_ _1059_ _1061_ VGND VGND VPWR VPWR _1113_ sky130_fd_sc_hd__nor2_1
XFILLER_0_60_203 VPWR VGND VPWR VGND sky130_ef_sc_hd__decap_12
X_2838_ _2233_ _2234_ VGND VGND VPWR VPWR _2235_ sky130_fd_sc_hd__or2_1
XFILLER_0_33_439 VGND VGND VPWR VPWR sky130_fd_sc_hd__fill_1
X_2769_ net12 VGND VGND VPWR VPWR _2169_ sky130_fd_sc_hd__buf_2
X_4508_ _1701_ _1720_ VGND VGND VPWR VPWR _1721_ sky130_fd_sc_hd__xor2_1
X_4439_ _1651_ net78 VGND VGND VPWR VPWR _1654_ sky130_fd_sc_hd__nand2_1
XFILLER_0_6_82 VGND VGND VPWR VPWR sky130_fd_sc_hd__fill_2
XTAP_TAPCELL_ROW_69_762 VGND VPWR sky130_fd_sc_hd__tapvpwrvgnd_1
XTAP_TAPCELL_ROW_16_309 VGND VPWR sky130_fd_sc_hd__tapvpwrvgnd_1
XFILLER_0_36_222 VGND VGND VPWR VPWR sky130_fd_sc_hd__fill_1
XFILLER_0_24_428 VGND VGND VPWR VPWR sky130_fd_sc_hd__fill_2
XFILLER_0_51_214 VGND VGND VPWR VPWR sky130_fd_sc_hd__fill_1
XFILLER_0_47_27 VGND VGND VPWR VPWR sky130_fd_sc_hd__fill_2
XFILLER_0_2_29 VPWR VGND VPWR VGND sky130_ef_sc_hd__decap_12
XFILLER_0_63_15 VPWR VGND VPWR VGND sky130_ef_sc_hd__decap_12
X_4790_ clknet_4_11_0_clk _0155_ VGND VGND VPWR VPWR net56 sky130_fd_sc_hd__dfxtp_1
X_3810_ _0986_ _1013_ VGND VGND VPWR VPWR _1037_ sky130_fd_sc_hd__nand2_1
X_3741_ _0916_ _0918_ VGND VGND VPWR VPWR _0970_ sky130_fd_sc_hd__or2_1
XFILLER_0_15_428 VGND VGND VPWR VPWR sky130_fd_sc_hd__decap_4
XFILLER_0_12_85 VPWR VGND VPWR VGND sky130_ef_sc_hd__decap_12
X_3672_ _0850_ _0901_ VGND VGND VPWR VPWR _0902_ sky130_fd_sc_hd__xnor2_2
XFILLER_0_42_236 VPWR VGND VPWR VGND sky130_ef_sc_hd__decap_12
X_2623_ u_interface.u_compute_core.u_mac.product_reg\[11\] u_interface.u_compute_core.mac_accum\[11\]
+ VGND VGND VPWR VPWR _2045_ sky130_fd_sc_hd__nand2_1
XFILLER_0_2_333 VPWR VGND VPWR VGND sky130_ef_sc_hd__decap_12
X_2554_ _1985_ VGND VGND VPWR VPWR _1986_ sky130_fd_sc_hd__inv_2
XFILLER_0_2_377 VPWR VGND VPWR VGND sky130_ef_sc_hd__decap_12
XFILLER_0_50_291 VPWR VGND VPWR VGND sky130_ef_sc_hd__decap_12
X_2485_ _1931_ _1934_ VGND VGND VPWR VPWR _1935_ sky130_fd_sc_hd__and2_1
X_4224_ _0432_ _1884_ _1389_ _1388_ VGND VGND VPWR VPWR _1443_ sky130_fd_sc_hd__a31o_1
X_4155_ _1080_ _1217_ _1218_ _1274_ _1372_ VGND VGND VPWR VPWR _1375_ sky130_fd_sc_hd__a2111o_1
X_3106_ _0322_ _0325_ _0358_ VGND VGND VPWR VPWR _0361_ sky130_fd_sc_hd__and3_1
X_4086_ _1306_ _1307_ VGND VGND VPWR VPWR _1308_ sky130_fd_sc_hd__or2_1
XFILLER_0_77_111 VGND VGND VPWR VPWR sky130_fd_sc_hd__fill_1
X_3037_ _0292_ _0293_ VGND VGND VPWR VPWR _0294_ sky130_fd_sc_hd__xnor2_1
XFILLER_0_65_328 VGND VGND VPWR VPWR sky130_fd_sc_hd__decap_8
XFILLER_0_18_233 VPWR VGND VPWR VGND sky130_ef_sc_hd__decap_12
XFILLER_0_80_309 VGND VGND VPWR VPWR sky130_fd_sc_hd__fill_1
X_3939_ _1129_ _1130_ _1162_ VGND VGND VPWR VPWR _1164_ sky130_fd_sc_hd__a21o_1
XFILLER_0_18_288 VGND VGND VPWR VPWR sky130_fd_sc_hd__decap_6
XTAP_TAPCELL_ROW_21_356 VGND VPWR sky130_fd_sc_hd__tapvpwrvgnd_1
XFILLER_0_33_214 VGND VGND VPWR VPWR sky130_fd_sc_hd__fill_1
XFILLER_0_33_225 VPWR VGND VPWR VGND sky130_ef_sc_hd__decap_12
XFILLER_0_14_483 VGND VGND VPWR VPWR sky130_fd_sc_hd__fill_1
XFILLER_0_5_193 VPWR VGND VPWR VGND sky130_ef_sc_hd__decap_12
XTAP_TAPCELL_ROW_29_423 VGND VPWR sky130_fd_sc_hd__tapvpwrvgnd_1
XFILLER_0_33_18 VGND VGND VPWR VPWR sky130_fd_sc_hd__decap_8
XFILLER_0_68_188 VGND VGND VPWR VPWR sky130_fd_sc_hd__decap_8
XFILLER_0_71_309 VGND VGND VPWR VPWR sky130_fd_sc_hd__fill_2
XFILLER_0_24_203 VPWR VGND VPWR VGND sky130_ef_sc_hd__decap_12
Xinput16 s_tdata[21] VGND VGND VPWR VPWR net16 sky130_fd_sc_hd__buf_1
Xinput27 s_tlast VGND VGND VPWR VPWR net27 sky130_fd_sc_hd__clkbuf_1
XFILLER_0_24_269 VGND VGND VPWR VPWR sky130_fd_sc_hd__decap_8
XFILLER_0_58_15 VPWR VGND VPWR VGND sky130_ef_sc_hd__decap_12
XTAP_TAPCELL_ROW_63_713 VGND VPWR sky130_fd_sc_hd__tapvpwrvgnd_1
XFILLER_0_7_447 VGND VGND VPWR VPWR sky130_fd_sc_hd__fill_1
X_4773_ clknet_4_15_0_clk _0138_ VGND VGND VPWR VPWR u_interface.core_attn_out\[21\]
+ sky130_fd_sc_hd__dfxtp_1
XFILLER_0_15_225 VGND VGND VPWR VPWR sky130_fd_sc_hd__fill_2
X_3724_ _0449_ _0634_ u_interface.u_compute_core.relu_data\[10\] u_interface.u_compute_core.relu_data\[9\]
+ VGND VGND VPWR VPWR _0953_ sky130_fd_sc_hd__and4_1
XFILLER_0_55_372 VGND VGND VPWR VPWR sky130_fd_sc_hd__decap_6
XFILLER_0_70_342 VPWR VGND VPWR VGND sky130_ef_sc_hd__decap_12
XFILLER_0_15_258 VPWR VGND VPWR VGND sky130_ef_sc_hd__decap_12
X_3655_ net73 VGND VGND VPWR VPWR _0886_ sky130_fd_sc_hd__inv_2
XFILLER_0_30_217 VGND VGND VPWR VPWR sky130_fd_sc_hd__decap_8
X_2606_ _2027_ _2030_ VGND VGND VPWR VPWR _2031_ sky130_fd_sc_hd__xnor2_1
XFILLER_0_2_141 VPWR VGND VPWR VGND sky130_ef_sc_hd__decap_12
X_3586_ _0814_ _0817_ VGND VGND VPWR VPWR _0818_ sky130_fd_sc_hd__xnor2_2
X_2537_ u_interface.u_compute_core.u_mac.product_reg\[0\] u_interface.u_compute_core.mac_accum\[0\]
+ _1969_ net2 VGND VGND VPWR VPWR _1971_ sky130_fd_sc_hd__a31o_1
X_2468_ u_interface.u_compute_core.scaled_data\[9\] u_interface.u_compute_core.mac_accum\[12\]
+ _1922_ VGND VGND VPWR VPWR _1923_ sky130_fd_sc_hd__mux2_1
XFILLER_0_54_3 VPWR VGND VPWR VGND sky130_ef_sc_hd__decap_12
X_4207_ _0438_ u_interface.u_compute_core.relu_data\[22\] _1425_ VGND VGND VPWR VPWR
+ _1426_ sky130_fd_sc_hd__a21oi_1
X_2399_ u_interface.u_compute_core.relu_data\[18\] VGND VGND VPWR VPWR _1874_ sky130_fd_sc_hd__buf_2
X_4138_ _1357_ _1358_ VGND VGND VPWR VPWR _1359_ sky130_fd_sc_hd__or2_1
X_4069_ _1285_ _1290_ VGND VGND VPWR VPWR _1291_ sky130_fd_sc_hd__xnor2_1
XFILLER_0_78_475 VGND VGND VPWR VPWR sky130_fd_sc_hd__fill_1
XFILLER_0_38_306 VGND VGND VPWR VPWR sky130_fd_sc_hd__fill_2
XFILLER_0_65_136 VGND VGND VPWR VPWR sky130_fd_sc_hd__fill_1
XFILLER_0_46_350 VGND VGND VPWR VPWR sky130_fd_sc_hd__decap_6
XFILLER_0_80_139 VGND VGND VPWR VPWR sky130_fd_sc_hd__fill_1
XFILLER_0_61_364 VGND VGND VPWR VPWR sky130_fd_sc_hd__fill_1
XFILLER_0_61_397 VGND VGND VPWR VPWR sky130_fd_sc_hd__decap_4
XFILLER_0_28_29 VGND VGND VPWR VPWR sky130_fd_sc_hd__fill_1
XTAP_TAPCELL_ROW_77_827 VGND VPWR sky130_fd_sc_hd__tapvpwrvgnd_1
XFILLER_0_69_420 VGND VGND VPWR VPWR sky130_fd_sc_hd__decap_8
XFILLER_0_56_147 VGND VGND VPWR VPWR sky130_fd_sc_hd__fill_1
XFILLER_0_60_27 VGND VGND VPWR VPWR sky130_fd_sc_hd__fill_1
X_3440_ _0633_ net64 _0673_ VGND VGND VPWR VPWR _0675_ sky130_fd_sc_hd__or3b_4
XFILLER_0_52_397 VGND VGND VPWR VPWR sky130_fd_sc_hd__decap_8
X_3371_ _0550_ _0564_ _0607_ VGND VGND VPWR VPWR _0608_ sky130_fd_sc_hd__o21bai_1
X_2322_ _1814_ VGND VGND VPWR VPWR _1815_ sky130_fd_sc_hd__clkbuf_2
XFILLER_0_19_6 VPWR VGND VPWR VGND sky130_ef_sc_hd__decap_12
XTAP_TAPCELL_ROW_48_584 VGND VPWR sky130_fd_sc_hd__tapvpwrvgnd_1
XFILLER_0_34_83 VGND VGND VPWR VPWR sky130_fd_sc_hd__fill_1
XFILLER_0_47_169 VGND VGND VPWR VPWR sky130_fd_sc_hd__decap_8
XFILLER_0_7_255 VGND VGND VPWR VPWR sky130_fd_sc_hd__decap_3
Xclone19 u_interface.u_compute_core.u_av.v_extended\[3\] VGND VGND VPWR VPWR net83
+ sky130_fd_sc_hd__buf_4
XFILLER_0_28_372 VPWR VGND VPWR VGND sky130_ef_sc_hd__decap_12
XTAP_TAPCELL_ROW_31_440 VGND VPWR sky130_fd_sc_hd__tapvpwrvgnd_1
XFILLER_0_7_288 VGND VGND VPWR VPWR sky130_fd_sc_hd__decap_6
X_4756_ clknet_4_10_0_clk _0121_ VGND VGND VPWR VPWR u_interface.core_attn_out\[4\]
+ sky130_fd_sc_hd__dfxtp_1
X_4687_ clknet_4_7_0_clk _0052_ VGND VGND VPWR VPWR u_interface.u_compute_core.scaled_data\[23\]
+ sky130_fd_sc_hd__dfxtp_1
X_3707_ u_interface.core_attn_out\[11\] _0713_ VGND VGND VPWR VPWR _0937_ sky130_fd_sc_hd__or2_1
XFILLER_0_3_461 VPWR VGND VPWR VGND sky130_ef_sc_hd__decap_12
X_3638_ _0813_ _0821_ _0868_ VGND VGND VPWR VPWR _0869_ sky130_fd_sc_hd__a21oi_1
X_3569_ _0767_ _0764_ VGND VGND VPWR VPWR _0801_ sky130_fd_sc_hd__and2b_1
XTAP_TAPCELL_ROW_74_808 VGND VPWR sky130_fd_sc_hd__tapvpwrvgnd_1
XTAP_TAPCELL_ROW_3_198 VGND VPWR sky130_fd_sc_hd__tapvpwrvgnd_1
XFILLER_0_78_261 VPWR VGND VPWR VGND sky130_ef_sc_hd__decap_12
XFILLER_0_34_320 VGND VGND VPWR VPWR sky130_fd_sc_hd__fill_2
XFILLER_0_39_28 VGND VGND VPWR VPWR sky130_fd_sc_hd__fill_1
XFILLER_0_55_27 VGND VGND VPWR VPWR sky130_fd_sc_hd__decap_4
XFILLER_0_71_15 VPWR VGND VPWR VGND sky130_ef_sc_hd__decap_12
XFILLER_0_69_250 VGND VGND VPWR VPWR sky130_fd_sc_hd__decap_3
X_2940_ _0197_ _0198_ VGND VGND VPWR VPWR _0199_ sky130_fd_sc_hd__and2_1
XFILLER_0_17_309 VGND VGND VPWR VPWR sky130_fd_sc_hd__decap_8
X_2871_ _2263_ _2264_ _2266_ VGND VGND VPWR VPWR _2267_ sky130_fd_sc_hd__nand3_1
XFILLER_0_29_169 VGND VGND VPWR VPWR sky130_fd_sc_hd__decap_4
X_4610_ _1794_ VGND VGND VPWR VPWR _0173_ sky130_fd_sc_hd__clkbuf_1
XFILLER_0_25_320 VGND VGND VPWR VPWR sky130_fd_sc_hd__fill_1
XFILLER_0_37_191 VPWR VGND VPWR VGND sky130_ef_sc_hd__decap_12
XFILLER_0_20_41 VPWR VGND VPWR VGND sky130_ef_sc_hd__decap_12
X_4541_ net51 u_interface.core_attn_out\[2\] _1742_ VGND VGND VPWR VPWR _1747_ sky130_fd_sc_hd__mux2_1
XFILLER_0_25_386 VGND VGND VPWR VPWR sky130_fd_sc_hd__decap_6
X_4472_ _1651_ _1649_ VGND VGND VPWR VPWR _1686_ sky130_fd_sc_hd__or2_1
X_3423_ _0656_ _0658_ VGND VGND VPWR VPWR _0659_ sky130_fd_sc_hd__nor2_1
XFILLER_0_40_389 VGND VGND VPWR VPWR sky130_fd_sc_hd__decap_4
X_3354_ _0483_ _1832_ VGND VGND VPWR VPWR _0591_ sky130_fd_sc_hd__nand2_1
X_3285_ _0521_ _0522_ _0510_ VGND VGND VPWR VPWR _0524_ sky130_fd_sc_hd__a21o_1
XTAP_TAPCELL_ROW_0_168 VGND VPWR sky130_fd_sc_hd__tapvpwrvgnd_1
XTAP_TAPCELL_ROW_0_179 VGND VPWR sky130_fd_sc_hd__tapvpwrvgnd_1
XFILLER_0_48_412 VGND VGND VPWR VPWR sky130_fd_sc_hd__decap_3
XFILLER_0_75_231 VGND VGND VPWR VPWR sky130_fd_sc_hd__fill_1
XFILLER_0_61_70 VGND VGND VPWR VPWR sky130_fd_sc_hd__decap_4
XFILLER_0_61_81 VGND VGND VPWR VPWR sky130_fd_sc_hd__decap_4
XFILLER_0_63_437 VGND VGND VPWR VPWR sky130_fd_sc_hd__decap_6
X_4808_ clknet_4_13_0_clk _0173_ VGND VGND VPWR VPWR net44 sky130_fd_sc_hd__dfxtp_1
X_4739_ clknet_4_0_0_clk _0104_ VGND VGND VPWR VPWR u_interface.u_compute_core.u_mac.product_reg\[13\]
+ sky130_fd_sc_hd__dfxtp_1
XFILLER_0_31_345 VGND VGND VPWR VPWR sky130_fd_sc_hd__fill_1
XTAP_TAPCELL_ROW_8_246 VGND VPWR sky130_fd_sc_hd__tapvpwrvgnd_1
XTAP_TAPCELL_ROW_59_679 VGND VPWR sky130_fd_sc_hd__tapvpwrvgnd_1
XTAP_TAPCELL_ROW_42_535 VGND VPWR sky130_fd_sc_hd__tapvpwrvgnd_1
XFILLER_0_66_253 VGND VGND VPWR VPWR sky130_fd_sc_hd__decap_8
XFILLER_0_34_161 VGND VGND VPWR VPWR sky130_fd_sc_hd__fill_1
XFILLER_0_1_217 VGND VGND VPWR VPWR sky130_fd_sc_hd__decap_6
XFILLER_0_66_15 VPWR VGND VPWR VGND sky130_ef_sc_hd__decap_12
X_3070_ _0281_ _0324_ VGND VGND VPWR VPWR _0326_ sky130_fd_sc_hd__nand2_1
XFILLER_0_15_30 VPWR VGND VPWR VGND sky130_ef_sc_hd__decap_12
XFILLER_0_9_317 VGND VGND VPWR VPWR sky130_fd_sc_hd__decap_8
X_3972_ _0431_ _1871_ _1141_ _1140_ VGND VGND VPWR VPWR _1196_ sky130_fd_sc_hd__a31o_1
XFILLER_0_57_253 VGND VGND VPWR VPWR sky130_fd_sc_hd__fill_1
X_2923_ _2293_ _2298_ _2299_ VGND VGND VPWR VPWR _0182_ sky130_fd_sc_hd__or3_1
XFILLER_0_57_297 VGND VGND VPWR VPWR sky130_fd_sc_hd__fill_1
XFILLER_0_72_234 VPWR VGND VPWR VGND sky130_ef_sc_hd__decap_12
X_2854_ _2168_ _2193_ VGND VGND VPWR VPWR _2250_ sky130_fd_sc_hd__nand2_1
XFILLER_0_72_289 VGND VGND VPWR VPWR sky130_fd_sc_hd__decap_8
XFILLER_0_13_301 VGND VGND VPWR VPWR sky130_fd_sc_hd__fill_1
X_2785_ _2163_ _2169_ _2182_ _2161_ VGND VGND VPWR VPWR _2184_ sky130_fd_sc_hd__a22o_1
XFILLER_0_25_150 VGND VGND VPWR VPWR sky130_fd_sc_hd__fill_1
X_4524_ _1724_ _1728_ _1730_ _1734_ VGND VGND VPWR VPWR _1735_ sky130_fd_sc_hd__o31ai_2
XFILLER_0_53_481 VGND VGND VPWR VPWR sky130_fd_sc_hd__decap_3
X_4455_ _1619_ _1622_ _1620_ VGND VGND VPWR VPWR _1669_ sky130_fd_sc_hd__o21ba_1
X_4386_ _1548_ _1549_ _1550_ _1554_ VGND VGND VPWR VPWR _1602_ sky130_fd_sc_hd__o31a_1
X_3406_ _0484_ u_interface.u_compute_core.relu_data\[5\] VGND VGND VPWR VPWR _0642_
+ sky130_fd_sc_hd__nand2_1
XFILLER_0_0_261 VGND VGND VPWR VPWR sky130_fd_sc_hd__fill_1
XFILLER_0_0_272 VGND VGND VPWR VPWR sky130_fd_sc_hd__decap_8
XTAP_TAPCELL_ROW_5_216 VGND VPWR sky130_fd_sc_hd__tapvpwrvgnd_1
X_3337_ _0573_ _0574_ VGND VGND VPWR VPWR _0575_ sky130_fd_sc_hd__or2b_1
X_3268_ u_interface.u_compute_core.u_av.v_extended\[1\] u_interface.u_compute_core.relu_data\[5\]
+ VGND VGND VPWR VPWR _0507_ sky130_fd_sc_hd__nand2_1
XFILLER_0_56_81 VGND VGND VPWR VPWR sky130_fd_sc_hd__decap_3
X_3199_ _0435_ _0443_ VGND VGND VPWR VPWR _0444_ sky130_fd_sc_hd__or2_1
XTAP_TAPCELL_ROW_56_649 VGND VPWR sky130_fd_sc_hd__tapvpwrvgnd_1
XFILLER_0_48_253 VPWR VGND VPWR VGND sky130_ef_sc_hd__decap_12
XFILLER_0_63_223 VGND VGND VPWR VPWR sky130_fd_sc_hd__fill_1
XFILLER_0_6_3 VPWR VGND VPWR VGND sky130_ef_sc_hd__decap_12
XFILLER_0_31_197 VGND VGND VPWR VPWR sky130_fd_sc_hd__decap_8
XFILLER_0_36_29 VGND VGND VPWR VPWR sky130_fd_sc_hd__fill_1
XFILLER_0_39_275 VGND VGND VPWR VPWR sky130_fd_sc_hd__decap_4
XFILLER_0_54_201 VGND VGND VPWR VPWR sky130_fd_sc_hd__fill_1
XFILLER_0_54_289 VGND VGND VPWR VPWR sky130_fd_sc_hd__fill_2
XTAP_TAPCELL_ROW_10_262 VGND VPWR sky130_fd_sc_hd__tapvpwrvgnd_1
XFILLER_0_22_153 VPWR VGND VPWR VGND sky130_ef_sc_hd__decap_12
X_2570_ u_interface.u_compute_core.u_mac.product_reg\[5\] u_interface.u_compute_core.mac_accum\[5\]
+ VGND VGND VPWR VPWR _1999_ sky130_fd_sc_hd__or2_1
XFILLER_0_50_462 VPWR VGND VPWR VGND sky130_ef_sc_hd__decap_12
XFILLER_0_10_326 VGND VGND VPWR VPWR sky130_fd_sc_hd__decap_3
XFILLER_0_77_69 VPWR VGND VPWR VGND sky130_ef_sc_hd__decap_12
X_4240_ _1404_ _1408_ _1458_ VGND VGND VPWR VPWR _1459_ sky130_fd_sc_hd__a21o_1
X_4171_ _1389_ _1390_ VGND VGND VPWR VPWR _1391_ sky130_fd_sc_hd__xnor2_1
X_3122_ _0374_ _0375_ VGND VGND VPWR VPWR _0376_ sky130_fd_sc_hd__nand2_1
X_3053_ _0305_ _0308_ VGND VGND VPWR VPWR _0309_ sky130_fd_sc_hd__and2_1
XFILLER_0_26_51 VPWR VGND VPWR VGND sky130_ef_sc_hd__decap_12
XFILLER_0_18_404 VGND VGND VPWR VPWR sky130_fd_sc_hd__fill_1
X_3955_ u_interface.u_compute_core.relu_data\[13\] _0453_ VGND VGND VPWR VPWR _1179_
+ sky130_fd_sc_hd__and2b_1
X_2906_ _2293_ _2300_ VGND VGND VPWR VPWR _2301_ sky130_fd_sc_hd__xnor2_1
XFILLER_0_9_169 VPWR VGND VPWR VGND sky130_ef_sc_hd__decap_12
XFILLER_0_18_437 VGND VGND VPWR VPWR sky130_fd_sc_hd__fill_1
XFILLER_0_45_223 VGND VGND VPWR VPWR sky130_fd_sc_hd__fill_1
XTAP_TAPCELL_ROW_61_696 VGND VPWR sky130_fd_sc_hd__tapvpwrvgnd_1
XFILLER_0_33_418 VGND VGND VPWR VPWR sky130_fd_sc_hd__decap_4
X_3886_ _1105_ _1111_ VGND VGND VPWR VPWR _1112_ sky130_fd_sc_hd__xor2_1
XFILLER_0_5_364 VGND VGND VPWR VPWR sky130_fd_sc_hd__decap_8
X_2837_ _2222_ _2232_ VGND VGND VPWR VPWR _2234_ sky130_fd_sc_hd__and2_1
XFILLER_0_26_470 VGND VGND VPWR VPWR sky130_fd_sc_hd__decap_6
XFILLER_0_60_215 VGND VGND VPWR VPWR sky130_fd_sc_hd__decap_4
X_2768_ net4 VGND VGND VPWR VPWR _2168_ sky130_fd_sc_hd__clkbuf_4
XFILLER_0_5_386 VGND VGND VPWR VPWR sky130_fd_sc_hd__decap_6
XFILLER_0_60_248 VGND VGND VPWR VPWR sky130_fd_sc_hd__decap_4
X_4507_ u_interface.core_attn_out\[28\] net85 VGND VGND VPWR VPWR _1720_ sky130_fd_sc_hd__xnor2_1
X_2699_ u_interface.u_compute_core.mac_accum\[22\] _1969_ _1813_ VGND VGND VPWR VPWR
+ _2111_ sky130_fd_sc_hd__o21a_1
X_4438_ _1464_ _1514_ _1574_ _1652_ _1575_ VGND VGND VPWR VPWR _1653_ sky130_fd_sc_hd__a311o_1
X_4369_ _1583_ _1584_ VGND VGND VPWR VPWR _1585_ sky130_fd_sc_hd__xnor2_1
XTAP_TAPCELL_ROW_69_763 VGND VPWR sky130_fd_sc_hd__tapvpwrvgnd_1
XTAP_TAPCELL_ROW_24_376 VGND VPWR sky130_fd_sc_hd__tapvpwrvgnd_1
XFILLER_0_36_234 VGND VGND VPWR VPWR sky130_fd_sc_hd__fill_2
XFILLER_0_63_27 VPWR VGND VPWR VGND sky130_ef_sc_hd__decap_12
XFILLER_0_59_337 VPWR VGND VPWR VGND sky130_ef_sc_hd__decap_12
XFILLER_0_27_223 VGND VGND VPWR VPWR sky130_fd_sc_hd__fill_1
X_3740_ _0951_ _0968_ VGND VGND VPWR VPWR _0969_ sky130_fd_sc_hd__xor2_1
XFILLER_0_12_97 VGND VGND VPWR VPWR sky130_fd_sc_hd__decap_8
X_3671_ _0897_ _0900_ VGND VGND VPWR VPWR _0901_ sky130_fd_sc_hd__xnor2_2
XFILLER_0_2_301 VGND VGND VPWR VPWR sky130_fd_sc_hd__decap_6
XFILLER_0_42_248 VGND VGND VPWR VPWR sky130_fd_sc_hd__decap_4
X_2622_ net134 _2026_ _2044_ _1973_ VGND VGND VPWR VPWR _0070_ sky130_fd_sc_hd__a22o_1
XFILLER_0_2_345 VPWR VGND VPWR VGND sky130_ef_sc_hd__decap_12
XFILLER_0_23_473 VGND VGND VPWR VPWR sky130_fd_sc_hd__decap_8
X_2553_ _1981_ _1982_ _1984_ VGND VGND VPWR VPWR _1985_ sky130_fd_sc_hd__and3_1
XFILLER_0_2_389 VPWR VGND VPWR VGND sky130_ef_sc_hd__decap_12
X_2484_ u_interface.u_compute_core.scaled_data\[14\] u_interface.u_compute_core.mac_accum\[17\]
+ _1922_ VGND VGND VPWR VPWR _1934_ sky130_fd_sc_hd__mux2_1
X_4223_ _1439_ _1441_ VGND VGND VPWR VPWR _1442_ sky130_fd_sc_hd__xnor2_1
X_4154_ _1360_ _1357_ _1372_ _1276_ _1373_ VGND VGND VPWR VPWR _1374_ sky130_fd_sc_hd__o221a_1
X_3105_ _0359_ VGND VGND VPWR VPWR _0360_ sky130_fd_sc_hd__inv_2
X_4085_ _1199_ _1252_ _1250_ VGND VGND VPWR VPWR _1307_ sky130_fd_sc_hd__a21oi_1
X_3036_ _0253_ _0255_ _0251_ VGND VGND VPWR VPWR _0293_ sky130_fd_sc_hd__o21ai_1
XTAP_TAPCELL_ROW_66_733 VGND VPWR sky130_fd_sc_hd__tapvpwrvgnd_1
XFILLER_0_77_167 VGND VGND VPWR VPWR sky130_fd_sc_hd__fill_1
XFILLER_0_65_307 VGND VGND VPWR VPWR sky130_fd_sc_hd__fill_2
XFILLER_0_18_245 VGND VGND VPWR VPWR sky130_fd_sc_hd__decap_6
X_3938_ _1129_ _1130_ _1162_ VGND VGND VPWR VPWR _1163_ sky130_fd_sc_hd__and3_1
XTAP_TAPCELL_ROW_21_357 VGND VPWR sky130_fd_sc_hd__tapvpwrvgnd_1
XFILLER_0_33_237 VGND VGND VPWR VPWR sky130_fd_sc_hd__fill_2
X_3869_ _0511_ _1859_ _1856_ _0680_ VGND VGND VPWR VPWR _1095_ sky130_fd_sc_hd__a22oi_1
XFILLER_0_5_161 VGND VGND VPWR VPWR sky130_fd_sc_hd__decap_6
Xclkbuf_4_2_0_clk clknet_0_clk VGND VGND VPWR VPWR clknet_4_2_0_clk sky130_fd_sc_hd__clkbuf_8
XTAP_TAPCELL_ROW_29_424 VGND VPWR sky130_fd_sc_hd__tapvpwrvgnd_1
XTAP_TAPCELL_ROW_37_490 VGND VPWR sky130_fd_sc_hd__tapvpwrvgnd_1
Xinput17 s_tdata[22] VGND VGND VPWR VPWR net17 sky130_fd_sc_hd__clkbuf_2
XFILLER_0_24_215 VGND VGND VPWR VPWR sky130_fd_sc_hd__decap_6
Xinput28 s_tvalid VGND VGND VPWR VPWR net28 sky130_fd_sc_hd__clkbuf_1
XFILLER_0_20_421 VGND VGND VPWR VPWR sky130_fd_sc_hd__fill_2
XFILLER_0_58_27 VGND VGND VPWR VPWR sky130_fd_sc_hd__fill_1
XFILLER_0_74_15 VPWR VGND VPWR VGND sky130_ef_sc_hd__decap_12
XTAP_TAPCELL_ROW_63_714 VGND VPWR sky130_fd_sc_hd__tapvpwrvgnd_1
XFILLER_0_47_329 VGND VGND VPWR VPWR sky130_fd_sc_hd__decap_6
XFILLER_0_23_41 VPWR VGND VPWR VGND sky130_ef_sc_hd__decap_12
XTAP_TAPCELL_ROW_71_780 VGND VPWR sky130_fd_sc_hd__tapvpwrvgnd_1
X_4772_ clknet_4_14_0_clk _0137_ VGND VGND VPWR VPWR u_interface.core_attn_out\[20\]
+ sky130_fd_sc_hd__dfxtp_1
X_3723_ _0511_ _1850_ _1845_ _0680_ VGND VGND VPWR VPWR _0952_ sky130_fd_sc_hd__a22oi_1
XFILLER_0_70_354 VGND VGND VPWR VPWR sky130_fd_sc_hd__decap_4
XFILLER_0_15_248 VGND VGND VPWR VPWR sky130_fd_sc_hd__decap_3
X_3654_ _0884_ u_interface.core_attn_out\[10\] VGND VGND VPWR VPWR _0885_ sky130_fd_sc_hd__nand2_1
XFILLER_0_70_365 VPWR VGND VPWR VGND sky130_ef_sc_hd__decap_12
X_2605_ _2028_ _2029_ VGND VGND VPWR VPWR _2030_ sky130_fd_sc_hd__nor2_1
XFILLER_0_11_421 VGND VGND VPWR VPWR sky130_fd_sc_hd__decap_3
XFILLER_0_2_153 VPWR VGND VPWR VGND sky130_ef_sc_hd__decap_12
X_3585_ _0815_ _0816_ VGND VGND VPWR VPWR _0817_ sky130_fd_sc_hd__xnor2_2
XFILLER_0_2_197 VPWR VGND VPWR VGND sky130_ef_sc_hd__decap_12
X_2536_ u_interface.u_compute_core.u_mac.product_reg\[0\] _1969_ net116 VGND VGND
+ VPWR VPWR _1970_ sky130_fd_sc_hd__a21oi_1
X_2467_ u_interface.u_compute_core.mac_last VGND VGND VPWR VPWR _1922_ sky130_fd_sc_hd__clkbuf_4
XFILLER_0_47_3 VPWR VGND VPWR VGND sky130_ef_sc_hd__decap_12
X_4206_ u_interface.u_compute_core.relu_data\[18\] _0453_ VGND VGND VPWR VPWR _1425_
+ sky130_fd_sc_hd__and2b_1
X_2398_ _1848_ _1873_ VGND VGND VPWR VPWR _0017_ sky130_fd_sc_hd__nor2_1
XFILLER_0_3_51 VGND VGND VPWR VPWR sky130_fd_sc_hd__decap_4
X_4137_ _1323_ _1308_ _1356_ VGND VGND VPWR VPWR _1358_ sky130_fd_sc_hd__a21oi_1
X_4068_ _1288_ _1289_ VGND VGND VPWR VPWR _1290_ sky130_fd_sc_hd__xnor2_1
X_3019_ _0270_ _0274_ VGND VGND VPWR VPWR _0276_ sky130_fd_sc_hd__nor2_1
XFILLER_0_38_318 VGND VGND VPWR VPWR sky130_fd_sc_hd__decap_4
XFILLER_0_46_362 VGND VGND VPWR VPWR sky130_fd_sc_hd__fill_2
XTAP_TAPCELL_ROW_77_828 VGND VPWR sky130_fd_sc_hd__tapvpwrvgnd_1
XFILLER_0_44_29 VGND VGND VPWR VPWR sky130_fd_sc_hd__fill_1
XFILLER_0_71_129 VPWR VGND VPWR VGND sky130_ef_sc_hd__decap_12
XFILLER_0_64_170 VPWR VGND VPWR VGND sky130_ef_sc_hd__decap_12
XFILLER_0_52_365 VPWR VGND VPWR VGND sky130_ef_sc_hd__decap_12
XFILLER_0_69_15 VPWR VGND VPWR VGND sky130_ef_sc_hd__decap_12
X_3370_ _0562_ _0563_ VGND VGND VPWR VPWR _0607_ sky130_fd_sc_hd__nor2_1
XFILLER_0_20_240 VPWR VGND VPWR VGND sky130_ef_sc_hd__decap_12
X_2321_ u_interface.u_compute_core.scaled_data\[28\] u_interface.u_compute_core.scaled_valid
+ VGND VGND VPWR VPWR _1814_ sky130_fd_sc_hd__nor2b_2
XFILLER_0_20_295 VGND VGND VPWR VPWR sky130_fd_sc_hd__decap_6
XFILLER_0_18_74 VGND VGND VPWR VPWR sky130_fd_sc_hd__fill_1
XFILLER_0_18_96 VGND VGND VPWR VPWR sky130_fd_sc_hd__decap_8
XTAP_TAPCELL_ROW_48_585 VGND VPWR sky130_fd_sc_hd__tapvpwrvgnd_1
XFILLER_0_47_104 VGND VGND VPWR VPWR sky130_fd_sc_hd__decap_8
XFILLER_0_7_223 VGND VGND VPWR VPWR sky130_fd_sc_hd__fill_1
X_4755_ clknet_4_10_0_clk _0120_ VGND VGND VPWR VPWR u_interface.core_attn_out\[3\]
+ sky130_fd_sc_hd__dfxtp_1
XFILLER_0_28_384 VPWR VGND VPWR VGND sky130_ef_sc_hd__decap_12
XTAP_TAPCELL_ROW_31_441 VGND VPWR sky130_fd_sc_hd__tapvpwrvgnd_1
X_3706_ _0934_ _0935_ VGND VGND VPWR VPWR _0936_ sky130_fd_sc_hd__xnor2_1
XFILLER_0_7_278 VGND VGND VPWR VPWR sky130_fd_sc_hd__fill_2
XFILLER_0_50_83 VGND VGND VPWR VPWR sky130_fd_sc_hd__fill_1
XFILLER_0_55_192 VGND VGND VPWR VPWR sky130_fd_sc_hd__fill_1
X_4686_ clknet_4_7_0_clk _0051_ VGND VGND VPWR VPWR u_interface.u_compute_core.scaled_data\[22\]
+ sky130_fd_sc_hd__dfxtp_1
X_3637_ _0818_ _0820_ VGND VGND VPWR VPWR _0868_ sky130_fd_sc_hd__and2_1
X_3568_ _0480_ _0799_ _0800_ _0667_ VGND VGND VPWR VPWR _0125_ sky130_fd_sc_hd__o211a_1
XFILLER_0_3_473 VGND VGND VPWR VPWR sky130_fd_sc_hd__decap_8
X_2519_ u_interface.u_compute_core.scaled_data\[25\] u_interface.u_compute_core.mac_accum\[28\]
+ _1944_ VGND VGND VPWR VPWR _1958_ sky130_fd_sc_hd__mux2_1
X_3499_ _0437_ u_interface.u_compute_core.relu_data\[6\] _0685_ VGND VGND VPWR VPWR
+ _0733_ sky130_fd_sc_hd__and3_1
XTAP_TAPCELL_ROW_74_809 VGND VPWR sky130_fd_sc_hd__tapvpwrvgnd_1
XTAP_TAPCELL_ROW_3_199 VGND VPWR sky130_fd_sc_hd__tapvpwrvgnd_1
XFILLER_0_78_295 VGND VGND VPWR VPWR sky130_fd_sc_hd__fill_1
XFILLER_0_78_273 VPWR VGND VPWR VGND sky130_ef_sc_hd__decap_12
XFILLER_0_81_405 VPWR VGND VPWR VGND sky130_ef_sc_hd__decap_12
XFILLER_0_81_427 VPWR VGND VPWR VGND sky130_ef_sc_hd__decap_12
XPHY_EDGE_ROW_49_Left_131 VGND VGND VPWR VPWR sky130_fd_sc_hd__decap_3
XFILLER_0_81_449 VPWR VGND VPWR VGND sky130_ef_sc_hd__decap_12
XFILLER_0_34_365 VGND VGND VPWR VPWR sky130_fd_sc_hd__decap_8
XFILLER_0_61_173 VGND VGND VPWR VPWR sky130_fd_sc_hd__decap_6
XPHY_EDGE_ROW_58_Left_140 VGND VGND VPWR VPWR sky130_fd_sc_hd__decap_3
XFILLER_0_71_27 VPWR VGND VPWR VGND sky130_ef_sc_hd__decap_12
XTAP_TAPCELL_ROW_45_555 VGND VPWR sky130_fd_sc_hd__tapvpwrvgnd_1
X_2870_ _2265_ _2228_ _2231_ VGND VGND VPWR VPWR _2266_ sky130_fd_sc_hd__o21ai_1
X_4540_ _1742_ net91 _1746_ VGND VGND VPWR VPWR _0151_ sky130_fd_sc_hd__o21a_1
XFILLER_0_52_151 VPWR VGND VPWR VGND sky130_ef_sc_hd__decap_12
X_4471_ _1653_ _1651_ _1661_ _1649_ _1684_ VGND VGND VPWR VPWR _1685_ sky130_fd_sc_hd__a311o_1
XFILLER_0_20_53 VPWR VGND VPWR VGND sky130_ef_sc_hd__decap_12
X_3422_ _0606_ _0608_ _0657_ VGND VGND VPWR VPWR _0658_ sky130_fd_sc_hd__a21boi_1
XFILLER_0_0_421 VPWR VGND VPWR VGND sky130_ef_sc_hd__decap_12
XFILLER_0_40_357 VGND VGND VPWR VPWR sky130_fd_sc_hd__decap_6
X_3353_ _0545_ _0589_ VGND VGND VPWR VPWR _0590_ sky130_fd_sc_hd__xnor2_1
X_3284_ _0510_ _0521_ _0522_ VGND VGND VPWR VPWR _0523_ sky130_fd_sc_hd__nand3_1
XTAP_TAPCELL_ROW_0_169 VGND VPWR sky130_fd_sc_hd__tapvpwrvgnd_1
XFILLER_0_75_221 VGND VGND VPWR VPWR sky130_fd_sc_hd__decap_3
XFILLER_0_0_41 VPWR VGND VPWR VGND sky130_ef_sc_hd__decap_12
XFILLER_0_0_85 VGND VGND VPWR VPWR sky130_fd_sc_hd__fill_2
XFILLER_0_0_63 VGND VGND VPWR VPWR sky130_fd_sc_hd__decap_8
XPHY_EDGE_ROW_3_Right_3 VGND VGND VPWR VPWR sky130_fd_sc_hd__decap_3
X_4807_ clknet_4_15_0_clk _0172_ VGND VGND VPWR VPWR net43 sky130_fd_sc_hd__dfxtp_1
XFILLER_0_16_321 VGND VGND VPWR VPWR sky130_fd_sc_hd__fill_1
X_2999_ _0211_ _0212_ _0214_ VGND VGND VPWR VPWR _0257_ sky130_fd_sc_hd__a21o_1
XFILLER_0_63_449 VGND VGND VPWR VPWR sky130_fd_sc_hd__fill_2
XFILLER_0_16_376 VGND VGND VPWR VPWR sky130_fd_sc_hd__fill_1
X_4738_ clknet_4_0_0_clk _0103_ VGND VGND VPWR VPWR u_interface.u_compute_core.u_mac.product_reg\[12\]
+ sky130_fd_sc_hd__dfxtp_1
X_4669_ clknet_4_3_0_clk _0034_ VGND VGND VPWR VPWR u_interface.u_compute_core.scaled_data\[5\]
+ sky130_fd_sc_hd__dfxtp_1
XFILLER_0_3_281 VPWR VGND VPWR VGND sky130_ef_sc_hd__decap_12
XTAP_TAPCELL_ROW_8_247 VGND VPWR sky130_fd_sc_hd__tapvpwrvgnd_1
XTAP_TAPCELL_ROW_42_536 VGND VPWR sky130_fd_sc_hd__tapvpwrvgnd_1
XFILLER_0_26_118 VPWR VGND VPWR VGND sky130_ef_sc_hd__decap_12
XFILLER_0_39_479 VGND VGND VPWR VPWR sky130_fd_sc_hd__fill_1
XFILLER_0_19_181 VGND VGND VPWR VPWR sky130_fd_sc_hd__decap_8
XFILLER_0_81_279 VGND VGND VPWR VPWR sky130_fd_sc_hd__fill_1
XFILLER_0_34_173 VGND VGND VPWR VPWR sky130_fd_sc_hd__fill_2
XFILLER_0_34_195 VGND VGND VPWR VPWR sky130_fd_sc_hd__fill_1
XFILLER_0_66_27 VGND VGND VPWR VPWR sky130_fd_sc_hd__fill_1
XFILLER_0_15_42 VPWR VGND VPWR VGND sky130_ef_sc_hd__decap_12
X_3971_ _1192_ _1194_ VGND VGND VPWR VPWR _1195_ sky130_fd_sc_hd__xnor2_1
X_2922_ _2315_ _2316_ net97 _2006_ VGND VGND VPWR VPWR _0098_ sky130_fd_sc_hd__a2bb2o_1
XFILLER_0_57_265 VGND VGND VPWR VPWR sky130_fd_sc_hd__fill_1
XFILLER_0_72_246 VGND VGND VPWR VPWR sky130_fd_sc_hd__decap_6
XFILLER_0_17_129 VPWR VGND VPWR VGND sky130_ef_sc_hd__decap_12
X_2853_ _2247_ _2248_ VGND VGND VPWR VPWR _2249_ sky130_fd_sc_hd__nor2_1
XFILLER_0_31_52 VGND VGND VPWR VPWR sky130_fd_sc_hd__fill_1
XFILLER_0_45_449 VPWR VGND VPWR VGND sky130_ef_sc_hd__decap_12
X_2784_ _2161_ _2163_ _2169_ _2182_ VGND VGND VPWR VPWR _2183_ sky130_fd_sc_hd__nand4_2
X_4523_ _1733_ VGND VGND VPWR VPWR _1734_ sky130_fd_sc_hd__inv_2
XFILLER_0_40_121 VGND VGND VPWR VPWR sky130_fd_sc_hd__decap_4
X_4454_ _1666_ _1667_ VGND VGND VPWR VPWR _1668_ sky130_fd_sc_hd__xnor2_1
X_4385_ _1599_ _1600_ VGND VGND VPWR VPWR _1601_ sky130_fd_sc_hd__nand2_1
X_3405_ u_interface.u_compute_core.relu_data\[1\] _0596_ VGND VGND VPWR VPWR _0641_
+ sky130_fd_sc_hd__nor2b_2
XTAP_TAPCELL_ROW_5_217 VGND VPWR sky130_fd_sc_hd__tapvpwrvgnd_1
X_3336_ u_interface.core_attn_out\[3\] _0572_ VGND VGND VPWR VPWR _0574_ sky130_fd_sc_hd__or2_1
X_3267_ _0462_ _0494_ VGND VGND VPWR VPWR _0506_ sky130_fd_sc_hd__and2_1
X_3198_ _0442_ VGND VGND VPWR VPWR _0443_ sky130_fd_sc_hd__clkbuf_4
XFILLER_0_48_265 VPWR VGND VPWR VGND sky130_ef_sc_hd__decap_12
XFILLER_0_8_351 VGND VGND VPWR VPWR sky130_fd_sc_hd__fill_1
XFILLER_0_16_151 VGND VGND VPWR VPWR sky130_fd_sc_hd__decap_4
XFILLER_0_8_395 VPWR VGND VPWR VGND sky130_ef_sc_hd__decap_12
XFILLER_0_44_471 VGND VGND VPWR VPWR sky130_fd_sc_hd__decap_4
XFILLER_0_36_19 VGND VGND VPWR VPWR sky130_fd_sc_hd__decap_8
XFILLER_0_39_221 VGND VGND VPWR VPWR sky130_fd_sc_hd__decap_3
XFILLER_0_27_449 VGND VGND VPWR VPWR sky130_fd_sc_hd__decap_6
XTAP_TAPCELL_ROW_10_263 VGND VPWR sky130_fd_sc_hd__tapvpwrvgnd_1
XFILLER_0_62_290 VGND VGND VPWR VPWR sky130_fd_sc_hd__fill_1
XFILLER_0_77_15 VPWR VGND VPWR VGND sky130_ef_sc_hd__decap_12
XFILLER_0_10_316 VGND VGND VPWR VPWR sky130_fd_sc_hd__decap_4
XFILLER_0_22_165 VGND VGND VPWR VPWR sky130_fd_sc_hd__decap_8
XFILLER_0_50_474 VGND VGND VPWR VPWR sky130_fd_sc_hd__fill_2
X_4170_ _0432_ _1884_ VGND VGND VPWR VPWR _1390_ sky130_fd_sc_hd__nand2_1
X_3121_ _0365_ _0373_ VGND VGND VPWR VPWR _0375_ sky130_fd_sc_hd__or2_1
X_3052_ _0237_ _0307_ VGND VGND VPWR VPWR _0308_ sky130_fd_sc_hd__xor2_4
XFILLER_0_26_41 VGND VGND VPWR VPWR sky130_fd_sc_hd__decap_3
XTAP_TAPCELL_ROW_18_330 VGND VPWR sky130_fd_sc_hd__tapvpwrvgnd_1
XFILLER_0_26_85 VGND VGND VPWR VPWR sky130_fd_sc_hd__fill_2
XFILLER_0_45_202 VGND VGND VPWR VPWR sky130_fd_sc_hd__fill_1
X_3954_ _0938_ _1177_ _1178_ _0667_ VGND VGND VPWR VPWR _0133_ sky130_fd_sc_hd__o211a_1
X_2905_ _2298_ _2299_ VGND VGND VPWR VPWR _2300_ sky130_fd_sc_hd__nor2_1
X_3885_ _1042_ _1110_ VGND VGND VPWR VPWR _1111_ sky130_fd_sc_hd__xor2_1
X_2836_ _2222_ _2232_ VGND VGND VPWR VPWR _2233_ sky130_fd_sc_hd__nor2_1
XFILLER_0_45_279 VGND VGND VPWR VPWR sky130_fd_sc_hd__fill_1
XTAP_TAPCELL_ROW_61_697 VGND VPWR sky130_fd_sc_hd__tapvpwrvgnd_1
XFILLER_0_5_332 VGND VGND VPWR VPWR sky130_fd_sc_hd__decap_4
X_2767_ _2020_ _2165_ _2167_ _2100_ net102 VGND VGND VPWR VPWR _0092_ sky130_fd_sc_hd__a32o_1
X_4506_ _1718_ _1702_ VGND VGND VPWR VPWR _1719_ sky130_fd_sc_hd__xnor2_4
XFILLER_0_77_3 VPWR VGND VPWR VGND sky130_ef_sc_hd__decap_12
X_2698_ _2107_ _2109_ VGND VGND VPWR VPWR _2110_ sky130_fd_sc_hd__xnor2_1
X_4437_ _1609_ VGND VGND VPWR VPWR _1652_ sky130_fd_sc_hd__inv_2
X_4368_ _1533_ _1535_ _1532_ VGND VGND VPWR VPWR _1584_ sky130_fd_sc_hd__o21ba_1
X_3319_ _0441_ _0484_ u_interface.u_compute_core.relu_data\[3\] u_interface.u_compute_core.relu_data\[2\]
+ VGND VGND VPWR VPWR _0557_ sky130_fd_sc_hd__nand4_1
X_4299_ u_interface.core_attn_out\[23\] _1515_ _1516_ VGND VGND VPWR VPWR _1517_ sky130_fd_sc_hd__and3_1
XTAP_TAPCELL_ROW_69_764 VGND VPWR sky130_fd_sc_hd__tapvpwrvgnd_1
XTAP_TAPCELL_ROW_52_620 VGND VPWR sky130_fd_sc_hd__tapvpwrvgnd_1
XTAP_TAPCELL_ROW_24_377 VGND VPWR sky130_fd_sc_hd__tapvpwrvgnd_1
XFILLER_0_17_460 VGND VGND VPWR VPWR sky130_fd_sc_hd__fill_1
XFILLER_0_32_474 VGND VGND VPWR VPWR sky130_fd_sc_hd__fill_2
XFILLER_0_63_39 VPWR VGND VPWR VGND sky130_ef_sc_hd__decap_12
XTAP_TAPCELL_ROW_15_300 VGND VPWR sky130_fd_sc_hd__tapvpwrvgnd_1
XFILLER_0_59_349 VPWR VGND VPWR VGND sky130_ef_sc_hd__decap_12
X_3670_ _0898_ _0899_ VGND VGND VPWR VPWR _0900_ sky130_fd_sc_hd__or2_1
XFILLER_0_42_216 VGND VGND VPWR VPWR sky130_fd_sc_hd__fill_1
X_2621_ _2040_ _2043_ VGND VGND VPWR VPWR _2044_ sky130_fd_sc_hd__xnor2_1
XFILLER_0_2_357 VGND VGND VPWR VPWR sky130_fd_sc_hd__decap_6
X_2552_ u_interface.u_compute_core.u_mac.product_reg\[0\] u_interface.u_compute_core.mac_accum\[0\]
+ _1975_ _1983_ VGND VGND VPWR VPWR _1984_ sky130_fd_sc_hd__a31o_1
XFILLER_0_50_260 VGND VGND VPWR VPWR sky130_fd_sc_hd__decap_8
XFILLER_0_10_124 VPWR VGND VPWR VGND sky130_ef_sc_hd__decap_12
XFILLER_0_10_146 VPWR VGND VPWR VGND sky130_ef_sc_hd__decap_12
X_2483_ _1933_ VGND VGND VPWR VPWR _0042_ sky130_fd_sc_hd__clkbuf_1
X_4222_ _1386_ _1391_ _1440_ VGND VGND VPWR VPWR _1441_ sky130_fd_sc_hd__a21oi_1
X_4153_ _1358_ VGND VGND VPWR VPWR _1373_ sky130_fd_sc_hd__inv_2
X_3104_ _0322_ _0325_ _0358_ VGND VGND VPWR VPWR _0359_ sky130_fd_sc_hd__a21o_1
XFILLER_0_37_73 VGND VGND VPWR VPWR sky130_fd_sc_hd__decap_8
X_4084_ _1303_ _1305_ VGND VGND VPWR VPWR _1306_ sky130_fd_sc_hd__xor2_1
X_3035_ _0290_ _0291_ VGND VGND VPWR VPWR _0292_ sky130_fd_sc_hd__nand2_1
XTAP_TAPCELL_ROW_66_734 VGND VPWR sky130_fd_sc_hd__tapvpwrvgnd_1
XFILLER_0_77_113 VPWR VGND VPWR VGND sky130_ef_sc_hd__decap_12
XFILLER_0_53_50 VGND VGND VPWR VPWR sky130_fd_sc_hd__fill_1
XFILLER_0_18_224 VGND VGND VPWR VPWR sky130_fd_sc_hd__fill_2
X_3937_ _1159_ _1161_ VGND VGND VPWR VPWR _1162_ sky130_fd_sc_hd__xnor2_1
XTAP_TAPCELL_ROW_21_358 VGND VPWR sky130_fd_sc_hd__tapvpwrvgnd_1
X_3868_ _1091_ _1093_ VGND VGND VPWR VPWR _1094_ sky130_fd_sc_hd__xor2_1
X_2819_ _2214_ _2215_ VGND VGND VPWR VPWR _2216_ sky130_fd_sc_hd__nor2_1
X_3799_ u_interface.core_attn_out\[13\] _1026_ VGND VGND VPWR VPWR _1027_ sky130_fd_sc_hd__nand2_1
XFILLER_0_14_474 VGND VGND VPWR VPWR sky130_fd_sc_hd__fill_2
XPHY_EDGE_ROW_21_Left_103 VGND VGND VPWR VPWR sky130_fd_sc_hd__decap_3
XTAP_TAPCELL_ROW_29_425 VGND VPWR sky130_fd_sc_hd__tapvpwrvgnd_1
XTAP_TAPCELL_ROW_37_491 VGND VPWR sky130_fd_sc_hd__tapvpwrvgnd_1
XPHY_EDGE_ROW_30_Left_112 VGND VGND VPWR VPWR sky130_fd_sc_hd__decap_3
XFILLER_0_49_371 VGND VGND VPWR VPWR sky130_fd_sc_hd__fill_1
Xinput18 s_tdata[23] VGND VGND VPWR VPWR net18 sky130_fd_sc_hd__buf_1
XFILLER_0_64_363 VGND VGND VPWR VPWR sky130_fd_sc_hd__fill_1
XFILLER_0_20_477 VGND VGND VPWR VPWR sky130_fd_sc_hd__decap_3
XFILLER_0_74_27 VGND VGND VPWR VPWR sky130_fd_sc_hd__fill_1
XFILLER_0_59_113 VGND VGND VPWR VPWR sky130_fd_sc_hd__decap_4
XTAP_TAPCELL_ROW_63_715 VGND VPWR sky130_fd_sc_hd__tapvpwrvgnd_1
XFILLER_0_7_405 VGND VGND VPWR VPWR sky130_fd_sc_hd__decap_3
XFILLER_0_23_53 VGND VGND VPWR VPWR sky130_fd_sc_hd__decap_3
XTAP_TAPCELL_ROW_71_781 VGND VPWR sky130_fd_sc_hd__tapvpwrvgnd_1
XFILLER_0_7_449 VGND VGND VPWR VPWR sky130_fd_sc_hd__decap_3
X_4771_ clknet_4_14_0_clk _0136_ VGND VGND VPWR VPWR u_interface.core_attn_out\[19\]
+ sky130_fd_sc_hd__dfxtp_1
XFILLER_0_55_330 VGND VGND VPWR VPWR sky130_fd_sc_hd__decap_6
X_3722_ _0899_ _0950_ VGND VGND VPWR VPWR _0951_ sky130_fd_sc_hd__xnor2_1
X_3653_ net71 _0883_ VGND VGND VPWR VPWR _0884_ sky130_fd_sc_hd__xor2_2
XFILLER_0_70_377 VGND VGND VPWR VPWR sky130_fd_sc_hd__decap_6
XFILLER_0_2_121 VPWR VGND VPWR VGND sky130_ef_sc_hd__decap_12
X_2604_ u_interface.u_compute_core.u_mac.product_reg\[9\] u_interface.u_compute_core.mac_accum\[9\]
+ VGND VGND VPWR VPWR _2029_ sky130_fd_sc_hd__nor2_1
XFILLER_0_11_433 VGND VGND VPWR VPWR sky130_fd_sc_hd__decap_4
XFILLER_0_2_165 VPWR VGND VPWR VGND sky130_ef_sc_hd__decap_12
X_3584_ _0484_ u_interface.u_compute_core.relu_data\[9\] VGND VGND VPWR VPWR _0816_
+ sky130_fd_sc_hd__nand2_1
X_2535_ net28 VGND VGND VPWR VPWR _1969_ sky130_fd_sc_hd__buf_2
X_2466_ _1921_ VGND VGND VPWR VPWR _0037_ sky130_fd_sc_hd__clkbuf_1
X_4205_ _1374_ _1375_ _1415_ VGND VGND VPWR VPWR _1424_ sky130_fd_sc_hd__a21oi_1
X_2397_ u_interface.u_compute_core.scaled_data\[17\] _1849_ _1872_ _1843_ VGND VGND
+ VPWR VPWR _1873_ sky130_fd_sc_hd__o2bb2a_1
X_4136_ _1323_ _1308_ _1356_ VGND VGND VPWR VPWR _1357_ sky130_fd_sc_hd__and3_1
X_4067_ _0626_ _1197_ VGND VGND VPWR VPWR _1289_ sky130_fd_sc_hd__nand2_1
X_3018_ _0270_ _0274_ VGND VGND VPWR VPWR _0275_ sky130_fd_sc_hd__and2_1
XFILLER_0_78_477 VGND VGND VPWR VPWR sky130_fd_sc_hd__decap_6
XTAP_TAPCELL_ROW_34_461 VGND VPWR sky130_fd_sc_hd__tapvpwrvgnd_1
XFILLER_0_61_333 VGND VGND VPWR VPWR sky130_fd_sc_hd__decap_3
XFILLER_0_61_344 VPWR VGND VPWR VGND sky130_ef_sc_hd__decap_12
XFILLER_0_21_219 VGND VGND VPWR VPWR sky130_fd_sc_hd__decap_4
XTAP_TAPCELL_ROW_77_829 VGND VPWR sky130_fd_sc_hd__tapvpwrvgnd_1
XFILLER_0_56_127 VPWR VGND VPWR VGND sky130_ef_sc_hd__decap_12
XFILLER_0_71_108 VGND VGND VPWR VPWR sky130_fd_sc_hd__decap_4
XFILLER_0_4_419 VGND VGND VPWR VPWR sky130_fd_sc_hd__fill_1
XFILLER_0_64_182 VPWR VGND VPWR VGND sky130_ef_sc_hd__decap_12
XFILLER_0_69_27 VPWR VGND VPWR VGND sky130_ef_sc_hd__decap_12
X_2320_ _1812_ VGND VGND VPWR VPWR _1813_ sky130_fd_sc_hd__buf_4
Xclkbuf_4_1_0_clk clknet_0_clk VGND VGND VPWR VPWR clknet_4_1_0_clk sky130_fd_sc_hd__clkbuf_8
XTAP_TAPCELL_ROW_48_586 VGND VPWR sky130_fd_sc_hd__tapvpwrvgnd_1
XFILLER_0_75_436 VGND VGND VPWR VPWR sky130_fd_sc_hd__fill_2
X_4754_ clknet_4_10_0_clk _0119_ VGND VGND VPWR VPWR u_interface.core_attn_out\[2\]
+ sky130_fd_sc_hd__dfxtp_1
XTAP_TAPCELL_ROW_31_442 VGND VPWR sky130_fd_sc_hd__tapvpwrvgnd_1
XFILLER_0_50_51 VPWR VGND VPWR VGND sky130_ef_sc_hd__decap_12
X_3705_ _0887_ _0892_ net74 VGND VGND VPWR VPWR _0935_ sky130_fd_sc_hd__o21ai_1
XFILLER_0_43_344 VGND VGND VPWR VPWR sky130_fd_sc_hd__decap_3
X_4685_ clknet_4_7_0_clk _0050_ VGND VGND VPWR VPWR u_interface.u_compute_core.scaled_data\[21\]
+ sky130_fd_sc_hd__dfxtp_1
XFILLER_0_70_141 VPWR VGND VPWR VGND sky130_ef_sc_hd__decap_12
XFILLER_0_3_441 VGND VGND VPWR VPWR sky130_fd_sc_hd__decap_6
X_3636_ _0858_ _0866_ VGND VGND VPWR VPWR _0867_ sky130_fd_sc_hd__xnor2_2
X_3567_ u_interface.core_attn_out\[8\] _0713_ VGND VGND VPWR VPWR _0800_ sky130_fd_sc_hd__or2_1
X_2518_ _1957_ VGND VGND VPWR VPWR _0053_ sky130_fd_sc_hd__clkbuf_1
X_3498_ _0728_ _0731_ VGND VGND VPWR VPWR _0732_ sky130_fd_sc_hd__xnor2_2
X_2449_ u_interface.u_compute_core.scaled_data\[3\] u_interface.u_compute_core.mac_accum\[6\]
+ _1900_ VGND VGND VPWR VPWR _1910_ sky130_fd_sc_hd__mux2_1
XFILLER_0_75_81 VPWR VGND VPWR VGND sky130_ef_sc_hd__decap_12
X_4119_ _1282_ _1284_ VGND VGND VPWR VPWR _1340_ sky130_fd_sc_hd__and2_1
XFILLER_0_66_403 VPWR VGND VPWR VGND sky130_ef_sc_hd__decap_12
XFILLER_0_78_285 VGND VGND VPWR VPWR sky130_fd_sc_hd__decap_3
XFILLER_0_38_149 VGND VGND VPWR VPWR sky130_fd_sc_hd__decap_3
XFILLER_0_81_439 VGND VGND VPWR VPWR sky130_fd_sc_hd__decap_8
XFILLER_0_81_417 VGND VGND VPWR VPWR sky130_fd_sc_hd__decap_3
XFILLER_0_19_352 VGND VGND VPWR VPWR sky130_fd_sc_hd__fill_1
XFILLER_0_34_333 VGND VGND VPWR VPWR sky130_fd_sc_hd__decap_8
XFILLER_0_61_141 VGND VGND VPWR VPWR sky130_fd_sc_hd__fill_1
XFILLER_0_34_388 VPWR VGND VPWR VGND sky130_ef_sc_hd__decap_12
XFILLER_0_71_39 VPWR VGND VPWR VGND sky130_ef_sc_hd__decap_12
XFILLER_0_29_116 VGND VGND VPWR VPWR sky130_fd_sc_hd__decap_6
XTAP_TAPCELL_ROW_45_556 VGND VPWR sky130_fd_sc_hd__tapvpwrvgnd_1
XFILLER_0_29_149 VGND VGND VPWR VPWR sky130_fd_sc_hd__decap_3
XFILLER_0_52_141 VGND VGND VPWR VPWR sky130_fd_sc_hd__fill_2
XFILLER_0_80_483 VGND VGND VPWR VPWR sky130_fd_sc_hd__fill_1
X_4470_ _1682_ _1683_ VGND VGND VPWR VPWR _1684_ sky130_fd_sc_hd__xnor2_1
XFILLER_0_20_65 VGND VGND VPWR VPWR sky130_fd_sc_hd__decap_4
XFILLER_0_52_163 VGND VGND VPWR VPWR sky130_fd_sc_hd__decap_6
X_3421_ _0583_ _0609_ VGND VGND VPWR VPWR _0657_ sky130_fd_sc_hd__nand2b_1
XFILLER_0_40_347 VGND VGND VPWR VPWR sky130_fd_sc_hd__decap_3
X_3352_ _0584_ _0588_ VGND VGND VPWR VPWR _0589_ sky130_fd_sc_hd__xnor2_1
XFILLER_0_0_433 VPWR VGND VPWR VGND sky130_ef_sc_hd__decap_12
XFILLER_0_0_477 VGND VGND VPWR VPWR sky130_fd_sc_hd__decap_6
X_3283_ _0519_ _0520_ _0487_ VGND VGND VPWR VPWR _0522_ sky130_fd_sc_hd__a21bo_1
XFILLER_0_45_40 VGND VGND VPWR VPWR sky130_fd_sc_hd__fill_1
XFILLER_0_45_73 VGND VGND VPWR VPWR sky130_fd_sc_hd__decap_8
XFILLER_0_0_53 VGND VGND VPWR VPWR sky130_fd_sc_hd__decap_3
X_4806_ clknet_4_15_0_clk _0171_ VGND VGND VPWR VPWR net42 sky130_fd_sc_hd__dfxtp_1
XFILLER_0_16_333 VGND VGND VPWR VPWR sky130_fd_sc_hd__fill_1
X_2998_ _0253_ _0255_ VGND VGND VPWR VPWR _0256_ sky130_fd_sc_hd__xnor2_1
X_4737_ clknet_4_0_0_clk _0102_ VGND VGND VPWR VPWR u_interface.u_compute_core.u_mac.product_reg\[11\]
+ sky130_fd_sc_hd__dfxtp_1
XFILLER_0_16_388 VPWR VGND VPWR VGND sky130_ef_sc_hd__decap_12
X_4668_ clknet_4_2_0_clk _0033_ VGND VGND VPWR VPWR u_interface.u_compute_core.scaled_data\[4\]
+ sky130_fd_sc_hd__dfxtp_1
XFILLER_0_31_303 VGND VGND VPWR VPWR sky130_fd_sc_hd__decap_8
X_3619_ _0459_ _0456_ _1859_ _1856_ VGND VGND VPWR VPWR _0850_ sky130_fd_sc_hd__and4_1
XFILLER_0_3_293 VPWR VGND VPWR VGND sky130_ef_sc_hd__decap_12
X_4599_ net41 u_interface.core_attn_out\[20\] _1782_ VGND VGND VPWR VPWR _1787_ sky130_fd_sc_hd__mux2_1
XTAP_TAPCELL_ROW_8_248 VGND VPWR sky130_fd_sc_hd__tapvpwrvgnd_1
XFILLER_0_39_447 VGND VGND VPWR VPWR sky130_fd_sc_hd__fill_1
XTAP_TAPCELL_ROW_42_537 VGND VPWR sky130_fd_sc_hd__tapvpwrvgnd_1
XFILLER_0_81_225 VPWR VGND VPWR VGND sky130_ef_sc_hd__decap_12
XFILLER_0_62_483 VGND VGND VPWR VPWR sky130_fd_sc_hd__fill_1
XPHY_EDGE_ROW_13_Right_13 VGND VGND VPWR VPWR sky130_fd_sc_hd__decap_3
XTAP_TAPCELL_ROW_58_670 VGND VPWR sky130_fd_sc_hd__tapvpwrvgnd_1
XFILLER_0_15_54 VGND VGND VPWR VPWR sky130_fd_sc_hd__fill_2
X_3970_ _1138_ _1143_ _1193_ VGND VGND VPWR VPWR _1194_ sky130_fd_sc_hd__a21boi_1
X_2921_ _2270_ _2272_ _2314_ _2003_ VGND VGND VPWR VPWR _2316_ sky130_fd_sc_hd__a31o_1
XFILLER_0_57_233 VGND VGND VPWR VPWR sky130_fd_sc_hd__fill_2
X_2852_ _2169_ net5 net13 _2202_ VGND VGND VPWR VPWR _2248_ sky130_fd_sc_hd__and4_1
XTAP_TAPCELL_ROW_13_283 VGND VPWR sky130_fd_sc_hd__tapvpwrvgnd_1
X_2783_ net13 VGND VGND VPWR VPWR _2182_ sky130_fd_sc_hd__buf_2
XPHY_EDGE_ROW_22_Right_22 VGND VGND VPWR VPWR sky130_fd_sc_hd__decap_3
X_4522_ _1731_ _1732_ VGND VGND VPWR VPWR _1733_ sky130_fd_sc_hd__nand2_1
XFILLER_0_25_174 VGND VGND VPWR VPWR sky130_fd_sc_hd__fill_2
X_4453_ _0443_ u_interface.u_compute_core.relu_data\[26\] VGND VGND VPWR VPWR _1667_
+ sky130_fd_sc_hd__nand2_1
XFILLER_0_40_144 VGND VGND VPWR VPWR sky130_fd_sc_hd__decap_8
X_3404_ _0639_ _1829_ VGND VGND VPWR VPWR _0640_ sky130_fd_sc_hd__nand2_1
X_4384_ _1598_ _1578_ VGND VGND VPWR VPWR _1600_ sky130_fd_sc_hd__or2b_1
XFILLER_0_21_391 VGND VGND VPWR VPWR sky130_fd_sc_hd__fill_1
XTAP_TAPCELL_ROW_5_218 VGND VPWR sky130_fd_sc_hd__tapvpwrvgnd_1
X_3335_ u_interface.core_attn_out\[3\] _0572_ VGND VGND VPWR VPWR _0573_ sky130_fd_sc_hd__and2_1
X_3266_ _0500_ _0475_ VGND VGND VPWR VPWR _0505_ sky130_fd_sc_hd__and2_4
XPHY_EDGE_ROW_31_Right_31 VGND VGND VPWR VPWR sky130_fd_sc_hd__decap_3
XFILLER_0_56_61 VPWR VGND VPWR VGND sky130_ef_sc_hd__decap_12
X_3197_ _0441_ VGND VGND VPWR VPWR _0442_ sky130_fd_sc_hd__buf_2
XPHY_EDGE_ROW_77_Left_159 VGND VGND VPWR VPWR sky130_fd_sc_hd__decap_3
XFILLER_0_48_200 VPWR VGND VPWR VGND sky130_ef_sc_hd__decap_12
XFILLER_0_48_277 VGND VGND VPWR VPWR sky130_fd_sc_hd__decap_4
XPHY_EDGE_ROW_40_Right_40 VGND VGND VPWR VPWR sky130_fd_sc_hd__decap_3
XFILLER_0_63_225 VGND VGND VPWR VPWR sky130_fd_sc_hd__fill_1
XFILLER_0_16_141 VGND VGND VPWR VPWR sky130_fd_sc_hd__decap_3
XFILLER_0_8_374 VGND VGND VPWR VPWR sky130_fd_sc_hd__decap_6
XFILLER_0_31_166 VGND VGND VPWR VPWR sky130_fd_sc_hd__fill_2
XTAP_TAPCELL_ROW_55_640 VGND VPWR sky130_fd_sc_hd__tapvpwrvgnd_1
XFILLER_0_79_391 VGND VGND VPWR VPWR sky130_fd_sc_hd__fill_1
XFILLER_0_35_461 VGND VGND VPWR VPWR sky130_fd_sc_hd__fill_2
XFILLER_0_35_483 VGND VGND VPWR VPWR sky130_fd_sc_hd__fill_1
XTAP_TAPCELL_ROW_10_264 VGND VPWR sky130_fd_sc_hd__tapvpwrvgnd_1
XFILLER_0_77_27 VPWR VGND VPWR VGND sky130_ef_sc_hd__decap_12
X_3120_ _0365_ _0373_ VGND VGND VPWR VPWR _0374_ sky130_fd_sc_hd__nand2_1
X_3051_ _0271_ _0306_ _2294_ VGND VGND VPWR VPWR _0307_ sky130_fd_sc_hd__and3b_2
XTAP_TAPCELL_ROW_18_331 VGND VPWR sky130_fd_sc_hd__tapvpwrvgnd_1
XFILLER_0_9_105 VGND VGND VPWR VPWR sky130_fd_sc_hd__fill_2
X_3953_ u_interface.core_attn_out\[16\] _0713_ VGND VGND VPWR VPWR _1178_ sky130_fd_sc_hd__or2_1
X_2904_ _2297_ net18 net25 _2295_ VGND VGND VPWR VPWR _2299_ sky130_fd_sc_hd__and4b_1
XFILLER_0_42_85 VPWR VGND VPWR VGND sky130_ef_sc_hd__decap_12
X_3884_ _1106_ _1109_ VGND VGND VPWR VPWR _1110_ sky130_fd_sc_hd__xnor2_1
X_2835_ _2230_ _2231_ VGND VGND VPWR VPWR _2232_ sky130_fd_sc_hd__nand2_1
XTAP_TAPCELL_ROW_61_698 VGND VPWR sky130_fd_sc_hd__tapvpwrvgnd_1
X_2766_ _2161_ _2162_ _2166_ VGND VGND VPWR VPWR _2167_ sky130_fd_sc_hd__nand3_1
XFILLER_0_41_442 VGND VGND VPWR VPWR sky130_fd_sc_hd__decap_6
X_4505_ _1680_ _1717_ VGND VGND VPWR VPWR _1718_ sky130_fd_sc_hd__xnor2_2
XFILLER_0_13_166 VGND VGND VPWR VPWR sky130_fd_sc_hd__fill_2
X_2697_ _2098_ _2101_ _2108_ VGND VGND VPWR VPWR _2109_ sky130_fd_sc_hd__a21oi_1
X_4436_ _1607_ VGND VGND VPWR VPWR _1651_ sky130_fd_sc_hd__inv_2
X_4367_ _1581_ _1582_ VGND VGND VPWR VPWR _1583_ sky130_fd_sc_hd__xnor2_1
X_3318_ _0554_ _0555_ VGND VGND VPWR VPWR _0556_ sky130_fd_sc_hd__nand2_1
XFILLER_0_6_85 VGND VGND VPWR VPWR sky130_fd_sc_hd__fill_2
X_4298_ _1464_ _1514_ _1513_ VGND VGND VPWR VPWR _1516_ sky130_fd_sc_hd__a21o_1
X_3249_ _0487_ _0469_ _0488_ VGND VGND VPWR VPWR _0489_ sky130_fd_sc_hd__and3_1
XTAP_TAPCELL_ROW_69_765 VGND VPWR sky130_fd_sc_hd__tapvpwrvgnd_1
XFILLER_0_68_328 VPWR VGND VPWR VGND sky130_ef_sc_hd__decap_12
XTAP_TAPCELL_ROW_52_621 VGND VPWR sky130_fd_sc_hd__tapvpwrvgnd_1
XFILLER_0_76_372 VGND VGND VPWR VPWR sky130_fd_sc_hd__fill_1
XTAP_TAPCELL_ROW_24_378 VGND VPWR sky130_fd_sc_hd__tapvpwrvgnd_1
XFILLER_0_59_306 VGND VGND VPWR VPWR sky130_fd_sc_hd__decap_3
XTAP_TAPCELL_ROW_15_301 VGND VPWR sky130_fd_sc_hd__tapvpwrvgnd_1
XFILLER_0_27_225 VGND VGND VPWR VPWR sky130_fd_sc_hd__fill_2
XFILLER_0_12_55 VGND VGND VPWR VPWR sky130_fd_sc_hd__fill_2
X_2620_ _2041_ _2042_ VGND VGND VPWR VPWR _2043_ sky130_fd_sc_hd__nor2_1
X_2551_ u_interface.u_compute_core.u_mac.product_reg\[1\] u_interface.u_compute_core.mac_accum\[1\]
+ VGND VGND VPWR VPWR _1983_ sky130_fd_sc_hd__and2_1
XFILLER_0_50_283 VGND VGND VPWR VPWR sky130_fd_sc_hd__fill_1
X_2482_ _1931_ _1932_ VGND VGND VPWR VPWR _1933_ sky130_fd_sc_hd__and2_1
XFILLER_0_10_158 VPWR VGND VPWR VGND sky130_ef_sc_hd__decap_12
XFILLER_0_10_136 VGND VGND VPWR VPWR sky130_fd_sc_hd__decap_4
X_4221_ _1385_ _1383_ VGND VGND VPWR VPWR _1440_ sky130_fd_sc_hd__and2b_1
X_4152_ _1313_ _1359_ VGND VGND VPWR VPWR _1372_ sky130_fd_sc_hd__or2_1
X_3103_ _0356_ _0357_ VGND VGND VPWR VPWR _0358_ sky130_fd_sc_hd__or2_1
X_4083_ _1244_ _1253_ _1304_ VGND VGND VPWR VPWR _1305_ sky130_fd_sc_hd__o21a_1
X_3034_ _0246_ _0289_ VGND VGND VPWR VPWR _0291_ sky130_fd_sc_hd__nand2_1
XTAP_TAPCELL_ROW_66_735 VGND VPWR sky130_fd_sc_hd__tapvpwrvgnd_1
XFILLER_0_77_125 VPWR VGND VPWR VGND sky130_ef_sc_hd__decap_12
XFILLER_0_58_361 VGND VGND VPWR VPWR sky130_fd_sc_hd__decap_3
XFILLER_0_18_214 VGND VGND VPWR VPWR sky130_fd_sc_hd__decap_4
X_3936_ _1042_ _1110_ _1160_ VGND VGND VPWR VPWR _1161_ sky130_fd_sc_hd__a21oi_1
X_3867_ _0442_ _1859_ _1048_ _1092_ VGND VGND VPWR VPWR _1093_ sky130_fd_sc_hd__a31o_1
X_2818_ _2164_ _2169_ net5 net6 VGND VGND VPWR VPWR _2215_ sky130_fd_sc_hd__and4_1
X_3798_ _1018_ _1025_ VGND VGND VPWR VPWR _1026_ sky130_fd_sc_hd__xor2_1
X_2749_ _2151_ _2152_ VGND VGND VPWR VPWR _2153_ sky130_fd_sc_hd__nand2_1
XFILLER_0_41_261 VGND VGND VPWR VPWR sky130_fd_sc_hd__fill_1
X_4419_ _1584_ _1583_ VGND VGND VPWR VPWR _1634_ sky130_fd_sc_hd__and2b_1
XFILLER_0_1_391 VGND VGND VPWR VPWR sky130_fd_sc_hd__fill_1
XTAP_TAPCELL_ROW_29_426 VGND VPWR sky130_fd_sc_hd__tapvpwrvgnd_1
XTAP_TAPCELL_ROW_37_492 VGND VPWR sky130_fd_sc_hd__tapvpwrvgnd_1
XFILLER_0_49_383 VGND VGND VPWR VPWR sky130_fd_sc_hd__decap_4
Xinput19 s_tdata[2] VGND VGND VPWR VPWR net19 sky130_fd_sc_hd__buf_1
XFILLER_0_58_29 VGND VGND VPWR VPWR sky130_fd_sc_hd__decap_4
XFILLER_0_59_169 VGND VGND VPWR VPWR sky130_fd_sc_hd__decap_6
XTAP_TAPCELL_ROW_71_782 VGND VPWR sky130_fd_sc_hd__tapvpwrvgnd_1
XFILLER_0_7_428 VGND VGND VPWR VPWR sky130_fd_sc_hd__decap_3
X_4770_ clknet_4_14_0_clk _0135_ VGND VGND VPWR VPWR u_interface.core_attn_out\[18\]
+ sky130_fd_sc_hd__dfxtp_1
XFILLER_0_70_312 VPWR VGND VPWR VGND sky130_ef_sc_hd__decap_12
X_3721_ _0946_ _0949_ VGND VGND VPWR VPWR _0950_ sky130_fd_sc_hd__xnor2_1
X_3652_ _0833_ _0879_ _0880_ _0882_ VGND VGND VPWR VPWR _0883_ sky130_fd_sc_hd__a31o_1
XFILLER_0_23_250 VPWR VGND VPWR VGND sky130_ef_sc_hd__decap_12
X_3583_ u_interface.u_compute_core.relu_data\[5\] _0596_ VGND VGND VPWR VPWR _0815_
+ sky130_fd_sc_hd__and2b_1
X_2603_ u_interface.u_compute_core.u_mac.product_reg\[9\] u_interface.u_compute_core.mac_accum\[9\]
+ VGND VGND VPWR VPWR _2028_ sky130_fd_sc_hd__and2_1
XFILLER_0_2_133 VGND VGND VPWR VPWR sky130_fd_sc_hd__decap_6
X_2534_ _1968_ _1820_ VGND VGND VPWR VPWR _0058_ sky130_fd_sc_hd__nor2_1
XFILLER_0_2_177 VPWR VGND VPWR VGND sky130_ef_sc_hd__decap_12
X_2465_ _1909_ _1920_ VGND VGND VPWR VPWR _1921_ sky130_fd_sc_hd__and2_1
X_2396_ _1871_ VGND VGND VPWR VPWR _1872_ sky130_fd_sc_hd__inv_2
X_4204_ net122 _0715_ _0434_ _1423_ VGND VGND VPWR VPWR _0138_ sky130_fd_sc_hd__o211a_1
X_4135_ _1354_ _1355_ VGND VGND VPWR VPWR _1356_ sky130_fd_sc_hd__xnor2_1
X_4066_ _1286_ _1287_ VGND VGND VPWR VPWR _1288_ sky130_fd_sc_hd__nor2_1
X_3017_ _0237_ _0273_ VGND VGND VPWR VPWR _0274_ sky130_fd_sc_hd__xor2_1
XFILLER_0_64_83 VGND VGND VPWR VPWR sky130_fd_sc_hd__fill_1
XFILLER_0_38_309 VGND VGND VPWR VPWR sky130_fd_sc_hd__decap_4
XTAP_TAPCELL_ROW_34_462 VGND VPWR sky130_fd_sc_hd__tapvpwrvgnd_1
XFILLER_0_80_109 VPWR VGND VPWR VGND sky130_ef_sc_hd__decap_12
X_3919_ _1138_ _1143_ VGND VGND VPWR VPWR _1144_ sky130_fd_sc_hd__xnor2_1
XFILLER_0_14_250 VGND VGND VPWR VPWR sky130_fd_sc_hd__fill_2
XFILLER_0_61_356 VGND VGND VPWR VPWR sky130_fd_sc_hd__decap_8
XFILLER_0_14_261 VPWR VGND VPWR VGND sky130_ef_sc_hd__decap_12
XPHY_EDGE_ROW_69_Right_69 VGND VGND VPWR VPWR sky130_fd_sc_hd__decap_3
XFILLER_0_56_139 VGND VGND VPWR VPWR sky130_fd_sc_hd__fill_1
XFILLER_0_64_161 VGND VGND VPWR VPWR sky130_fd_sc_hd__fill_1
XFILLER_0_52_345 VPWR VGND VPWR VGND sky130_ef_sc_hd__decap_12
XFILLER_0_64_194 VGND VGND VPWR VPWR sky130_fd_sc_hd__fill_2
XFILLER_0_69_39 VPWR VGND VPWR VGND sky130_ef_sc_hd__decap_12
XPHY_EDGE_ROW_78_Right_78 VGND VGND VPWR VPWR sky130_fd_sc_hd__decap_3
XFILLER_0_20_253 VGND VGND VPWR VPWR sky130_fd_sc_hd__decap_3
XTAP_TAPCELL_ROW_48_587 VGND VPWR sky130_fd_sc_hd__tapvpwrvgnd_1
XFILLER_0_75_404 VPWR VGND VPWR VGND sky130_ef_sc_hd__decap_12
XFILLER_0_34_64 VGND VGND VPWR VPWR sky130_fd_sc_hd__decap_3
XFILLER_0_7_247 VGND VGND VPWR VPWR sky130_fd_sc_hd__decap_8
XFILLER_0_7_225 VGND VGND VPWR VPWR sky130_fd_sc_hd__decap_4
X_4753_ clknet_4_11_0_clk _0118_ VGND VGND VPWR VPWR u_interface.core_attn_out\[1\]
+ sky130_fd_sc_hd__dfxtp_1
XTAP_TAPCELL_ROW_31_443 VGND VPWR sky130_fd_sc_hd__tapvpwrvgnd_1
XFILLER_0_62_109 VGND VGND VPWR VPWR sky130_fd_sc_hd__decap_3
X_3704_ _0932_ _0933_ VGND VGND VPWR VPWR _0934_ sky130_fd_sc_hd__or2b_1
XFILLER_0_43_334 VGND VGND VPWR VPWR sky130_fd_sc_hd__fill_2
XFILLER_0_50_63 VPWR VGND VPWR VGND sky130_ef_sc_hd__decap_12
X_4684_ clknet_4_7_0_clk _0049_ VGND VGND VPWR VPWR u_interface.u_compute_core.scaled_data\[20\]
+ sky130_fd_sc_hd__dfxtp_1
XFILLER_0_70_153 VGND VGND VPWR VPWR sky130_fd_sc_hd__fill_2
X_3635_ _0865_ _0863_ VGND VGND VPWR VPWR _0866_ sky130_fd_sc_hd__xor2_2
XFILLER_0_11_231 VPWR VGND VPWR VGND sky130_ef_sc_hd__decap_12
X_3566_ _0797_ _0798_ VGND VGND VPWR VPWR _0799_ sky130_fd_sc_hd__nor2_1
X_2517_ _1953_ _1956_ VGND VGND VPWR VPWR _1957_ sky130_fd_sc_hd__and2_1
XFILLER_0_11_264 VPWR VGND VPWR VGND sky130_ef_sc_hd__decap_12
X_3497_ _0729_ _0730_ VGND VGND VPWR VPWR _0731_ sky130_fd_sc_hd__xnor2_2
XFILLER_0_59_72 VGND VGND VPWR VPWR sky130_fd_sc_hd__fill_2
X_2448_ _1812_ VGND VGND VPWR VPWR _1909_ sky130_fd_sc_hd__clkbuf_2
XFILLER_0_52_3 VGND VGND VPWR VPWR sky130_fd_sc_hd__decap_6
XTAP_TAPCELL_ROW_39_510 VGND VPWR sky130_fd_sc_hd__tapvpwrvgnd_1
X_2379_ u_interface.u_compute_core.relu_data\[13\] VGND VGND VPWR VPWR _1859_ sky130_fd_sc_hd__buf_2
XFILLER_0_75_93 VPWR VGND VPWR VGND sky130_ef_sc_hd__decap_12
X_4118_ _1333_ _1338_ VGND VGND VPWR VPWR _1339_ sky130_fd_sc_hd__xnor2_1
X_4049_ _1269_ _1271_ VGND VGND VPWR VPWR _1272_ sky130_fd_sc_hd__xnor2_1
XFILLER_0_66_415 VGND VGND VPWR VPWR sky130_fd_sc_hd__fill_2
XTAP_TAPCELL_ROW_73_800 VGND VPWR sky130_fd_sc_hd__tapvpwrvgnd_1
XTAP_TAPCELL_ROW_2_190 VGND VPWR sky130_fd_sc_hd__tapvpwrvgnd_1
XTAP_TAPCELL_ROW_45_557 VGND VPWR sky130_fd_sc_hd__tapvpwrvgnd_1
XFILLER_0_69_297 VGND VGND VPWR VPWR sky130_fd_sc_hd__fill_1
XFILLER_0_72_407 VGND VGND VPWR VPWR sky130_fd_sc_hd__decap_8
XFILLER_0_25_334 VGND VGND VPWR VPWR sky130_fd_sc_hd__fill_2
X_3420_ _0623_ _0655_ VGND VGND VPWR VPWR _0656_ sky130_fd_sc_hd__xnor2_1
X_3351_ _0453_ _0587_ VGND VGND VPWR VPWR _0588_ sky130_fd_sc_hd__xnor2_1
XFILLER_0_0_445 VGND VGND VPWR VPWR sky130_fd_sc_hd__decap_3
X_3282_ _0487_ _0519_ _0520_ VGND VGND VPWR VPWR _0521_ sky130_fd_sc_hd__nand3b_1
XFILLER_0_75_245 VGND VGND VPWR VPWR sky130_fd_sc_hd__decap_6
X_4805_ clknet_4_14_0_clk _0170_ VGND VGND VPWR VPWR net41 sky130_fd_sc_hd__dfxtp_1
X_2997_ _0204_ _0206_ _0254_ VGND VGND VPWR VPWR _0255_ sky130_fd_sc_hd__o21ba_1
XFILLER_0_9_41 VPWR VGND VPWR VGND sky130_ef_sc_hd__decap_12
XFILLER_0_9_30 VGND VGND VPWR VPWR sky130_fd_sc_hd__fill_1
X_4736_ clknet_4_0_0_clk _0101_ VGND VGND VPWR VPWR u_interface.u_compute_core.u_mac.product_reg\[10\]
+ sky130_fd_sc_hd__dfxtp_1
XFILLER_0_9_96 VGND VGND VPWR VPWR sky130_fd_sc_hd__fill_1
X_4667_ clknet_4_2_0_clk _0032_ VGND VGND VPWR VPWR u_interface.u_compute_core.scaled_data\[3\]
+ sky130_fd_sc_hd__dfxtp_1
XFILLER_0_31_315 VGND VGND VPWR VPWR sky130_fd_sc_hd__decap_4
XFILLER_0_3_261 VPWR VGND VPWR VGND sky130_ef_sc_hd__decap_12
XFILLER_0_31_337 VGND VGND VPWR VPWR sky130_fd_sc_hd__decap_8
X_3618_ _0422_ _1859_ _1856_ _0426_ VGND VGND VPWR VPWR _0849_ sky130_fd_sc_hd__a22oi_1
X_4598_ _1786_ VGND VGND VPWR VPWR _0169_ sky130_fd_sc_hd__clkbuf_1
X_3549_ _0779_ _0781_ VGND VGND VPWR VPWR _0782_ sky130_fd_sc_hd__xor2_2
XFILLER_0_54_407 VPWR VGND VPWR VGND sky130_ef_sc_hd__decap_12
XFILLER_0_81_237 VPWR VGND VPWR VGND sky130_ef_sc_hd__decap_12
XFILLER_0_62_451 VGND VGND VPWR VPWR sky130_fd_sc_hd__fill_2
XFILLER_0_62_473 VGND VGND VPWR VPWR sky130_fd_sc_hd__decap_3
XFILLER_0_22_348 VGND VGND VPWR VPWR sky130_fd_sc_hd__decap_3
Xclkbuf_4_0_0_clk clknet_0_clk VGND VGND VPWR VPWR clknet_4_0_0_clk sky130_fd_sc_hd__clkbuf_8
XFILLER_0_34_197 VGND VGND VPWR VPWR sky130_fd_sc_hd__decap_3
XFILLER_0_30_381 VGND VGND VPWR VPWR sky130_fd_sc_hd__fill_1
XFILLER_0_66_29 VPWR VGND VPWR VGND sky130_ef_sc_hd__decap_12
XTAP_TAPCELL_ROW_58_671 VGND VPWR sky130_fd_sc_hd__tapvpwrvgnd_1
XFILLER_0_57_201 VGND VGND VPWR VPWR sky130_fd_sc_hd__decap_8
XFILLER_0_15_99 VGND VGND VPWR VPWR sky130_fd_sc_hd__fill_2
X_2920_ _2270_ _2272_ _2314_ VGND VGND VPWR VPWR _2315_ sky130_fd_sc_hd__a21oi_1
XFILLER_0_57_223 VGND VGND VPWR VPWR sky130_fd_sc_hd__fill_1
XFILLER_0_45_418 VGND VGND VPWR VPWR sky130_fd_sc_hd__fill_1
XFILLER_0_72_215 VPWR VGND VPWR VGND sky130_ef_sc_hd__decap_12
X_2851_ _2178_ _2182_ _2202_ _2169_ VGND VGND VPWR VPWR _2247_ sky130_fd_sc_hd__a22oi_1
XTAP_TAPCELL_ROW_13_284 VGND VPWR sky130_fd_sc_hd__tapvpwrvgnd_1
X_2782_ _2168_ _2180_ VGND VGND VPWR VPWR _2181_ sky130_fd_sc_hd__nand2_1
X_4521_ u_interface.core_attn_out\[30\] _1719_ VGND VGND VPWR VPWR _1732_ sky130_fd_sc_hd__or2b_1
X_4452_ _1664_ _1665_ VGND VGND VPWR VPWR _1666_ sky130_fd_sc_hd__nor2_1
XFILLER_0_13_337 VPWR VGND VPWR VGND sky130_ef_sc_hd__decap_12
X_3403_ u_interface.u_compute_core.u_av.v_extended\[4\] VGND VGND VPWR VPWR _0639_
+ sky130_fd_sc_hd__buf_2
X_4383_ _1578_ _1598_ VGND VGND VPWR VPWR _1599_ sky130_fd_sc_hd__or2b_1
XFILLER_0_0_253 VGND VGND VPWR VPWR sky130_fd_sc_hd__decap_8
X_3334_ _0570_ _0571_ VGND VGND VPWR VPWR _0572_ sky130_fd_sc_hd__xor2_1
XTAP_TAPCELL_ROW_5_219 VGND VPWR sky130_fd_sc_hd__tapvpwrvgnd_1
X_3265_ _0480_ _0503_ _0504_ net62 VGND VGND VPWR VPWR _0118_ sky130_fd_sc_hd__o211a_1
XFILLER_0_56_51 VGND VGND VPWR VPWR sky130_fd_sc_hd__fill_2
XFILLER_0_56_73 VGND VGND VPWR VPWR sky130_fd_sc_hd__decap_8
X_3196_ u_interface.u_compute_core.u_av.v_extended\[4\] VGND VGND VPWR VPWR _0441_
+ sky130_fd_sc_hd__buf_6
XFILLER_0_48_212 VGND VGND VPWR VPWR sky130_fd_sc_hd__decap_4
XFILLER_0_48_234 VPWR VGND VPWR VGND sky130_ef_sc_hd__decap_12
XFILLER_0_63_215 VGND VGND VPWR VPWR sky130_fd_sc_hd__decap_8
XFILLER_0_44_440 VGND VGND VPWR VPWR sky130_fd_sc_hd__fill_2
XFILLER_0_63_248 VPWR VGND VPWR VGND sky130_ef_sc_hd__decap_12
X_4719_ clknet_4_5_0_clk _0084_ VGND VGND VPWR VPWR u_interface.u_compute_core.mac_accum\[25\]
+ sky130_fd_sc_hd__dfxtp_1
XFILLER_0_71_281 VPWR VGND VPWR VGND sky130_ef_sc_hd__decap_12
XPHY_EDGE_ROW_12_Left_94 VGND VGND VPWR VPWR sky130_fd_sc_hd__decap_3
XFILLER_0_31_145 VGND VGND VPWR VPWR sky130_fd_sc_hd__fill_1
XTAP_TAPCELL_ROW_55_641 VGND VPWR sky130_fd_sc_hd__tapvpwrvgnd_1
XFILLER_0_39_289 VGND VGND VPWR VPWR sky130_fd_sc_hd__fill_2
XFILLER_0_54_226 VGND VGND VPWR VPWR sky130_fd_sc_hd__fill_1
XFILLER_0_22_101 VGND VGND VPWR VPWR sky130_fd_sc_hd__decap_4
XTAP_TAPCELL_ROW_10_265 VGND VPWR sky130_fd_sc_hd__tapvpwrvgnd_1
XFILLER_0_77_39 VPWR VGND VPWR VGND sky130_ef_sc_hd__decap_12
X_3050_ _2178_ _2202_ VGND VGND VPWR VPWR _0306_ sky130_fd_sc_hd__or2_1
XTAP_TAPCELL_ROW_18_332 VGND VPWR sky130_fd_sc_hd__tapvpwrvgnd_1
XFILLER_0_18_418 VGND VGND VPWR VPWR sky130_fd_sc_hd__fill_2
XFILLER_0_42_42 VGND VGND VPWR VPWR sky130_fd_sc_hd__decap_3
X_3952_ _1170_ _1176_ VGND VGND VPWR VPWR _1177_ sky130_fd_sc_hd__xor2_1
X_2903_ net25 _2294_ _2296_ _2297_ VGND VGND VPWR VPWR _2298_ sky130_fd_sc_hd__o2bb2a_1
X_3883_ _1107_ _1108_ VGND VGND VPWR VPWR _1109_ sky130_fd_sc_hd__or2_1
X_2834_ _2194_ _2229_ VGND VGND VPWR VPWR _2231_ sky130_fd_sc_hd__nand2_1
XFILLER_0_42_97 VPWR VGND VPWR VGND sky130_ef_sc_hd__decap_12
XFILLER_0_5_345 VGND VGND VPWR VPWR sky130_fd_sc_hd__decap_8
X_4504_ _1704_ _1716_ VGND VGND VPWR VPWR _1717_ sky130_fd_sc_hd__xnor2_1
X_2765_ _2163_ _2164_ VGND VGND VPWR VPWR _2166_ sky130_fd_sc_hd__and2_1
XFILLER_0_41_432 VGND VGND VPWR VPWR sky130_fd_sc_hd__fill_1
XFILLER_0_53_281 VPWR VGND VPWR VGND sky130_ef_sc_hd__decap_12
X_2696_ u_interface.u_compute_core.mac_accum\[21\] u_interface.u_compute_core.mac_accum\[20\]
+ _2068_ VGND VGND VPWR VPWR _2108_ sky130_fd_sc_hd__o21a_1
X_4435_ _1648_ _1649_ VGND VGND VPWR VPWR _1650_ sky130_fd_sc_hd__or2_1
X_4366_ _0443_ _1890_ VGND VGND VPWR VPWR _1582_ sky130_fd_sc_hd__nand2_1
XFILLER_0_6_75 VGND VGND VPWR VPWR sky130_fd_sc_hd__fill_2
X_3317_ _0483_ _1829_ _0552_ _0553_ VGND VGND VPWR VPWR _0555_ sky130_fd_sc_hd__a22o_1
X_4297_ _1464_ _1513_ _1514_ VGND VGND VPWR VPWR _1515_ sky130_fd_sc_hd__nand3_1
X_3248_ u_interface.u_compute_core.u_av.v_extended\[2\] _1824_ _0485_ _0486_ VGND
+ VGND VPWR VPWR _0488_ sky130_fd_sc_hd__a22o_1
XTAP_TAPCELL_ROW_69_766 VGND VPWR sky130_fd_sc_hd__tapvpwrvgnd_1
Xrebuffer20 _1688_ VGND VGND VPWR VPWR net84 sky130_fd_sc_hd__dlygate4sd1_1
X_3179_ _0426_ VGND VGND VPWR VPWR _0427_ sky130_fd_sc_hd__buf_2
XTAP_TAPCELL_ROW_52_622 VGND VPWR sky130_fd_sc_hd__tapvpwrvgnd_1
XFILLER_0_36_226 VGND VGND VPWR VPWR sky130_fd_sc_hd__decap_8
XTAP_TAPCELL_ROW_24_379 VGND VPWR sky130_fd_sc_hd__tapvpwrvgnd_1
XFILLER_0_51_207 VGND VGND VPWR VPWR sky130_fd_sc_hd__fill_1
XFILLER_0_32_421 VGND VGND VPWR VPWR sky130_fd_sc_hd__decap_8
XFILLER_0_32_432 VGND VGND VPWR VPWR sky130_fd_sc_hd__decap_6
XFILLER_0_44_270 VPWR VGND VPWR VGND sky130_ef_sc_hd__decap_12
XFILLER_0_4_3 VPWR VGND VPWR VGND sky130_ef_sc_hd__decap_12
XTAP_TAPCELL_ROW_15_302 VGND VPWR sky130_fd_sc_hd__tapvpwrvgnd_1
XFILLER_0_12_12 VGND VGND VPWR VPWR sky130_fd_sc_hd__fill_1
XFILLER_0_27_215 VGND VGND VPWR VPWR sky130_fd_sc_hd__fill_2
XFILLER_0_12_34 VPWR VGND VPWR VGND sky130_ef_sc_hd__decap_12
XFILLER_0_27_248 VGND VGND VPWR VPWR sky130_fd_sc_hd__decap_4
XFILLER_0_35_281 VGND VGND VPWR VPWR sky130_fd_sc_hd__decap_8
X_2550_ u_interface.u_compute_core.u_mac.product_reg\[2\] u_interface.u_compute_core.mac_accum\[2\]
+ VGND VGND VPWR VPWR _1982_ sky130_fd_sc_hd__or2_1
X_2481_ u_interface.u_compute_core.scaled_data\[13\] u_interface.u_compute_core.mac_accum\[16\]
+ _1922_ VGND VGND VPWR VPWR _1932_ sky130_fd_sc_hd__mux2_1
X_4220_ _1432_ _1438_ VGND VGND VPWR VPWR _1439_ sky130_fd_sc_hd__xnor2_1
X_4151_ _0938_ _1370_ _1371_ _0420_ VGND VGND VPWR VPWR _0137_ sky130_fd_sc_hd__o211a_1
X_3102_ _0316_ _0355_ VGND VGND VPWR VPWR _0357_ sky130_fd_sc_hd__nor2_1
X_4082_ _1241_ _1243_ VGND VGND VPWR VPWR _1304_ sky130_fd_sc_hd__or2_1
X_3033_ _0246_ _0289_ VGND VGND VPWR VPWR _0290_ sky130_fd_sc_hd__or2_1
XTAP_TAPCELL_ROW_66_736 VGND VPWR sky130_fd_sc_hd__tapvpwrvgnd_1
XFILLER_0_77_137 VPWR VGND VPWR VGND sky130_ef_sc_hd__decap_12
X_3935_ _1109_ _1106_ VGND VGND VPWR VPWR _1160_ sky130_fd_sc_hd__and2b_1
XFILLER_0_73_321 VGND VGND VPWR VPWR sky130_fd_sc_hd__decap_6
X_3866_ _0468_ u_interface.u_compute_core.relu_data\[14\] _1046_ VGND VGND VPWR VPWR
+ _1092_ sky130_fd_sc_hd__and3_1
X_2817_ _2169_ _2178_ _2202_ _2164_ VGND VGND VPWR VPWR _2214_ sky130_fd_sc_hd__a22oi_1
XFILLER_0_14_421 VPWR VGND VPWR VGND sky130_ef_sc_hd__decap_12
X_3797_ _0835_ _0839_ _1022_ _1024_ VGND VGND VPWR VPWR _1025_ sky130_fd_sc_hd__a31o_1
XFILLER_0_14_454 VPWR VGND VPWR VGND sky130_ef_sc_hd__decap_12
XFILLER_0_41_240 VGND VGND VPWR VPWR sky130_fd_sc_hd__fill_1
X_2748_ _2068_ u_interface.u_compute_core.mac_accum\[30\] VGND VGND VPWR VPWR _2152_
+ sky130_fd_sc_hd__or2_1
X_4418_ _1626_ _1632_ VGND VGND VPWR VPWR _1633_ sky130_fd_sc_hd__xnor2_1
XFILLER_0_41_295 VPWR VGND VPWR VGND sky130_ef_sc_hd__decap_12
X_2679_ net144 _1969_ _2093_ net62 VGND VGND VPWR VPWR _0078_ sky130_fd_sc_hd__o211a_1
X_4349_ _1564_ _1565_ VGND VGND VPWR VPWR _1566_ sky130_fd_sc_hd__xnor2_1
XTAP_TAPCELL_ROW_37_493 VGND VPWR sky130_fd_sc_hd__tapvpwrvgnd_1
XFILLER_0_49_351 VPWR VGND VPWR VGND sky130_ef_sc_hd__decap_12
XFILLER_0_64_365 VPWR VGND VPWR VGND sky130_ef_sc_hd__decap_12
XFILLER_0_64_398 VGND VGND VPWR VPWR sky130_fd_sc_hd__decap_6
XFILLER_0_32_251 VGND VGND VPWR VPWR sky130_fd_sc_hd__fill_1
XFILLER_0_74_29 VPWR VGND VPWR VGND sky130_ef_sc_hd__decap_12
XTAP_TAPCELL_ROW_71_783 VGND VPWR sky130_fd_sc_hd__tapvpwrvgnd_1
XFILLER_0_23_88 VGND VGND VPWR VPWR sky130_fd_sc_hd__fill_2
X_3720_ _0947_ _0948_ VGND VGND VPWR VPWR _0949_ sky130_fd_sc_hd__or2_1
XFILLER_0_70_324 VPWR VGND VPWR VGND sky130_ef_sc_hd__decap_12
X_3651_ _0881_ VGND VGND VPWR VPWR _0882_ sky130_fd_sc_hd__inv_2
X_3582_ _0639_ _1841_ VGND VGND VPWR VPWR _0814_ sky130_fd_sc_hd__nand2_1
X_2602_ _2022_ _2023_ _2021_ VGND VGND VPWR VPWR _2027_ sky130_fd_sc_hd__a21boi_1
XFILLER_0_11_413 VGND VGND VPWR VPWR sky130_fd_sc_hd__decap_8
XFILLER_0_23_273 VGND VGND VPWR VPWR sky130_fd_sc_hd__fill_1
X_2533_ _1967_ VGND VGND VPWR VPWR _1968_ sky130_fd_sc_hd__clkbuf_4
XFILLER_0_2_189 VGND VGND VPWR VPWR sky130_fd_sc_hd__decap_6
XFILLER_0_11_479 VGND VGND VPWR VPWR sky130_fd_sc_hd__decap_4
XFILLER_0_11_468 VGND VGND VPWR VPWR sky130_fd_sc_hd__fill_2
X_2464_ u_interface.u_compute_core.scaled_data\[8\] u_interface.u_compute_core.mac_accum\[11\]
+ _1900_ VGND VGND VPWR VPWR _1920_ sky130_fd_sc_hd__mux2_1
X_4203_ _0421_ _1422_ VGND VGND VPWR VPWR _1423_ sky130_fd_sc_hd__nand2_1
X_2395_ u_interface.u_compute_core.relu_data\[17\] VGND VGND VPWR VPWR _1871_ sky130_fd_sc_hd__buf_2
XTAP_TAPCELL_ROW_79_850 VGND VPWR sky130_fd_sc_hd__tapvpwrvgnd_1
X_4134_ _1248_ _1301_ _1299_ VGND VGND VPWR VPWR _1355_ sky130_fd_sc_hd__a21oi_1
X_4065_ _0680_ _0511_ u_interface.u_compute_core.relu_data\[17\] u_interface.u_compute_core.relu_data\[16\]
+ VGND VGND VPWR VPWR _1287_ sky130_fd_sc_hd__and4_1
X_3016_ _2256_ _0271_ _0272_ VGND VGND VPWR VPWR _0273_ sky130_fd_sc_hd__a21bo_1
XFILLER_0_78_457 VPWR VGND VPWR VGND sky130_ef_sc_hd__decap_12
XFILLER_0_80_83 VGND VGND VPWR VPWR sky130_fd_sc_hd__fill_1
XTAP_TAPCELL_ROW_34_463 VGND VPWR sky130_fd_sc_hd__tapvpwrvgnd_1
XFILLER_0_58_181 VPWR VGND VPWR VGND sky130_ef_sc_hd__decap_12
XFILLER_0_46_365 VPWR VGND VPWR VGND sky130_ef_sc_hd__decap_12
X_3918_ _1141_ _1142_ VGND VGND VPWR VPWR _1143_ sky130_fd_sc_hd__xnor2_1
X_3849_ _1074_ _1034_ _1035_ VGND VGND VPWR VPWR _1076_ sky130_fd_sc_hd__nand3_1
XFILLER_0_14_273 VGND VGND VPWR VPWR sky130_fd_sc_hd__fill_1
XFILLER_0_52_302 VGND VGND VPWR VPWR sky130_fd_sc_hd__decap_6
XFILLER_0_52_324 VGND VGND VPWR VPWR sky130_fd_sc_hd__fill_2
XFILLER_0_52_357 VGND VGND VPWR VPWR sky130_fd_sc_hd__decap_6
XFILLER_0_20_210 VGND VGND VPWR VPWR sky130_fd_sc_hd__decap_6
XPHY_EDGE_ROW_0_Left_82 VGND VGND VPWR VPWR sky130_fd_sc_hd__decap_3
XFILLER_0_18_44 VGND VGND VPWR VPWR sky130_fd_sc_hd__fill_1
XTAP_TAPCELL_ROW_76_820 VGND VPWR sky130_fd_sc_hd__tapvpwrvgnd_1
XTAP_TAPCELL_ROW_48_588 VGND VPWR sky130_fd_sc_hd__tapvpwrvgnd_1
XFILLER_0_75_416 VPWR VGND VPWR VGND sky130_ef_sc_hd__decap_12
XFILLER_0_28_321 VPWR VGND VPWR VGND sky130_ef_sc_hd__decap_12
X_4752_ clknet_4_11_0_clk _0117_ VGND VGND VPWR VPWR u_interface.core_attn_out\[0\]
+ sky130_fd_sc_hd__dfxtp_1
X_3703_ _0931_ u_interface.core_attn_out\[11\] VGND VGND VPWR VPWR _0933_ sky130_fd_sc_hd__nand2_1
XFILLER_0_50_75 VGND VGND VPWR VPWR sky130_fd_sc_hd__decap_8
XFILLER_0_55_184 VGND VGND VPWR VPWR sky130_fd_sc_hd__decap_8
X_4683_ clknet_4_5_0_clk _0048_ VGND VGND VPWR VPWR u_interface.u_compute_core.scaled_data\[19\]
+ sky130_fd_sc_hd__dfxtp_1
X_3634_ _0689_ _1841_ _0817_ _0864_ VGND VGND VPWR VPWR _0865_ sky130_fd_sc_hd__a31o_1
X_3565_ _0796_ _0759_ VGND VGND VPWR VPWR _0798_ sky130_fd_sc_hd__and2b_1
XFILLER_0_59_51 VGND VGND VPWR VPWR sky130_fd_sc_hd__fill_2
X_2516_ u_interface.u_compute_core.scaled_data\[24\] u_interface.u_compute_core.mac_accum\[27\]
+ _1944_ VGND VGND VPWR VPWR _1956_ sky130_fd_sc_hd__mux2_1
XFILLER_0_11_243 VGND VGND VPWR VPWR sky130_fd_sc_hd__fill_2
X_3496_ _0436_ u_interface.u_compute_core.relu_data\[7\] VGND VGND VPWR VPWR _0730_
+ sky130_fd_sc_hd__nand2_1
XFILLER_0_11_276 VGND VGND VPWR VPWR sky130_fd_sc_hd__decap_4
X_2447_ _1908_ VGND VGND VPWR VPWR _0031_ sky130_fd_sc_hd__clkbuf_1
XFILLER_0_45_3 VGND VGND VPWR VPWR sky130_fd_sc_hd__fill_1
X_2378_ _1848_ _1858_ VGND VGND VPWR VPWR _0012_ sky130_fd_sc_hd__nor2_1
XTAP_TAPCELL_ROW_39_511 VGND VPWR sky130_fd_sc_hd__tapvpwrvgnd_1
X_4117_ _1336_ _1337_ VGND VGND VPWR VPWR _1338_ sky130_fd_sc_hd__xnor2_1
X_4048_ _1170_ _1176_ _1223_ _1270_ VGND VGND VPWR VPWR _1271_ sky130_fd_sc_hd__a31oi_2
XFILLER_0_61_110 VGND VGND VPWR VPWR sky130_fd_sc_hd__fill_2
XFILLER_0_61_121 VPWR VGND VPWR VGND sky130_ef_sc_hd__decap_12
XFILLER_0_61_154 VPWR VGND VPWR VGND sky130_ef_sc_hd__decap_12
XPHY_EDGE_ROW_18_Left_100 VGND VGND VPWR VPWR sky130_fd_sc_hd__decap_3
XTAP_TAPCELL_ROW_2_191 VGND VPWR sky130_fd_sc_hd__tapvpwrvgnd_1
XTAP_TAPCELL_ROW_45_558 VGND VPWR sky130_fd_sc_hd__tapvpwrvgnd_1
XFILLER_0_57_405 VGND VGND VPWR VPWR sky130_fd_sc_hd__decap_3
XFILLER_0_80_441 VPWR VGND VPWR VGND sky130_ef_sc_hd__decap_12
XFILLER_0_80_474 VGND VGND VPWR VPWR sky130_fd_sc_hd__fill_2
X_3350_ _0585_ _0586_ VGND VGND VPWR VPWR _0587_ sky130_fd_sc_hd__xor2_1
XFILLER_0_29_21 VPWR VGND VPWR VGND sky130_ef_sc_hd__decap_12
X_3281_ _0517_ _0518_ _0514_ VGND VGND VPWR VPWR _0520_ sky130_fd_sc_hd__a21o_1
XFILLER_0_29_54 VGND VGND VPWR VPWR sky130_fd_sc_hd__fill_2
XFILLER_0_17_7 VGND VGND VPWR VPWR sky130_fd_sc_hd__fill_2
XFILLER_0_45_97 VPWR VGND VPWR VGND sky130_ef_sc_hd__decap_12
XFILLER_0_48_427 VPWR VGND VPWR VGND sky130_ef_sc_hd__decap_12
X_4804_ clknet_4_14_0_clk _0169_ VGND VGND VPWR VPWR net39 sky130_fd_sc_hd__dfxtp_1
XFILLER_0_61_85 VGND VGND VPWR VPWR sky130_fd_sc_hd__fill_1
X_2996_ _0203_ _0207_ VGND VGND VPWR VPWR _0254_ sky130_fd_sc_hd__and2b_1
X_4735_ clknet_4_0_0_clk _0100_ VGND VGND VPWR VPWR u_interface.u_compute_core.u_mac.product_reg\[9\]
+ sky130_fd_sc_hd__dfxtp_1
XFILLER_0_9_53 VGND VGND VPWR VPWR sky130_fd_sc_hd__decap_3
XFILLER_0_43_121 VGND VGND VPWR VPWR sky130_fd_sc_hd__decap_4
XFILLER_0_16_368 VGND VGND VPWR VPWR sky130_fd_sc_hd__decap_8
X_4666_ clknet_4_3_0_clk _0031_ VGND VGND VPWR VPWR u_interface.u_compute_core.scaled_data\[2\]
+ sky130_fd_sc_hd__dfxtp_1
XFILLER_0_43_165 VGND VGND VPWR VPWR sky130_fd_sc_hd__decap_3
X_3617_ _0430_ _1850_ _0812_ _0810_ VGND VGND VPWR VPWR _0848_ sky130_fd_sc_hd__a31o_1
X_4597_ _1775_ _1785_ VGND VGND VPWR VPWR _1786_ sky130_fd_sc_hd__and2_1
XFILLER_0_3_273 VGND VGND VPWR VPWR sky130_fd_sc_hd__decap_6
X_3548_ _0689_ _1835_ _0731_ _0780_ VGND VGND VPWR VPWR _0781_ sky130_fd_sc_hd__a31o_1
X_3479_ u_interface.core_attn_out\[6\] _0713_ VGND VGND VPWR VPWR _0714_ sky130_fd_sc_hd__or2_1
XFILLER_0_39_405 VPWR VGND VPWR VGND sky130_ef_sc_hd__decap_12
XFILLER_0_39_449 VPWR VGND VPWR VGND sky130_ef_sc_hd__decap_12
XFILLER_0_66_224 VPWR VGND VPWR VGND sky130_ef_sc_hd__decap_12
XFILLER_0_54_419 VGND VGND VPWR VPWR sky130_fd_sc_hd__fill_1
XFILLER_0_81_249 VGND VGND VPWR VPWR sky130_fd_sc_hd__decap_3
XFILLER_0_34_121 VGND VGND VPWR VPWR sky130_fd_sc_hd__decap_8
XFILLER_0_34_165 VGND VGND VPWR VPWR sky130_fd_sc_hd__decap_8
XTAP_TAPCELL_ROW_58_672 VGND VPWR sky130_fd_sc_hd__tapvpwrvgnd_1
X_2850_ _2162_ _2220_ _2243_ _2245_ VGND VGND VPWR VPWR _2246_ sky130_fd_sc_hd__a31o_1
XFILLER_0_57_279 VGND VGND VPWR VPWR sky130_fd_sc_hd__fill_1
XFILLER_0_72_227 VGND VGND VPWR VPWR sky130_fd_sc_hd__decap_4
X_2781_ net10 _2164_ net5 VGND VGND VPWR VPWR _2180_ sky130_fd_sc_hd__and3_1
X_4520_ _1719_ u_interface.core_attn_out\[30\] VGND VGND VPWR VPWR _1731_ sky130_fd_sc_hd__nand2b_1
XFILLER_0_13_305 VGND VGND VPWR VPWR sky130_fd_sc_hd__decap_3
XTAP_TAPCELL_ROW_13_285 VGND VPWR sky130_fd_sc_hd__tapvpwrvgnd_1
X_4451_ _0454_ _1888_ _1663_ VGND VGND VPWR VPWR _1665_ sky130_fd_sc_hd__and3_1
XFILLER_0_13_349 VGND VGND VPWR VPWR sky130_fd_sc_hd__decap_4
X_3402_ _0636_ _0637_ VGND VGND VPWR VPWR _0638_ sky130_fd_sc_hd__nor2_1
X_4382_ _1594_ _1597_ VGND VGND VPWR VPWR _1598_ sky130_fd_sc_hd__xnor2_1
XFILLER_0_21_371 VGND VGND VPWR VPWR sky130_fd_sc_hd__fill_2
XFILLER_0_0_265 VGND VGND VPWR VPWR sky130_fd_sc_hd__decap_4
X_3333_ _0505_ _0532_ _0531_ VGND VGND VPWR VPWR _0571_ sky130_fd_sc_hd__a21boi_2
XFILLER_0_21_393 VPWR VGND VPWR VGND sky130_ef_sc_hd__decap_12
XPHY_EDGE_ROW_7_Right_7 VGND VGND VPWR VPWR sky130_fd_sc_hd__decap_3
X_3264_ net143 _0435_ VGND VGND VPWR VPWR _0504_ sky130_fd_sc_hd__or2_1
X_3195_ _1968_ net20 _0434_ _0440_ VGND VGND VPWR VPWR _0112_ sky130_fd_sc_hd__o211a_1
XFILLER_0_72_73 VGND VGND VPWR VPWR sky130_fd_sc_hd__fill_1
XFILLER_0_8_321 VPWR VGND VPWR VGND sky130_ef_sc_hd__decap_12
XFILLER_0_48_246 VGND VGND VPWR VPWR sky130_fd_sc_hd__decap_6
X_2979_ _2168_ _2294_ VGND VGND VPWR VPWR _0237_ sky130_fd_sc_hd__nand2_4
X_4718_ clknet_4_5_0_clk _0083_ VGND VGND VPWR VPWR u_interface.u_compute_core.mac_accum\[24\]
+ sky130_fd_sc_hd__dfxtp_1
XFILLER_0_71_293 VGND VGND VPWR VPWR sky130_fd_sc_hd__fill_1
X_4649_ clknet_4_6_0_clk _0014_ VGND VGND VPWR VPWR u_interface.u_compute_core.relu_data\[14\]
+ sky130_fd_sc_hd__dfxtp_1
XFILLER_0_12_371 VGND VGND VPWR VPWR sky130_fd_sc_hd__fill_1
XFILLER_0_12_360 VGND VGND VPWR VPWR sky130_fd_sc_hd__decap_4
XTAP_TAPCELL_ROW_55_642 VGND VPWR sky130_fd_sc_hd__tapvpwrvgnd_1
XFILLER_0_79_393 VGND VGND VPWR VPWR sky130_fd_sc_hd__decap_8
XFILLER_0_39_279 VGND VGND VPWR VPWR sky130_fd_sc_hd__fill_1
XFILLER_0_50_477 VGND VGND VPWR VPWR sky130_fd_sc_hd__decap_6
XFILLER_0_26_66 VPWR VGND VPWR VGND sky130_ef_sc_hd__decap_12
XTAP_TAPCELL_ROW_18_333 VGND VPWR sky130_fd_sc_hd__tapvpwrvgnd_1
X_3951_ _1173_ _1175_ VGND VGND VPWR VPWR _1176_ sky130_fd_sc_hd__nand2_1
X_2902_ net4 net17 _2224_ VGND VGND VPWR VPWR _2297_ sky130_fd_sc_hd__and3_1
XFILLER_0_42_76 VGND VGND VPWR VPWR sky130_fd_sc_hd__decap_8
X_3882_ _0460_ _0423_ _1874_ _1871_ VGND VGND VPWR VPWR _1108_ sky130_fd_sc_hd__and4_1
X_2833_ _2194_ _2229_ VGND VGND VPWR VPWR _2230_ sky130_fd_sc_hd__or2_1
XFILLER_0_5_324 VGND VGND VPWR VPWR sky130_fd_sc_hd__fill_1
X_2764_ _2162_ _2163_ _2164_ _2161_ VGND VGND VPWR VPWR _2165_ sky130_fd_sc_hd__a22o_1
XFILLER_0_60_219 VGND VGND VPWR VPWR sky130_fd_sc_hd__fill_1
X_4503_ _1706_ _1715_ VGND VGND VPWR VPWR _1716_ sky130_fd_sc_hd__xnor2_1
XFILLER_0_53_293 VGND VGND VPWR VPWR sky130_fd_sc_hd__decap_6
XFILLER_0_13_146 VPWR VGND VPWR VGND sky130_ef_sc_hd__decap_12
X_2695_ _2105_ _2106_ VGND VGND VPWR VPWR _2107_ sky130_fd_sc_hd__and2b_1
X_4434_ _1599_ _1603_ _1647_ VGND VGND VPWR VPWR _1649_ sky130_fd_sc_hd__and3_1
X_4365_ _1579_ _1580_ VGND VGND VPWR VPWR _1581_ sky130_fd_sc_hd__nor2_1
X_3316_ _0483_ _1829_ _0552_ _0553_ VGND VGND VPWR VPWR _0554_ sky130_fd_sc_hd__nand4_1
X_4296_ _1459_ _1465_ VGND VGND VPWR VPWR _1514_ sky130_fd_sc_hd__and2_1
X_3247_ _0483_ _1824_ _0485_ _0486_ VGND VGND VPWR VPWR _0487_ sky130_fd_sc_hd__nand4_2
Xrebuffer21 _1719_ VGND VGND VPWR VPWR net85 sky130_fd_sc_hd__dlymetal6s2s_1
Xrebuffer10 net73 VGND VGND VPWR VPWR net74 sky130_fd_sc_hd__dlygate4sd1_1
X_3178_ u_interface.u_compute_core.u_av.v_extended\[1\] VGND VGND VPWR VPWR _0426_
+ sky130_fd_sc_hd__buf_2
XFILLER_0_36_216 VGND VGND VPWR VPWR sky130_fd_sc_hd__decap_6
XFILLER_0_36_249 VGND VGND VPWR VPWR sky130_fd_sc_hd__decap_3
XFILLER_0_8_195 VGND VGND VPWR VPWR sky130_fd_sc_hd__fill_1
XFILLER_0_44_282 VPWR VGND VPWR VGND sky130_ef_sc_hd__decap_12
XFILLER_0_32_477 VGND VGND VPWR VPWR sky130_fd_sc_hd__decap_3
XTAP_TAPCELL_ROW_15_303 VGND VPWR sky130_fd_sc_hd__tapvpwrvgnd_1
XFILLER_0_12_46 VGND VGND VPWR VPWR sky130_fd_sc_hd__fill_2
XFILLER_0_23_400 VGND VGND VPWR VPWR sky130_fd_sc_hd__decap_8
XFILLER_0_10_116 VGND VGND VPWR VPWR sky130_fd_sc_hd__fill_1
X_2480_ _1812_ VGND VGND VPWR VPWR _1931_ sky130_fd_sc_hd__clkbuf_2
X_4150_ u_interface.core_attn_out\[20\] _1966_ VGND VGND VPWR VPWR _1371_ sky130_fd_sc_hd__or2_1
X_3101_ _0316_ _0355_ VGND VGND VPWR VPWR _0356_ sky130_fd_sc_hd__and2_1
X_4081_ _1294_ _1302_ VGND VGND VPWR VPWR _1303_ sky130_fd_sc_hd__xor2_1
X_3032_ _0287_ _0288_ VGND VGND VPWR VPWR _0289_ sky130_fd_sc_hd__nand2_1
XTAP_TAPCELL_ROW_66_737 VGND VPWR sky130_fd_sc_hd__tapvpwrvgnd_1
XFILLER_0_77_105 VGND VGND VPWR VPWR sky130_fd_sc_hd__decap_6
XFILLER_0_77_149 VPWR VGND VPWR VGND sky130_ef_sc_hd__decap_12
X_3934_ _1157_ _1158_ VGND VGND VPWR VPWR _1159_ sky130_fd_sc_hd__xor2_1
X_3865_ _1089_ _1090_ VGND VGND VPWR VPWR _1091_ sky130_fd_sc_hd__xnor2_1
XFILLER_0_73_355 VGND VGND VPWR VPWR sky130_fd_sc_hd__fill_1
X_2816_ net10 net7 VGND VGND VPWR VPWR _2213_ sky130_fd_sc_hd__nand2_1
X_3796_ _0929_ _1019_ _1021_ _1023_ VGND VGND VPWR VPWR _1024_ sky130_fd_sc_hd__a211oi_1
XFILLER_0_14_466 VGND VGND VPWR VPWR sky130_fd_sc_hd__decap_8
XFILLER_0_14_433 VGND VGND VPWR VPWR sky130_fd_sc_hd__decap_4
X_2747_ _2068_ u_interface.u_compute_core.mac_accum\[30\] VGND VGND VPWR VPWR _2151_
+ sky130_fd_sc_hd__nand2_1
XFILLER_0_75_3 VPWR VGND VPWR VGND sky130_ef_sc_hd__decap_12
XFILLER_0_14_477 VGND VGND VPWR VPWR sky130_fd_sc_hd__decap_6
X_2678_ _2003_ _2091_ _2092_ VGND VGND VPWR VPWR _2093_ sky130_fd_sc_hd__or3_1
XFILLER_0_78_83 VGND VGND VPWR VPWR sky130_fd_sc_hd__fill_1
X_4417_ _1630_ _1631_ VGND VGND VPWR VPWR _1632_ sky130_fd_sc_hd__xor2_1
XFILLER_0_1_393 VPWR VGND VPWR VGND sky130_ef_sc_hd__decap_12
X_4348_ _1512_ _1516_ VGND VGND VPWR VPWR _1565_ sky130_fd_sc_hd__nand2_1
X_4279_ _0428_ _1893_ _1495_ VGND VGND VPWR VPWR _1497_ sky130_fd_sc_hd__a21oi_1
XFILLER_0_68_116 VGND VGND VPWR VPWR sky130_fd_sc_hd__decap_3
XFILLER_0_68_149 VGND VGND VPWR VPWR sky130_fd_sc_hd__fill_2
XTAP_TAPCELL_ROW_37_494 VGND VPWR sky130_fd_sc_hd__tapvpwrvgnd_1
XFILLER_0_49_363 VGND VGND VPWR VPWR sky130_fd_sc_hd__decap_8
XFILLER_0_64_377 VPWR VGND VPWR VGND sky130_ef_sc_hd__decap_12
XTAP_TAPCELL_ROW_20_350 VGND VPWR sky130_fd_sc_hd__tapvpwrvgnd_1
XFILLER_0_55_300 VGND VGND VPWR VPWR sky130_fd_sc_hd__decap_6
XFILLER_0_55_344 VPWR VGND VPWR VGND sky130_ef_sc_hd__decap_12
XFILLER_0_70_336 VGND VGND VPWR VPWR sky130_fd_sc_hd__decap_3
X_3650_ _0830_ _0832_ VGND VGND VPWR VPWR _0881_ sky130_fd_sc_hd__or2_1
XFILLER_0_70_358 VGND VGND VPWR VPWR sky130_fd_sc_hd__fill_1
Xrebuffer1 _0621_ VGND VGND VPWR VPWR net65 sky130_fd_sc_hd__dlygate4sd1_1
X_3581_ _0809_ _0812_ VGND VGND VPWR VPWR _0813_ sky130_fd_sc_hd__xnor2_2
X_2601_ _1979_ VGND VGND VPWR VPWR _2026_ sky130_fd_sc_hd__clkbuf_4
X_2532_ _1966_ VGND VGND VPWR VPWR _1967_ sky130_fd_sc_hd__inv_2
XFILLER_0_11_447 VGND VGND VPWR VPWR sky130_fd_sc_hd__fill_1
X_2463_ _1919_ VGND VGND VPWR VPWR _0036_ sky130_fd_sc_hd__clkbuf_1
X_4202_ _1420_ _1421_ VGND VGND VPWR VPWR _1422_ sky130_fd_sc_hd__xnor2_1
XFILLER_0_48_53 VGND VGND VPWR VPWR sky130_fd_sc_hd__fill_1
X_2394_ _1848_ _1870_ VGND VGND VPWR VPWR _0016_ sky130_fd_sc_hd__nor2_1
XTAP_TAPCELL_ROW_79_851 VGND VPWR sky130_fd_sc_hd__tapvpwrvgnd_1
X_4133_ _1351_ _1353_ VGND VGND VPWR VPWR _1354_ sky130_fd_sc_hd__xor2_1
XFILLER_0_3_55 VGND VGND VPWR VPWR sky130_fd_sc_hd__fill_1
X_4064_ _0446_ u_interface.u_compute_core.relu_data\[17\] _1868_ _0450_ VGND VGND
+ VPWR VPWR _1286_ sky130_fd_sc_hd__a22oi_1
X_3015_ _2202_ _2256_ _2294_ _2178_ VGND VGND VPWR VPWR _0272_ sky130_fd_sc_hd__a22o_1
XFILLER_0_64_41 VGND VGND VPWR VPWR sky130_fd_sc_hd__decap_4
XFILLER_0_64_85 VGND VGND VPWR VPWR sky130_fd_sc_hd__fill_2
XFILLER_0_78_469 VGND VGND VPWR VPWR sky130_fd_sc_hd__decap_6
XTAP_TAPCELL_ROW_34_464 VGND VPWR sky130_fd_sc_hd__tapvpwrvgnd_1
XFILLER_0_58_171 VGND VGND VPWR VPWR sky130_fd_sc_hd__fill_1
XFILLER_0_58_193 VGND VGND VPWR VPWR sky130_fd_sc_hd__decap_3
XFILLER_0_46_377 VPWR VGND VPWR VGND sky130_ef_sc_hd__decap_12
X_3917_ _0626_ _1871_ VGND VGND VPWR VPWR _1142_ sky130_fd_sc_hd__nand2_1
X_3848_ _1034_ _1035_ _1074_ VGND VGND VPWR VPWR _1075_ sky130_fd_sc_hd__a21o_1
XFILLER_0_14_230 VPWR VGND VPWR VGND sky130_ef_sc_hd__decap_12
X_3779_ _0961_ _0963_ VGND VGND VPWR VPWR _1007_ sky130_fd_sc_hd__and2_1
XFILLER_0_69_447 VGND VGND VPWR VPWR sky130_fd_sc_hd__fill_1
XFILLER_0_37_344 VGND VGND VPWR VPWR sky130_fd_sc_hd__decap_6
XFILLER_0_20_266 VPWR VGND VPWR VGND sky130_ef_sc_hd__decap_12
XTAP_TAPCELL_ROW_76_821 VGND VPWR sky130_fd_sc_hd__tapvpwrvgnd_1
XFILLER_0_75_428 VGND VGND VPWR VPWR sky130_fd_sc_hd__decap_8
XFILLER_0_7_205 VPWR VGND VPWR VGND sky130_ef_sc_hd__decap_12
XFILLER_0_28_333 VGND VGND VPWR VPWR sky130_fd_sc_hd__fill_1
X_4751_ clknet_4_2_0_clk _0116_ VGND VGND VPWR VPWR u_interface.u_compute_core.u_av.v_extended\[10\]
+ sky130_fd_sc_hd__dfxtp_2
X_3702_ u_interface.core_attn_out\[11\] _0931_ VGND VGND VPWR VPWR _0932_ sky130_fd_sc_hd__nor2_1
XFILLER_0_43_314 VPWR VGND VPWR VGND sky130_ef_sc_hd__decap_12
X_4682_ clknet_4_7_0_clk _0047_ VGND VGND VPWR VPWR u_interface.u_compute_core.scaled_data\[18\]
+ sky130_fd_sc_hd__dfxtp_1
XFILLER_0_70_111 VGND VGND VPWR VPWR sky130_fd_sc_hd__fill_1
X_3633_ _0437_ u_interface.u_compute_core.relu_data\[9\] _0815_ VGND VGND VPWR VPWR
+ _0864_ sky130_fd_sc_hd__and3_1
XFILLER_0_55_196 VPWR VGND VPWR VGND sky130_ef_sc_hd__decap_12
XFILLER_0_11_211 VGND VGND VPWR VPWR sky130_fd_sc_hd__fill_1
X_3564_ _0759_ _0796_ VGND VGND VPWR VPWR _0797_ sky130_fd_sc_hd__and2b_1
XFILLER_0_51_380 VGND VGND VPWR VPWR sky130_fd_sc_hd__decap_4
X_2515_ _1955_ VGND VGND VPWR VPWR _0052_ sky130_fd_sc_hd__clkbuf_1
X_3495_ u_interface.u_compute_core.relu_data\[3\] u_interface.u_compute_core.u_av.v_extended\[10\]
+ VGND VGND VPWR VPWR _0729_ sky130_fd_sc_hd__nor2b_1
X_2446_ _1813_ _1907_ VGND VGND VPWR VPWR _1908_ sky130_fd_sc_hd__and2_1
XFILLER_0_75_51 VGND VGND VPWR VPWR sky130_fd_sc_hd__decap_4
XFILLER_0_38_3 VPWR VGND VPWR VGND sky130_ef_sc_hd__decap_12
X_2377_ u_interface.u_compute_core.scaled_data\[12\] _1849_ _1857_ _1843_ VGND VGND
+ VPWR VPWR _1858_ sky130_fd_sc_hd__o2bb2a_1
X_4116_ _0431_ _1246_ VGND VGND VPWR VPWR _1337_ sky130_fd_sc_hd__nand2_1
X_4047_ _1168_ _1222_ _1221_ VGND VGND VPWR VPWR _1270_ sky130_fd_sc_hd__a21o_1
XFILLER_0_46_141 VGND VGND VPWR VPWR sky130_fd_sc_hd__decap_6
XFILLER_0_74_483 VGND VGND VPWR VPWR sky130_fd_sc_hd__fill_1
XFILLER_0_34_347 VGND VGND VPWR VPWR sky130_fd_sc_hd__decap_3
XFILLER_0_61_133 VGND VGND VPWR VPWR sky130_fd_sc_hd__decap_8
XFILLER_0_6_282 VPWR VGND VPWR VGND sky130_ef_sc_hd__decap_12
XFILLER_0_61_166 VGND VGND VPWR VPWR sky130_fd_sc_hd__fill_2
XTAP_TAPCELL_ROW_2_192 VGND VPWR sky130_fd_sc_hd__tapvpwrvgnd_1
XTAP_TAPCELL_ROW_45_559 VGND VPWR sky130_fd_sc_hd__tapvpwrvgnd_1
XFILLER_0_57_428 VGND VGND VPWR VPWR sky130_fd_sc_hd__decap_4
XFILLER_0_25_314 VGND VGND VPWR VPWR sky130_fd_sc_hd__decap_6
XFILLER_0_80_453 VGND VGND VPWR VPWR sky130_fd_sc_hd__fill_1
XFILLER_0_52_133 VGND VGND VPWR VPWR sky130_fd_sc_hd__decap_6
XFILLER_0_33_391 VGND VGND VPWR VPWR sky130_fd_sc_hd__fill_1
X_3280_ _0514_ _0517_ _0518_ VGND VGND VPWR VPWR _0519_ sky130_fd_sc_hd__nand3_1
XFILLER_0_29_33 VPWR VGND VPWR VGND sky130_ef_sc_hd__decap_12
XFILLER_0_75_225 VGND VGND VPWR VPWR sky130_fd_sc_hd__decap_6
XFILLER_0_48_439 VPWR VGND VPWR VGND sky130_ef_sc_hd__decap_12
XFILLER_0_28_141 VPWR VGND VPWR VGND sky130_ef_sc_hd__decap_12
X_4803_ clknet_4_14_0_clk _0168_ VGND VGND VPWR VPWR net38 sky130_fd_sc_hd__dfxtp_1
XFILLER_0_56_450 VGND VGND VPWR VPWR sky130_fd_sc_hd__fill_1
X_2995_ _0251_ _0252_ VGND VGND VPWR VPWR _0253_ sky130_fd_sc_hd__nand2_1
X_4734_ clknet_4_1_0_clk _0099_ VGND VGND VPWR VPWR u_interface.u_compute_core.u_mac.product_reg\[8\]
+ sky130_fd_sc_hd__dfxtp_1
XFILLER_0_56_483 VGND VGND VPWR VPWR sky130_fd_sc_hd__fill_1
XFILLER_0_71_453 VGND VGND VPWR VPWR sky130_fd_sc_hd__fill_1
XFILLER_0_71_442 VGND VGND VPWR VPWR sky130_fd_sc_hd__decap_6
XFILLER_0_28_185 VGND VGND VPWR VPWR sky130_fd_sc_hd__decap_3
XFILLER_0_71_475 VGND VGND VPWR VPWR sky130_fd_sc_hd__decap_4
X_4665_ clknet_4_3_0_clk _0030_ VGND VGND VPWR VPWR u_interface.u_compute_core.scaled_data\[1\]
+ sky130_fd_sc_hd__dfxtp_1
X_3616_ _0766_ _0807_ _0846_ VGND VGND VPWR VPWR _0847_ sky130_fd_sc_hd__a21o_1
XFILLER_0_43_199 VGND VGND VPWR VPWR sky130_fd_sc_hd__fill_2
X_4596_ net39 u_interface.core_attn_out\[19\] _1782_ VGND VGND VPWR VPWR _1785_ sky130_fd_sc_hd__mux2_1
X_3547_ _0468_ _1838_ _0729_ VGND VGND VPWR VPWR _0780_ sky130_fd_sc_hd__and3_1
X_3478_ u_interface.u_compute_core.relu_valid VGND VGND VPWR VPWR _0713_ sky130_fd_sc_hd__buf_2
X_2429_ u_interface.u_compute_core.relu_data\[26\] VGND VGND VPWR VPWR _1896_ sky130_fd_sc_hd__inv_2
XFILLER_0_39_417 VGND VGND VPWR VPWR sky130_fd_sc_hd__decap_4
XFILLER_0_39_439 VGND VGND VPWR VPWR sky130_fd_sc_hd__decap_8
XFILLER_0_66_236 VPWR VGND VPWR VGND sky130_ef_sc_hd__decap_12
XTAP_TAPCELL_ROW_42_529 VGND VPWR sky130_fd_sc_hd__tapvpwrvgnd_1
XFILLER_0_74_291 VGND VGND VPWR VPWR sky130_fd_sc_hd__fill_1
XFILLER_0_19_196 VGND VGND VPWR VPWR sky130_fd_sc_hd__fill_1
XFILLER_0_22_328 VPWR VGND VPWR VGND sky130_ef_sc_hd__decap_12
XFILLER_0_30_361 VGND VGND VPWR VPWR sky130_fd_sc_hd__decap_3
XTAP_TAPCELL_ROW_58_673 VGND VPWR sky130_fd_sc_hd__tapvpwrvgnd_1
XFILLER_0_15_57 VPWR VGND VPWR VGND sky130_ef_sc_hd__decap_12
XFILLER_0_57_225 VGND VGND VPWR VPWR sky130_fd_sc_hd__decap_8
XFILLER_0_57_247 VGND VGND VPWR VPWR sky130_fd_sc_hd__decap_6
XFILLER_0_38_483 VGND VGND VPWR VPWR sky130_fd_sc_hd__fill_1
X_2780_ _2164_ _2168_ _2178_ _2162_ VGND VGND VPWR VPWR _2179_ sky130_fd_sc_hd__a22o_1
XFILLER_0_53_442 VGND VGND VPWR VPWR sky130_fd_sc_hd__fill_1
XTAP_TAPCELL_ROW_13_286 VGND VPWR sky130_fd_sc_hd__tapvpwrvgnd_1
XFILLER_0_25_144 VGND VGND VPWR VPWR sky130_fd_sc_hd__decap_6
XFILLER_0_25_166 VGND VGND VPWR VPWR sky130_fd_sc_hd__fill_2
X_4450_ _0454_ _1888_ _1663_ VGND VGND VPWR VPWR _1664_ sky130_fd_sc_hd__a21oi_1
X_4381_ _1595_ _1596_ VGND VGND VPWR VPWR _1597_ sky130_fd_sc_hd__xor2_1
X_3401_ _0430_ _1835_ _0633_ _0635_ VGND VGND VPWR VPWR _0637_ sky130_fd_sc_hd__o2bb2a_1
XFILLER_0_40_158 VGND VGND VPWR VPWR sky130_fd_sc_hd__fill_1
X_3332_ _0568_ _0569_ VGND VGND VPWR VPWR _0570_ sky130_fd_sc_hd__xor2_1
X_3263_ _0478_ _0502_ VGND VGND VPWR VPWR _0503_ sky130_fd_sc_hd__xor2_1
XPHY_EDGE_ROW_37_Left_119 VGND VGND VPWR VPWR sky130_fd_sc_hd__decap_3
X_3194_ _0435_ _0439_ VGND VGND VPWR VPWR _0440_ sky130_fd_sc_hd__or2_1
XFILLER_0_72_41 VPWR VGND VPWR VGND sky130_ef_sc_hd__decap_12
XFILLER_0_36_409 VGND VGND VPWR VPWR sky130_fd_sc_hd__decap_8
XPHY_EDGE_ROW_46_Left_128 VGND VGND VPWR VPWR sky130_fd_sc_hd__decap_3
XFILLER_0_8_333 VPWR VGND VPWR VGND sky130_ef_sc_hd__decap_12
X_2978_ _0234_ _0235_ VGND VGND VPWR VPWR _0236_ sky130_fd_sc_hd__nor2_1
XFILLER_0_71_250 VGND VGND VPWR VPWR sky130_fd_sc_hd__fill_1
XFILLER_0_44_475 VGND VGND VPWR VPWR sky130_fd_sc_hd__fill_1
X_4717_ clknet_4_5_0_clk _0082_ VGND VGND VPWR VPWR u_interface.u_compute_core.mac_accum\[23\]
+ sky130_fd_sc_hd__dfxtp_1
X_4648_ clknet_4_6_0_clk _0013_ VGND VGND VPWR VPWR u_interface.u_compute_core.relu_data\[13\]
+ sky130_fd_sc_hd__dfxtp_2
XFILLER_0_31_169 VGND VGND VPWR VPWR sky130_fd_sc_hd__decap_6
X_4579_ net34 u_interface.core_attn_out\[14\] _1760_ VGND VGND VPWR VPWR _1773_ sky130_fd_sc_hd__mux2_1
XPHY_EDGE_ROW_55_Left_137 VGND VGND VPWR VPWR sky130_fd_sc_hd__decap_3
XTAP_TAPCELL_ROW_4_210 VGND VPWR sky130_fd_sc_hd__tapvpwrvgnd_1
XTAP_TAPCELL_ROW_55_643 VGND VPWR sky130_fd_sc_hd__tapvpwrvgnd_1
XFILLER_0_39_225 VGND VGND VPWR VPWR sky130_fd_sc_hd__decap_4
XPHY_EDGE_ROW_64_Left_146 VGND VGND VPWR VPWR sky130_fd_sc_hd__decap_3
XFILLER_0_39_236 VGND VGND VPWR VPWR sky130_fd_sc_hd__decap_4
XFILLER_0_54_206 VPWR VGND VPWR VGND sky130_ef_sc_hd__decap_12
XFILLER_0_22_114 VPWR VGND VPWR VGND sky130_ef_sc_hd__decap_12
XPHY_EDGE_ROW_73_Left_155 VGND VGND VPWR VPWR sky130_fd_sc_hd__decap_3
Xhold90 u_interface.u_compute_core.scaled_data\[26\] VGND VGND VPWR VPWR net154 sky130_fd_sc_hd__dlygate4sd3_1
XFILLER_0_26_78 VGND VGND VPWR VPWR sky130_fd_sc_hd__decap_6
X_3950_ _0940_ _0941_ _0980_ _1174_ VGND VGND VPWR VPWR _1175_ sky130_fd_sc_hd__or4b_4
X_2901_ _2295_ VGND VGND VPWR VPWR _2296_ sky130_fd_sc_hd__inv_2
XFILLER_0_42_22 VGND VGND VPWR VPWR sky130_fd_sc_hd__decap_6
X_3881_ _0423_ _1874_ _1871_ _0427_ VGND VGND VPWR VPWR _1107_ sky130_fd_sc_hd__a22oi_1
X_2832_ _2223_ _2228_ VGND VGND VPWR VPWR _2229_ sky130_fd_sc_hd__xnor2_1
XFILLER_0_45_239 VPWR VGND VPWR VGND sky130_ef_sc_hd__decap_12
X_2763_ net11 VGND VGND VPWR VPWR _2164_ sky130_fd_sc_hd__buf_2
X_4502_ _1673_ _1714_ VGND VGND VPWR VPWR _1715_ sky130_fd_sc_hd__xnor2_1
XFILLER_0_13_158 VGND VGND VPWR VPWR sky130_fd_sc_hd__decap_8
XFILLER_0_13_136 VGND VGND VPWR VPWR sky130_fd_sc_hd__fill_1
X_2694_ _2064_ u_interface.u_compute_core.mac_accum\[22\] VGND VGND VPWR VPWR _2106_
+ sky130_fd_sc_hd__nand2_1
X_4433_ _1599_ _1603_ _1647_ VGND VGND VPWR VPWR _1648_ sky130_fd_sc_hd__a21oi_1
XFILLER_0_13_169 VPWR VGND VPWR VGND sky130_ef_sc_hd__decap_12
X_4364_ _0439_ _1893_ _1882_ _0454_ VGND VGND VPWR VPWR _1580_ sky130_fd_sc_hd__a22oi_1
X_3315_ u_interface.u_compute_core.u_av.v_extended\[5\] _1821_ _1818_ u_interface.u_compute_core.u_av.v_extended\[6\]
+ VGND VGND VPWR VPWR _0553_ sky130_fd_sc_hd__a22o_1
X_4295_ _1511_ _1512_ VGND VGND VPWR VPWR _1513_ sky130_fd_sc_hd__nand2_1
X_3246_ _0441_ _0437_ _1821_ _1818_ VGND VGND VPWR VPWR _0486_ sky130_fd_sc_hd__nand4_4
Xrebuffer11 _1685_ VGND VGND VPWR VPWR net75 sky130_fd_sc_hd__dlymetal6s2s_1
XFILLER_0_20_3 VGND VGND VPWR VPWR sky130_fd_sc_hd__decap_6
X_3177_ _1968_ net3 _0420_ _0425_ VGND VGND VPWR VPWR _0109_ sky130_fd_sc_hd__o211a_1
Xrebuffer22 _1719_ VGND VGND VPWR VPWR net86 sky130_fd_sc_hd__dlygate4sd1_1
XFILLER_0_76_386 VPWR VGND VPWR VGND sky130_ef_sc_hd__decap_12
XFILLER_0_8_141 VPWR VGND VPWR VGND sky130_ef_sc_hd__decap_12
XFILLER_0_17_442 VGND VGND VPWR VPWR sky130_fd_sc_hd__fill_1
XTAP_TAPCELL_ROW_60_690 VGND VPWR sky130_fd_sc_hd__tapvpwrvgnd_1
XFILLER_0_44_294 VGND VGND VPWR VPWR sky130_fd_sc_hd__fill_1
XTAP_TAPCELL_ROW_15_304 VGND VPWR sky130_fd_sc_hd__tapvpwrvgnd_1
XFILLER_0_67_364 VGND VGND VPWR VPWR sky130_fd_sc_hd__fill_1
XTAP_TAPCELL_ROW_23_370 VGND VPWR sky130_fd_sc_hd__tapvpwrvgnd_1
XFILLER_0_50_231 VPWR VGND VPWR VGND sky130_ef_sc_hd__decap_12
X_3100_ _0353_ _0354_ VGND VGND VPWR VPWR _0355_ sky130_fd_sc_hd__nor2_1
XFILLER_0_37_11 VGND VGND VPWR VPWR sky130_fd_sc_hd__fill_2
X_4080_ _1248_ _1301_ VGND VGND VPWR VPWR _1302_ sky130_fd_sc_hd__xnor2_1
X_3031_ _0243_ _0249_ _0286_ VGND VGND VPWR VPWR _0288_ sky130_fd_sc_hd__nand3_1
XTAP_TAPCELL_ROW_66_738 VGND VPWR sky130_fd_sc_hd__tapvpwrvgnd_1
X_3933_ _1104_ _1111_ _1103_ VGND VGND VPWR VPWR _1158_ sky130_fd_sc_hd__a21oi_1
X_3864_ _0639_ _1862_ VGND VGND VPWR VPWR _1090_ sky130_fd_sc_hd__nand2_1
XFILLER_0_73_378 VGND VGND VPWR VPWR sky130_fd_sc_hd__fill_1
X_2815_ _2198_ _2199_ _2206_ VGND VGND VPWR VPWR _2212_ sky130_fd_sc_hd__and3_1
XFILLER_0_26_261 VGND VGND VPWR VPWR sky130_fd_sc_hd__decap_3
XFILLER_0_26_272 VGND VGND VPWR VPWR sky130_fd_sc_hd__fill_2
X_3795_ _0833_ _0878_ _0927_ _0974_ VGND VGND VPWR VPWR _1023_ sky130_fd_sc_hd__and4_1
XFILLER_0_41_220 VGND VGND VPWR VPWR sky130_fd_sc_hd__fill_1
X_2746_ _2149_ _2150_ net113 _2006_ VGND VGND VPWR VPWR _0088_ sky130_fd_sc_hd__a2bb2o_1
X_2677_ _2086_ _2088_ _2090_ VGND VGND VPWR VPWR _2092_ sky130_fd_sc_hd__and3_1
X_4416_ _0432_ u_interface.u_compute_core.relu_data\[27\] VGND VGND VPWR VPWR _1631_
+ sky130_fd_sc_hd__nand2_1
XFILLER_0_1_361 VPWR VGND VPWR VGND sky130_ef_sc_hd__decap_12
XFILLER_0_68_3 VPWR VGND VPWR VGND sky130_ef_sc_hd__decap_12
X_4347_ _1562_ _1563_ VGND VGND VPWR VPWR _1564_ sky130_fd_sc_hd__or2b_1
X_4278_ _0428_ _1893_ _1495_ VGND VGND VPWR VPWR _1496_ sky130_fd_sc_hd__and3_1
X_3229_ _0467_ _0469_ VGND VGND VPWR VPWR _0470_ sky130_fd_sc_hd__or2_1
XFILLER_0_9_461 VGND VGND VPWR VPWR sky130_fd_sc_hd__fill_1
XFILLER_0_17_261 VGND VGND VPWR VPWR sky130_fd_sc_hd__fill_2
XFILLER_0_64_389 VGND VGND VPWR VPWR sky130_fd_sc_hd__decap_4
XFILLER_0_32_253 VPWR VGND VPWR VGND sky130_ef_sc_hd__decap_12
XFILLER_0_32_286 VGND VGND VPWR VPWR sky130_fd_sc_hd__fill_2
XFILLER_0_59_117 VGND VGND VPWR VPWR sky130_fd_sc_hd__fill_1
XTAP_TAPCELL_ROW_63_708 VGND VPWR sky130_fd_sc_hd__tapvpwrvgnd_1
XFILLER_0_59_139 VGND VGND VPWR VPWR sky130_fd_sc_hd__fill_2
XFILLER_0_67_161 VGND VGND VPWR VPWR sky130_fd_sc_hd__decap_6
XFILLER_0_23_57 VGND VGND VPWR VPWR sky130_fd_sc_hd__fill_1
XFILLER_0_23_68 VPWR VGND VPWR VGND sky130_ef_sc_hd__decap_12
XFILLER_0_55_356 VPWR VGND VPWR VGND sky130_ef_sc_hd__decap_12
XFILLER_0_55_378 VGND VGND VPWR VPWR sky130_fd_sc_hd__fill_1
XFILLER_0_23_231 VGND VGND VPWR VPWR sky130_fd_sc_hd__fill_1
X_3580_ _0810_ _0811_ VGND VGND VPWR VPWR _0812_ sky130_fd_sc_hd__nor2_1
X_2600_ _2020_ _2024_ _2025_ _1980_ net112 VGND VGND VPWR VPWR _0067_ sky130_fd_sc_hd__a32o_1
Xrebuffer2 _1375_ VGND VGND VPWR VPWR net66 sky130_fd_sc_hd__dlygate4sd1_1
X_2531_ u_interface.u_compute_core.relu_valid VGND VGND VPWR VPWR _1966_ sky130_fd_sc_hd__buf_2
X_2462_ _1909_ _1918_ VGND VGND VPWR VPWR _1919_ sky130_fd_sc_hd__and2_1
X_4201_ u_interface.core_attn_out\[20\] _1362_ _1363_ _1369_ VGND VGND VPWR VPWR _1421_
+ sky130_fd_sc_hd__a22oi_1
X_2393_ u_interface.u_compute_core.scaled_data\[16\] _1849_ _1869_ _1843_ VGND VGND
+ VPWR VPWR _1870_ sky130_fd_sc_hd__o2bb2a_1
X_4132_ _1294_ _1302_ _1352_ VGND VGND VPWR VPWR _1353_ sky130_fd_sc_hd__o21a_1
X_4063_ _1282_ _1284_ VGND VGND VPWR VPWR _1285_ sky130_fd_sc_hd__xor2_1
X_3014_ _2178_ _2202_ net18 VGND VGND VPWR VPWR _0271_ sky130_fd_sc_hd__and3_1
XFILLER_0_80_41 VPWR VGND VPWR VGND sky130_ef_sc_hd__decap_12
XTAP_TAPCELL_ROW_34_465 VGND VPWR sky130_fd_sc_hd__tapvpwrvgnd_1
X_3916_ _1139_ _1140_ VGND VGND VPWR VPWR _1141_ sky130_fd_sc_hd__nor2_1
XFILLER_0_80_85 VPWR VGND VPWR VGND sky130_ef_sc_hd__decap_12
XFILLER_0_73_175 VGND VGND VPWR VPWR sky130_fd_sc_hd__decap_4
XFILLER_0_73_164 VGND VGND VPWR VPWR sky130_fd_sc_hd__fill_1
X_3847_ u_interface.core_attn_out\[14\] _1073_ VGND VGND VPWR VPWR _1074_ sky130_fd_sc_hd__xnor2_2
XFILLER_0_46_389 VPWR VGND VPWR VGND sky130_ef_sc_hd__decap_12
XFILLER_0_61_304 VPWR VGND VPWR VGND sky130_ef_sc_hd__decap_12
XFILLER_0_73_197 VPWR VGND VPWR VGND sky130_ef_sc_hd__decap_12
X_3778_ _0997_ _1005_ VGND VGND VPWR VPWR _1006_ sky130_fd_sc_hd__xnor2_1
X_2729_ _2067_ u_interface.u_compute_core.mac_accum\[27\] VGND VGND VPWR VPWR _2136_
+ sky130_fd_sc_hd__xor2_1
XFILLER_0_14_242 VGND VGND VPWR VPWR sky130_fd_sc_hd__decap_8
XFILLER_0_14_297 VGND VGND VPWR VPWR sky130_fd_sc_hd__fill_1
XFILLER_0_10_470 VGND VGND VPWR VPWR sky130_fd_sc_hd__decap_6
XPHY_EDGE_ROW_29_Right_29 VGND VGND VPWR VPWR sky130_fd_sc_hd__decap_3
XPHY_EDGE_ROW_38_Right_38 VGND VGND VPWR VPWR sky130_fd_sc_hd__decap_3
XFILLER_0_64_197 VPWR VGND VPWR VGND sky130_ef_sc_hd__decap_12
XFILLER_0_20_223 VGND VGND VPWR VPWR sky130_fd_sc_hd__fill_2
XFILLER_0_20_278 VGND VGND VPWR VPWR sky130_fd_sc_hd__decap_3
XFILLER_0_18_35 VGND VGND VPWR VPWR sky130_fd_sc_hd__fill_1
XFILLER_0_18_68 VGND VGND VPWR VPWR sky130_fd_sc_hd__decap_6
XPHY_EDGE_ROW_47_Right_47 VGND VGND VPWR VPWR sky130_fd_sc_hd__decap_3
XTAP_TAPCELL_ROW_76_822 VGND VPWR sky130_fd_sc_hd__tapvpwrvgnd_1
XFILLER_0_7_217 VGND VGND VPWR VPWR sky130_fd_sc_hd__decap_6
X_4750_ clknet_4_2_0_clk _0115_ VGND VGND VPWR VPWR u_interface.u_compute_core.u_av.v_extended\[6\]
+ sky130_fd_sc_hd__dfxtp_2
XPHY_EDGE_ROW_56_Right_56 VGND VGND VPWR VPWR sky130_fd_sc_hd__decap_3
X_3701_ net82 _0930_ VGND VGND VPWR VPWR _0931_ sky130_fd_sc_hd__xor2_2
XFILLER_0_43_304 VGND VGND VPWR VPWR sky130_fd_sc_hd__decap_4
XFILLER_0_43_326 VGND VGND VPWR VPWR sky130_fd_sc_hd__decap_8
XFILLER_0_55_164 VGND VGND VPWR VPWR sky130_fd_sc_hd__decap_4
XFILLER_0_55_175 VGND VGND VPWR VPWR sky130_fd_sc_hd__fill_1
X_4681_ clknet_4_6_0_clk _0046_ VGND VGND VPWR VPWR u_interface.u_compute_core.scaled_data\[17\]
+ sky130_fd_sc_hd__dfxtp_1
X_3632_ _0859_ _0862_ VGND VGND VPWR VPWR _0863_ sky130_fd_sc_hd__xnor2_1
XFILLER_0_50_88 VPWR VGND VPWR VGND sky130_ef_sc_hd__decap_12
XFILLER_0_11_201 VGND VGND VPWR VPWR sky130_fd_sc_hd__decap_3
X_3563_ _0795_ u_interface.core_attn_out\[8\] VGND VGND VPWR VPWR _0796_ sky130_fd_sc_hd__xor2_1
X_2514_ _1953_ _1954_ VGND VGND VPWR VPWR _1955_ sky130_fd_sc_hd__and2_1
X_3494_ _0441_ _1835_ VGND VGND VPWR VPWR _0728_ sky130_fd_sc_hd__nand2_1
X_2445_ u_interface.u_compute_core.scaled_data\[2\] u_interface.u_compute_core.mac_accum\[5\]
+ _1900_ VGND VGND VPWR VPWR _1907_ sky130_fd_sc_hd__mux2_1
XPHY_EDGE_ROW_65_Right_65 VGND VGND VPWR VPWR sky130_fd_sc_hd__decap_3
X_2376_ _1856_ VGND VGND VPWR VPWR _1857_ sky130_fd_sc_hd__inv_2
X_4115_ _1334_ _1335_ VGND VGND VPWR VPWR _1336_ sky130_fd_sc_hd__nor2_1
X_4046_ u_interface.core_attn_out\[18\] _1268_ VGND VGND VPWR VPWR _1269_ sky130_fd_sc_hd__xnor2_1
XPHY_EDGE_ROW_74_Right_74 VGND VGND VPWR VPWR sky130_fd_sc_hd__decap_3
XFILLER_0_19_323 VGND VGND VPWR VPWR sky130_fd_sc_hd__fill_1
XFILLER_0_19_356 VGND VGND VPWR VPWR sky130_fd_sc_hd__decap_8
XFILLER_0_34_315 VGND VGND VPWR VPWR sky130_fd_sc_hd__fill_1
XFILLER_0_6_294 VGND VGND VPWR VPWR sky130_fd_sc_hd__decap_4
XFILLER_0_69_223 VGND VGND VPWR VPWR sky130_fd_sc_hd__fill_1
XTAP_TAPCELL_ROW_2_193 VGND VPWR sky130_fd_sc_hd__tapvpwrvgnd_1
XFILLER_0_69_256 VPWR VGND VPWR VGND sky130_ef_sc_hd__decap_12
XFILLER_0_37_131 VGND VGND VPWR VPWR sky130_fd_sc_hd__fill_2
XFILLER_0_80_421 VGND VGND VPWR VPWR sky130_fd_sc_hd__decap_4
XFILLER_0_4_209 VPWR VGND VPWR VGND sky130_ef_sc_hd__decap_12
XFILLER_0_20_69 VGND VGND VPWR VPWR sky130_fd_sc_hd__fill_1
XFILLER_0_29_45 VGND VGND VPWR VPWR sky130_fd_sc_hd__decap_6
XFILLER_0_45_44 VPWR VGND VPWR VGND sky130_ef_sc_hd__decap_12
XFILLER_0_0_57 VGND VGND VPWR VPWR sky130_fd_sc_hd__fill_2
X_2994_ _0249_ _0250_ _0200_ _0209_ VGND VGND VPWR VPWR _0252_ sky130_fd_sc_hd__a211o_1
X_4802_ clknet_4_14_0_clk _0167_ VGND VGND VPWR VPWR net37 sky130_fd_sc_hd__dfxtp_1
XFILLER_0_16_315 VGND VGND VPWR VPWR sky130_fd_sc_hd__decap_6
XFILLER_0_28_153 VPWR VGND VPWR VGND sky130_ef_sc_hd__decap_12
X_4733_ clknet_4_0_0_clk _0098_ VGND VGND VPWR VPWR u_interface.u_compute_core.u_mac.product_reg\[7\]
+ sky130_fd_sc_hd__dfxtp_1
XFILLER_0_28_197 VGND VGND VPWR VPWR sky130_fd_sc_hd__fill_2
XFILLER_0_9_66 VPWR VGND VPWR VGND sky130_ef_sc_hd__decap_12
X_4664_ clknet_4_3_0_clk _0029_ VGND VGND VPWR VPWR u_interface.u_compute_core.scaled_data\[0\]
+ sky130_fd_sc_hd__dfxtp_1
X_3615_ _0806_ _0803_ VGND VGND VPWR VPWR _0846_ sky130_fd_sc_hd__and2b_1
X_4595_ _1784_ VGND VGND VPWR VPWR _0168_ sky130_fd_sc_hd__clkbuf_1
XFILLER_0_10_91 VGND VGND VPWR VPWR sky130_fd_sc_hd__decap_3
X_3546_ _0775_ _0778_ VGND VGND VPWR VPWR _0779_ sky130_fd_sc_hd__xnor2_2
X_3477_ _0709_ _0711_ VGND VGND VPWR VPWR _0712_ sky130_fd_sc_hd__xor2_1
XFILLER_0_50_3 VPWR VGND VPWR VGND sky130_ef_sc_hd__decap_12
X_2428_ _1879_ _1895_ VGND VGND VPWR VPWR _0025_ sky130_fd_sc_hd__nor2_1
X_2359_ net152 _1815_ _1842_ _1843_ VGND VGND VPWR VPWR _1844_ sky130_fd_sc_hd__o2bb2a_1
X_4029_ _1250_ _1251_ VGND VGND VPWR VPWR _1252_ sky130_fd_sc_hd__nor2_1
XFILLER_0_66_248 VGND VGND VPWR VPWR sky130_fd_sc_hd__decap_4
XFILLER_0_19_142 VPWR VGND VPWR VGND sky130_ef_sc_hd__decap_12
XFILLER_0_74_281 VGND VGND VPWR VPWR sky130_fd_sc_hd__decap_4
XFILLER_0_62_421 VGND VGND VPWR VPWR sky130_fd_sc_hd__decap_6
XFILLER_0_22_307 VGND VGND VPWR VPWR sky130_fd_sc_hd__fill_1
XFILLER_0_62_465 VGND VGND VPWR VPWR sky130_fd_sc_hd__decap_8
XFILLER_0_15_69 VGND VGND VPWR VPWR sky130_fd_sc_hd__decap_8
XFILLER_0_25_123 VPWR VGND VPWR VGND sky130_ef_sc_hd__decap_12
XFILLER_0_31_57 VGND VGND VPWR VPWR sky130_fd_sc_hd__decap_6
XTAP_TAPCELL_ROW_13_287 VGND VPWR sky130_fd_sc_hd__tapvpwrvgnd_1
X_4380_ _0428_ u_interface.u_compute_core.relu_data\[27\] _1494_ VGND VGND VPWR VPWR
+ _1596_ sky130_fd_sc_hd__and3_1
X_3400_ _0635_ _0633_ u_interface.u_compute_core.u_av.v_extended\[2\] _1835_ VGND
+ VGND VPWR VPWR _0636_ sky130_fd_sc_hd__nor4bb_2
X_3331_ _0526_ _0528_ VGND VGND VPWR VPWR _0569_ sky130_fd_sc_hd__nand2_1
XFILLER_0_0_289 VGND VGND VPWR VPWR sky130_fd_sc_hd__fill_1
X_3262_ _0481_ _0501_ VGND VGND VPWR VPWR _0502_ sky130_fd_sc_hd__xnor2_1
XFILLER_0_56_43 VGND VGND VPWR VPWR sky130_fd_sc_hd__decap_8
X_3193_ _0438_ VGND VGND VPWR VPWR _0439_ sky130_fd_sc_hd__clkbuf_4
XFILLER_0_22_7 VGND VGND VPWR VPWR sky130_fd_sc_hd__fill_2
XFILLER_0_15_6 VPWR VGND VPWR VGND sky130_ef_sc_hd__decap_12
XFILLER_0_72_53 VPWR VGND VPWR VGND sky130_ef_sc_hd__decap_12
XFILLER_0_8_345 VGND VGND VPWR VPWR sky130_fd_sc_hd__decap_6
XFILLER_0_29_462 VPWR VGND VPWR VGND sky130_ef_sc_hd__decap_12
XFILLER_0_63_229 VPWR VGND VPWR VGND sky130_ef_sc_hd__decap_12
X_2977_ _2178_ _2202_ _2226_ net17 VGND VGND VPWR VPWR _0235_ sky130_fd_sc_hd__and4_1
XFILLER_0_44_421 VGND VGND VPWR VPWR sky130_fd_sc_hd__decap_8
X_4716_ clknet_4_5_0_clk _0081_ VGND VGND VPWR VPWR u_interface.u_compute_core.mac_accum\[22\]
+ sky130_fd_sc_hd__dfxtp_1
XFILLER_0_71_262 VGND VGND VPWR VPWR sky130_fd_sc_hd__decap_4
X_4647_ clknet_4_3_0_clk _0012_ VGND VGND VPWR VPWR u_interface.u_compute_core.relu_data\[12\]
+ sky130_fd_sc_hd__dfxtp_1
XFILLER_0_12_340 VGND VGND VPWR VPWR sky130_fd_sc_hd__fill_2
X_4578_ _1772_ VGND VGND VPWR VPWR _0163_ sky130_fd_sc_hd__clkbuf_1
X_3529_ _0720_ _0717_ VGND VGND VPWR VPWR _0762_ sky130_fd_sc_hd__and2b_1
XTAP_TAPCELL_ROW_4_211 VGND VPWR sky130_fd_sc_hd__tapvpwrvgnd_1
XTAP_TAPCELL_ROW_55_644 VGND VPWR sky130_fd_sc_hd__tapvpwrvgnd_1
XFILLER_0_54_218 VGND VGND VPWR VPWR sky130_fd_sc_hd__decap_8
XFILLER_0_35_443 VGND VGND VPWR VPWR sky130_fd_sc_hd__decap_4
XTAP_TAPCELL_ROW_10_257 VGND VPWR sky130_fd_sc_hd__tapvpwrvgnd_1
XFILLER_0_22_126 VPWR VGND VPWR VGND sky130_ef_sc_hd__decap_12
XFILLER_0_30_170 VGND VGND VPWR VPWR sky130_fd_sc_hd__decap_4
Xhold91 u_interface.u_compute_core.scaled_data\[9\] VGND VGND VPWR VPWR net155 sky130_fd_sc_hd__dlygate4sd3_1
Xhold80 u_interface.u_compute_core.mac_accum\[19\] VGND VGND VPWR VPWR net144 sky130_fd_sc_hd__dlygate4sd3_1
X_2900_ net4 _2226_ net17 net26 VGND VGND VPWR VPWR _2295_ sky130_fd_sc_hd__a22o_1
XFILLER_0_42_67 VGND VGND VPWR VPWR sky130_fd_sc_hd__decap_6
XFILLER_0_45_207 VPWR VGND VPWR VGND sky130_ef_sc_hd__decap_12
X_3880_ _0431_ _1865_ _1056_ _1055_ VGND VGND VPWR VPWR _1106_ sky130_fd_sc_hd__a31o_1
X_2831_ _2225_ _2227_ VGND VGND VPWR VPWR _2228_ sky130_fd_sc_hd__or2_1
X_2762_ net26 VGND VGND VPWR VPWR _2163_ sky130_fd_sc_hd__buf_2
XFILLER_0_5_337 VGND VGND VPWR VPWR sky130_fd_sc_hd__fill_2
X_4501_ _1707_ _1713_ VGND VGND VPWR VPWR _1714_ sky130_fd_sc_hd__xnor2_1
XFILLER_0_5_359 VGND VGND VPWR VPWR sky130_fd_sc_hd__fill_2
X_4432_ _1645_ _1646_ VGND VGND VPWR VPWR _1647_ sky130_fd_sc_hd__xnor2_1
X_2693_ _2064_ u_interface.u_compute_core.mac_accum\[22\] VGND VGND VPWR VPWR _2105_
+ sky130_fd_sc_hd__nor2_1
XFILLER_0_6_56 VGND VGND VPWR VPWR sky130_fd_sc_hd__decap_3
X_4363_ _0453_ _0438_ u_interface.u_compute_core.relu_data\[25\] _1882_ VGND VGND
+ VPWR VPWR _1579_ sky130_fd_sc_hd__and4_1
X_3314_ _0551_ u_interface.u_compute_core.u_av.v_extended\[5\] _1821_ _1818_ VGND
+ VGND VPWR VPWR _0552_ sky130_fd_sc_hd__nand4_1
X_4294_ _1473_ _1456_ _1510_ VGND VGND VPWR VPWR _1512_ sky130_fd_sc_hd__a21o_1
X_3245_ _0484_ _1821_ _1818_ _0441_ VGND VGND VPWR VPWR _0485_ sky130_fd_sc_hd__a22o_1
Xrebuffer12 _1685_ VGND VGND VPWR VPWR net76 sky130_fd_sc_hd__dlygate4sd1_1
X_3176_ _0421_ _0424_ VGND VGND VPWR VPWR _0425_ sky130_fd_sc_hd__or2_1
XPHY_EDGE_ROW_16_Left_98 VGND VGND VPWR VPWR sky130_fd_sc_hd__decap_3
XFILLER_0_13_3 VGND VGND VPWR VPWR sky130_fd_sc_hd__decap_8
XTAP_TAPCELL_ROW_52_614 VGND VPWR sky130_fd_sc_hd__tapvpwrvgnd_1
XFILLER_0_8_120 VGND VGND VPWR VPWR sky130_fd_sc_hd__fill_2
XFILLER_0_76_398 VGND VGND VPWR VPWR sky130_fd_sc_hd__decap_3
XFILLER_0_8_153 VPWR VGND VPWR VGND sky130_ef_sc_hd__decap_12
XFILLER_0_29_270 VGND VGND VPWR VPWR sky130_fd_sc_hd__decap_8
XFILLER_0_29_281 VGND VGND VPWR VPWR sky130_fd_sc_hd__decap_8
XFILLER_0_8_197 VPWR VGND VPWR VGND sky130_ef_sc_hd__decap_12
XFILLER_0_29_292 VGND VGND VPWR VPWR sky130_fd_sc_hd__decap_8
XFILLER_0_44_240 VGND VGND VPWR VPWR sky130_fd_sc_hd__fill_2
XTAP_TAPCELL_ROW_15_305 VGND VPWR sky130_fd_sc_hd__tapvpwrvgnd_1
XFILLER_0_67_321 VGND VGND VPWR VPWR sky130_fd_sc_hd__decap_4
XFILLER_0_67_332 VGND VGND VPWR VPWR sky130_fd_sc_hd__decap_4
XFILLER_0_12_26 VGND VGND VPWR VPWR sky130_fd_sc_hd__fill_2
XTAP_TAPCELL_ROW_23_371 VGND VPWR sky130_fd_sc_hd__tapvpwrvgnd_1
XFILLER_0_35_273 VGND VGND VPWR VPWR sky130_fd_sc_hd__decap_6
XFILLER_0_2_307 VGND VGND VPWR VPWR sky130_fd_sc_hd__fill_1
X_3030_ _0243_ _0249_ _0286_ VGND VGND VPWR VPWR _0287_ sky130_fd_sc_hd__a21o_1
XTAP_TAPCELL_ROW_66_739 VGND VPWR sky130_fd_sc_hd__tapvpwrvgnd_1
XFILLER_0_58_321 VGND VGND VPWR VPWR sky130_fd_sc_hd__decap_8
X_3932_ _1149_ _1156_ VGND VGND VPWR VPWR _1157_ sky130_fd_sc_hd__xor2_1
XFILLER_0_58_365 VPWR VGND VPWR VGND sky130_ef_sc_hd__decap_12
XFILLER_0_73_313 VGND VGND VPWR VPWR sky130_fd_sc_hd__fill_1
X_3863_ _1087_ _1088_ VGND VGND VPWR VPWR _1089_ sky130_fd_sc_hd__xnor2_1
X_2814_ _2210_ _2211_ net100 _2006_ VGND VGND VPWR VPWR _0095_ sky130_fd_sc_hd__a2bb2o_1
X_3794_ _0929_ _1019_ _1021_ VGND VGND VPWR VPWR _1022_ sky130_fd_sc_hd__a21oi_1
XFILLER_0_5_167 VGND VGND VPWR VPWR sky130_fd_sc_hd__fill_1
XFILLER_0_41_232 VGND VGND VPWR VPWR sky130_fd_sc_hd__decap_8
X_2745_ _2142_ _2144_ _2148_ _2003_ VGND VGND VPWR VPWR _2150_ sky130_fd_sc_hd__a31o_1
XFILLER_0_78_41 VPWR VGND VPWR VGND sky130_ef_sc_hd__decap_12
X_2676_ _2086_ _2088_ _2090_ VGND VGND VPWR VPWR _2091_ sky130_fd_sc_hd__a21oi_1
XFILLER_0_78_85 VPWR VGND VPWR VGND sky130_ef_sc_hd__decap_12
X_4415_ _1627_ _1628_ _1629_ VGND VGND VPWR VPWR _1630_ sky130_fd_sc_hd__a21o_1
XFILLER_0_1_373 VPWR VGND VPWR VGND sky130_ef_sc_hd__decap_12
X_4346_ _1504_ _1508_ _1561_ VGND VGND VPWR VPWR _1563_ sky130_fd_sc_hd__nand3_1
X_4277_ _1494_ VGND VGND VPWR VPWR _1495_ sky130_fd_sc_hd__inv_2
X_3228_ _0468_ u_interface.u_compute_core.u_av.v_extended\[2\] _1821_ _1818_ VGND
+ VGND VPWR VPWR _0469_ sky130_fd_sc_hd__and4_1
X_3159_ _0345_ _0346_ _0402_ _0400_ VGND VGND VPWR VPWR _0411_ sky130_fd_sc_hd__a31o_1
XTAP_TAPCELL_ROW_29_419 VGND VPWR sky130_fd_sc_hd__tapvpwrvgnd_1
XFILLER_0_76_195 VGND VGND VPWR VPWR sky130_fd_sc_hd__fill_1
XFILLER_0_64_324 VGND VGND VPWR VPWR sky130_fd_sc_hd__decap_4
XFILLER_0_64_335 VPWR VGND VPWR VGND sky130_ef_sc_hd__decap_12
XFILLER_0_32_221 VPWR VGND VPWR VGND sky130_ef_sc_hd__decap_12
XFILLER_0_32_265 VGND VGND VPWR VPWR sky130_fd_sc_hd__decap_4
XFILLER_0_2_3 VPWR VGND VPWR VGND sky130_ef_sc_hd__decap_12
XTAP_TAPCELL_ROW_63_709 VGND VPWR sky130_fd_sc_hd__tapvpwrvgnd_1
XFILLER_0_23_221 VGND VGND VPWR VPWR sky130_fd_sc_hd__decap_3
Xrebuffer3 net66 VGND VGND VPWR VPWR net67 sky130_fd_sc_hd__buf_2
X_2530_ _1965_ VGND VGND VPWR VPWR _0057_ sky130_fd_sc_hd__clkbuf_1
X_2461_ u_interface.u_compute_core.scaled_data\[7\] u_interface.u_compute_core.mac_accum\[10\]
+ _1900_ VGND VGND VPWR VPWR _1918_ sky130_fd_sc_hd__mux2_1
X_4200_ _1418_ _1419_ VGND VGND VPWR VPWR _1420_ sky130_fd_sc_hd__or2b_1
X_2392_ _1868_ VGND VGND VPWR VPWR _1869_ sky130_fd_sc_hd__inv_2
X_4131_ _1291_ _1293_ VGND VGND VPWR VPWR _1352_ sky130_fd_sc_hd__or2_1
X_4062_ _0442_ _1871_ _1230_ _1283_ VGND VGND VPWR VPWR _1284_ sky130_fd_sc_hd__a31o_1
X_3013_ _0268_ _0269_ VGND VGND VPWR VPWR _0270_ sky130_fd_sc_hd__nor2_1
XFILLER_0_3_57 VPWR VGND VPWR VGND sky130_ef_sc_hd__decap_12
XFILLER_0_80_53 VPWR VGND VPWR VGND sky130_ef_sc_hd__decap_12
XTAP_TAPCELL_ROW_34_466 VGND VPWR sky130_fd_sc_hd__tapvpwrvgnd_1
X_3915_ _0680_ _0511_ u_interface.u_compute_core.relu_data\[14\] _1859_ VGND VGND
+ VPWR VPWR _1140_ sky130_fd_sc_hd__and4_1
XFILLER_0_80_97 VPWR VGND VPWR VGND sky130_ef_sc_hd__decap_12
XFILLER_0_73_187 VGND VGND VPWR VPWR sky130_fd_sc_hd__fill_1
X_3846_ _1070_ _1072_ VGND VGND VPWR VPWR _1073_ sky130_fd_sc_hd__xor2_2
XFILLER_0_61_316 VGND VGND VPWR VPWR sky130_fd_sc_hd__decap_3
XFILLER_0_80_3 VPWR VGND VPWR VGND sky130_ef_sc_hd__decap_12
X_3777_ _1002_ _1004_ VGND VGND VPWR VPWR _1005_ sky130_fd_sc_hd__xor2_2
X_2728_ net128 _2026_ _2134_ _2135_ VGND VGND VPWR VPWR _0085_ sky130_fd_sc_hd__a22o_1
X_2659_ _2057_ _2062_ _2065_ _2076_ VGND VGND VPWR VPWR _2077_ sky130_fd_sc_hd__a31o_1
XFILLER_0_1_181 VPWR VGND VPWR VGND sky130_ef_sc_hd__decap_12
X_4329_ _1482_ _1488_ _1545_ VGND VGND VPWR VPWR _1546_ sky130_fd_sc_hd__a21oi_1
XFILLER_0_69_449 VGND VGND VPWR VPWR sky130_fd_sc_hd__fill_2
XFILLER_0_37_335 VGND VGND VPWR VPWR sky130_fd_sc_hd__fill_1
XFILLER_0_37_357 VPWR VGND VPWR VGND sky130_ef_sc_hd__decap_12
XFILLER_0_9_281 VPWR VGND VPWR VGND sky130_ef_sc_hd__decap_12
XFILLER_0_52_316 VGND VGND VPWR VPWR sky130_fd_sc_hd__decap_8
XFILLER_0_60_371 VPWR VGND VPWR VGND sky130_ef_sc_hd__decap_12
XTAP_TAPCELL_ROW_76_823 VGND VPWR sky130_fd_sc_hd__tapvpwrvgnd_1
X_3700_ _0880_ _0879_ _0833_ net70 _0929_ VGND VGND VPWR VPWR _0930_ sky130_fd_sc_hd__a41o_1
XFILLER_0_50_23 VGND VGND VPWR VPWR sky130_fd_sc_hd__fill_2
XTAP_TAPCELL_ROW_31_436 VGND VPWR sky130_fd_sc_hd__tapvpwrvgnd_1
X_4680_ clknet_4_6_0_clk _0045_ VGND VGND VPWR VPWR u_interface.u_compute_core.scaled_data\[16\]
+ sky130_fd_sc_hd__dfxtp_1
X_3631_ _0860_ _0861_ VGND VGND VPWR VPWR _0862_ sky130_fd_sc_hd__xnor2_1
X_3562_ net81 _0794_ VGND VGND VPWR VPWR _0795_ sky130_fd_sc_hd__xnor2_2
X_2513_ u_interface.u_compute_core.scaled_data\[23\] u_interface.u_compute_core.mac_accum\[26\]
+ _1944_ VGND VGND VPWR VPWR _1954_ sky130_fd_sc_hd__mux2_1
X_3493_ _0723_ _0726_ VGND VGND VPWR VPWR _0727_ sky130_fd_sc_hd__xnor2_2
X_2444_ _1906_ VGND VGND VPWR VPWR _0030_ sky130_fd_sc_hd__clkbuf_1
X_2375_ u_interface.u_compute_core.relu_data\[12\] VGND VGND VPWR VPWR _1856_ sky130_fd_sc_hd__buf_2
X_4114_ _0450_ _0446_ u_interface.u_compute_core.relu_data\[18\] _1871_ VGND VGND
+ VPWR VPWR _1335_ sky130_fd_sc_hd__and4_1
X_4045_ _1227_ _1265_ _1266_ _1219_ _1267_ VGND VGND VPWR VPWR _1268_ sky130_fd_sc_hd__a221oi_2
XFILLER_0_78_235 VGND VGND VPWR VPWR sky130_fd_sc_hd__decap_3
XFILLER_0_59_460 VPWR VGND VPWR VGND sky130_ef_sc_hd__decap_12
XFILLER_0_74_441 VGND VGND VPWR VPWR sky130_fd_sc_hd__fill_2
XFILLER_0_19_335 VGND VGND VPWR VPWR sky130_fd_sc_hd__fill_1
XFILLER_0_19_379 VGND VGND VPWR VPWR sky130_fd_sc_hd__decap_3
XFILLER_0_61_102 VGND VGND VPWR VPWR sky130_fd_sc_hd__decap_8
X_3829_ _1054_ _1055_ VGND VGND VPWR VPWR _1056_ sky130_fd_sc_hd__nor2_1
XFILLER_0_6_273 VGND VGND VPWR VPWR sky130_fd_sc_hd__fill_2
XFILLER_0_10_290 VPWR VGND VPWR VGND sky130_ef_sc_hd__decap_12
XTAP_TAPCELL_ROW_2_194 VGND VPWR sky130_fd_sc_hd__tapvpwrvgnd_1
XFILLER_0_69_268 VPWR VGND VPWR VGND sky130_ef_sc_hd__decap_12
XTAP_TAPCELL_ROW_81_870 VGND VPWR sky130_fd_sc_hd__tapvpwrvgnd_1
XPHY_EDGE_ROW_4_Left_86 VGND VGND VPWR VPWR sky130_fd_sc_hd__decap_3
XFILLER_0_80_400 VGND VGND VPWR VPWR sky130_fd_sc_hd__fill_2
XFILLER_0_37_176 VGND VGND VPWR VPWR sky130_fd_sc_hd__fill_1
XFILLER_0_80_477 VGND VGND VPWR VPWR sky130_fd_sc_hd__decap_6
XFILLER_0_80_466 VGND VGND VPWR VPWR sky130_fd_sc_hd__decap_8
XFILLER_0_0_405 VPWR VGND VPWR VGND sky130_ef_sc_hd__decap_12
XFILLER_0_33_393 VPWR VGND VPWR VGND sky130_ef_sc_hd__decap_12
XFILLER_0_0_449 VPWR VGND VPWR VGND sky130_ef_sc_hd__decap_12
XFILLER_0_29_57 VPWR VGND VPWR VGND sky130_ef_sc_hd__decap_12
XFILLER_0_29_79 VGND VGND VPWR VPWR sky130_fd_sc_hd__decap_4
XTAP_TAPCELL_ROW_44_550 VGND VPWR sky130_fd_sc_hd__tapvpwrvgnd_1
X_2993_ _0200_ _0209_ _0249_ _0250_ VGND VGND VPWR VPWR _0251_ sky130_fd_sc_hd__o211ai_1
X_4801_ clknet_4_14_0_clk _0166_ VGND VGND VPWR VPWR net36 sky130_fd_sc_hd__dfxtp_1
XFILLER_0_61_55 VGND VGND VPWR VPWR sky130_fd_sc_hd__fill_1
XFILLER_0_28_165 VPWR VGND VPWR VGND sky130_ef_sc_hd__decap_12
X_4732_ clknet_4_3_0_clk _0097_ VGND VGND VPWR VPWR u_interface.u_compute_core.u_mac.product_reg\[6\]
+ sky130_fd_sc_hd__dfxtp_1
XFILLER_0_56_463 VPWR VGND VPWR VGND sky130_ef_sc_hd__decap_12
XFILLER_0_16_327 VGND VGND VPWR VPWR sky130_fd_sc_hd__decap_6
XFILLER_0_9_12 VGND VGND VPWR VPWR sky130_fd_sc_hd__decap_3
X_4663_ clknet_4_6_0_clk _0028_ VGND VGND VPWR VPWR u_interface.u_compute_core.scaled_valid
+ sky130_fd_sc_hd__dfxtp_1
XFILLER_0_9_78 VPWR VGND VPWR VGND sky130_ef_sc_hd__decap_12
X_3614_ _0480_ _0844_ _0845_ _0667_ VGND VGND VPWR VPWR _0126_ sky130_fd_sc_hd__o211a_1
XFILLER_0_43_157 VGND VGND VPWR VPWR sky130_fd_sc_hd__fill_2
XFILLER_0_31_319 VGND VGND VPWR VPWR sky130_fd_sc_hd__fill_1
X_4594_ _1775_ _1783_ VGND VGND VPWR VPWR _1784_ sky130_fd_sc_hd__and2_1
X_3545_ _0776_ _0777_ VGND VGND VPWR VPWR _0778_ sky130_fd_sc_hd__xnor2_2
X_3476_ _0663_ _0664_ _0710_ VGND VGND VPWR VPWR _0711_ sky130_fd_sc_hd__o21ai_1
X_2427_ u_interface.u_compute_core.scaled_data\[25\] _1814_ _1894_ _1816_ VGND VGND
+ VPWR VPWR _1895_ sky130_fd_sc_hd__o2bb2a_1
XFILLER_0_43_3 VGND VGND VPWR VPWR sky130_fd_sc_hd__decap_8
Xclkbuf_4_15_0_clk clknet_0_clk VGND VGND VPWR VPWR clknet_4_15_0_clk sky130_fd_sc_hd__clkbuf_8
X_2358_ u_interface.u_compute_core.scaled_valid VGND VGND VPWR VPWR _1843_ sky130_fd_sc_hd__clkbuf_2
X_4028_ _1247_ _1249_ _1245_ VGND VGND VPWR VPWR _1251_ sky130_fd_sc_hd__a21oi_1
XFILLER_0_19_154 VPWR VGND VPWR VGND sky130_ef_sc_hd__decap_12
XFILLER_0_47_474 VGND VGND VPWR VPWR sky130_fd_sc_hd__decap_6
XTAP_TAPCELL_ROW_50_597 VGND VPWR sky130_fd_sc_hd__tapvpwrvgnd_1
XFILLER_0_62_477 VGND VGND VPWR VPWR sky130_fd_sc_hd__decap_6
XFILLER_0_15_393 VGND VGND VPWR VPWR sky130_fd_sc_hd__decap_8
XFILLER_0_30_341 VPWR VGND VPWR VGND sky130_ef_sc_hd__decap_12
XFILLER_0_25_113 VGND VGND VPWR VPWR sky130_fd_sc_hd__decap_4
XTAP_TAPCELL_ROW_13_288 VGND VPWR sky130_fd_sc_hd__tapvpwrvgnd_1
XFILLER_0_25_135 VGND VGND VPWR VPWR sky130_fd_sc_hd__fill_2
XFILLER_0_80_285 VGND VGND VPWR VPWR sky130_fd_sc_hd__decap_8
XFILLER_0_80_263 VGND VGND VPWR VPWR sky130_fd_sc_hd__fill_1
XFILLER_0_80_296 VGND VGND VPWR VPWR sky130_fd_sc_hd__decap_8
XFILLER_0_0_202 VGND VGND VPWR VPWR sky130_fd_sc_hd__decap_4
XFILLER_0_40_138 VGND VGND VPWR VPWR sky130_fd_sc_hd__fill_2
X_3330_ _0543_ _0567_ VGND VGND VPWR VPWR _0568_ sky130_fd_sc_hd__xnor2_1
X_3261_ _0475_ net72 VGND VGND VPWR VPWR _0501_ sky130_fd_sc_hd__xnor2_1
X_3192_ _0437_ VGND VGND VPWR VPWR _0438_ sky130_fd_sc_hd__clkbuf_2
XFILLER_0_56_88 VPWR VGND VPWR VGND sky130_ef_sc_hd__decap_12
XFILLER_0_72_65 VGND VGND VPWR VPWR sky130_fd_sc_hd__decap_8
XFILLER_0_29_474 VGND VGND VPWR VPWR sky130_fd_sc_hd__decap_6
X_2976_ _2202_ _2226_ _2256_ _2178_ VGND VGND VPWR VPWR _0234_ sky130_fd_sc_hd__a22oi_1
X_4715_ clknet_4_4_0_clk _0080_ VGND VGND VPWR VPWR u_interface.u_compute_core.mac_accum\[21\]
+ sky130_fd_sc_hd__dfxtp_1
XFILLER_0_16_168 VPWR VGND VPWR VGND sky130_ef_sc_hd__decap_12
XFILLER_0_44_477 VGND VGND VPWR VPWR sky130_fd_sc_hd__decap_3
X_4646_ clknet_4_3_0_clk _0011_ VGND VGND VPWR VPWR u_interface.u_compute_core.relu_data\[11\]
+ sky130_fd_sc_hd__dfxtp_1
X_4577_ _1753_ _1771_ VGND VGND VPWR VPWR _1772_ sky130_fd_sc_hd__and2_1
X_3528_ _0716_ _0743_ _0760_ VGND VGND VPWR VPWR _0761_ sky130_fd_sc_hd__a21o_1
X_3459_ _0644_ _0646_ VGND VGND VPWR VPWR _0694_ sky130_fd_sc_hd__and2_1
XTAP_TAPCELL_ROW_4_212 VGND VPWR sky130_fd_sc_hd__tapvpwrvgnd_1
XFILLER_0_79_385 VGND VGND VPWR VPWR sky130_fd_sc_hd__decap_6
XTAP_TAPCELL_ROW_55_645 VGND VPWR sky130_fd_sc_hd__tapvpwrvgnd_1
XTAP_TAPCELL_ROW_10_258 VGND VPWR sky130_fd_sc_hd__tapvpwrvgnd_1
XFILLER_0_22_105 VGND VGND VPWR VPWR sky130_fd_sc_hd__fill_1
XFILLER_0_62_274 VPWR VGND VPWR VGND sky130_ef_sc_hd__decap_12
XFILLER_0_22_138 VGND VGND VPWR VPWR sky130_fd_sc_hd__fill_2
Xhold70 u_interface.u_compute_core.mac_accum\[11\] VGND VGND VPWR VPWR net134 sky130_fd_sc_hd__dlygate4sd3_1
Xhold81 u_interface.u_compute_core.mac_accum\[15\] VGND VGND VPWR VPWR net145 sky130_fd_sc_hd__dlygate4sd3_1
XTAP_TAPCELL_ROW_18_325 VGND VPWR sky130_fd_sc_hd__tapvpwrvgnd_1
X_2830_ _2163_ _2193_ _2226_ net25 VGND VGND VPWR VPWR _2227_ sky130_fd_sc_hd__a22oi_1
XFILLER_0_42_57 VGND VGND VPWR VPWR sky130_fd_sc_hd__decap_3
XFILLER_0_45_219 VGND VGND VPWR VPWR sky130_fd_sc_hd__decap_4
XFILLER_0_5_305 VPWR VGND VPWR VGND sky130_ef_sc_hd__decap_12
X_2761_ _2161_ _2162_ _1973_ _2100_ net135 VGND VGND VPWR VPWR _0091_ sky130_fd_sc_hd__a32o_1
X_4500_ _1710_ _1712_ VGND VGND VPWR VPWR _1713_ sky130_fd_sc_hd__xnor2_1
X_2692_ _2020_ _2103_ _2104_ _2100_ net142 VGND VGND VPWR VPWR _0080_ sky130_fd_sc_hd__a32o_1
X_4431_ _1495_ _1595_ _0428_ u_interface.u_compute_core.relu_data\[27\] VGND VGND
+ VPWR VPWR _1646_ sky130_fd_sc_hd__o211a_1
XANTENNA_1 _1811_ VGND VGND VPWR VPWR sky130_fd_sc_hd__diode_2
X_4362_ _1547_ _1555_ _1577_ VGND VGND VPWR VPWR _1578_ sky130_fd_sc_hd__o21a_1
X_3313_ u_interface.u_compute_core.u_av.v_extended\[6\] VGND VGND VPWR VPWR _0551_
+ sky130_fd_sc_hd__buf_2
XFILLER_0_67_65 VGND VGND VPWR VPWR sky130_fd_sc_hd__fill_1
X_4293_ _1473_ _1456_ _1510_ VGND VGND VPWR VPWR _1511_ sky130_fd_sc_hd__nand3_1
X_3244_ u_interface.u_compute_core.u_av.v_extended\[3\] VGND VGND VPWR VPWR _0484_
+ sky130_fd_sc_hd__clkbuf_4
XFILLER_0_67_87 VGND VGND VPWR VPWR sky130_fd_sc_hd__fill_1
XTAP_TAPCELL_ROW_69_759 VGND VPWR sky130_fd_sc_hd__tapvpwrvgnd_1
X_3175_ _0423_ VGND VGND VPWR VPWR _0424_ sky130_fd_sc_hd__buf_2
Xrebuffer13 _0790_ VGND VGND VPWR VPWR net77 sky130_fd_sc_hd__buf_2
XFILLER_0_76_300 VGND VGND VPWR VPWR sky130_fd_sc_hd__decap_8
XFILLER_0_16_91 VGND VGND VPWR VPWR sky130_fd_sc_hd__decap_8
XTAP_TAPCELL_ROW_52_615 VGND VPWR sky130_fd_sc_hd__tapvpwrvgnd_1
XFILLER_0_8_110 VGND VGND VPWR VPWR sky130_fd_sc_hd__decap_3
XFILLER_0_8_132 VGND VGND VPWR VPWR sky130_fd_sc_hd__decap_8
XFILLER_0_8_165 VPWR VGND VPWR VGND sky130_ef_sc_hd__decap_12
X_2959_ _0216_ _0217_ VGND VGND VPWR VPWR _0218_ sky130_fd_sc_hd__nor2_1
XFILLER_0_17_477 VGND VGND VPWR VPWR sky130_fd_sc_hd__decap_3
X_4629_ net52 u_interface.core_attn_out\[30\] u_interface.core_valid_out VGND VGND
+ VPWR VPWR _1807_ sky130_fd_sc_hd__mux2_1
XTAP_TAPCELL_ROW_15_306 VGND VPWR sky130_fd_sc_hd__tapvpwrvgnd_1
XFILLER_0_12_16 VGND VGND VPWR VPWR sky130_fd_sc_hd__decap_6
XTAP_TAPCELL_ROW_23_372 VGND VPWR sky130_fd_sc_hd__tapvpwrvgnd_1
XFILLER_0_23_436 VPWR VGND VPWR VGND sky130_ef_sc_hd__decap_12
XFILLER_0_50_277 VGND VGND VPWR VPWR sky130_fd_sc_hd__decap_6
Xoutput60 net60 VGND VGND VPWR VPWR m_tdata[9] sky130_fd_sc_hd__buf_2
X_3931_ _1108_ _1155_ VGND VGND VPWR VPWR _1156_ sky130_fd_sc_hd__xor2_1
XFILLER_0_58_377 VPWR VGND VPWR VGND sky130_ef_sc_hd__decap_12
X_3862_ _0484_ u_interface.u_compute_core.relu_data\[15\] VGND VGND VPWR VPWR _1088_
+ sky130_fd_sc_hd__nand2_1
X_2813_ _2191_ _2209_ _2004_ VGND VGND VPWR VPWR _2211_ sky130_fd_sc_hd__a21o_1
XFILLER_0_5_113 VPWR VGND VPWR VGND sky130_ef_sc_hd__decap_12
X_3793_ _0943_ _0973_ _1020_ VGND VGND VPWR VPWR _1021_ sky130_fd_sc_hd__o21a_1
XFILLER_0_81_391 VGND VGND VPWR VPWR sky130_fd_sc_hd__fill_1
X_2744_ _2142_ _2144_ _2148_ VGND VGND VPWR VPWR _2149_ sky130_fd_sc_hd__a21oi_1
X_2675_ _2066_ u_interface.u_compute_core.mac_accum\[19\] VGND VGND VPWR VPWR _2090_
+ sky130_fd_sc_hd__xor2_1
XFILLER_0_78_53 VPWR VGND VPWR VGND sky130_ef_sc_hd__decap_12
X_4414_ _0451_ _0447_ _1890_ _1887_ VGND VGND VPWR VPWR _1629_ sky130_fd_sc_hd__and4_1
XFILLER_0_78_97 VPWR VGND VPWR VGND sky130_ef_sc_hd__decap_12
XFILLER_0_1_385 VGND VGND VPWR VPWR sky130_fd_sc_hd__decap_6
X_4345_ _1504_ _1508_ _1561_ VGND VGND VPWR VPWR _1562_ sky130_fd_sc_hd__a21oi_1
X_4276_ _0424_ u_interface.u_compute_core.relu_data\[26\] VGND VGND VPWR VPWR _1494_
+ sky130_fd_sc_hd__nand2_1
X_3227_ net83 VGND VGND VPWR VPWR _0468_ sky130_fd_sc_hd__buf_6
X_3158_ _1973_ _0408_ _0409_ _0410_ VGND VGND VPWR VPWR _0105_ sky130_fd_sc_hd__a31o_1
X_3089_ _0342_ _0343_ VGND VGND VPWR VPWR _0344_ sky130_fd_sc_hd__xnor2_1
XFILLER_0_76_141 VPWR VGND VPWR VGND sky130_ef_sc_hd__decap_12
XFILLER_0_9_441 VGND VGND VPWR VPWR sky130_fd_sc_hd__fill_1
XFILLER_0_64_347 VPWR VGND VPWR VGND sky130_ef_sc_hd__decap_12
XTAP_TAPCELL_ROW_20_342 VGND VPWR sky130_fd_sc_hd__tapvpwrvgnd_1
XFILLER_0_32_233 VPWR VGND VPWR VGND sky130_ef_sc_hd__decap_12
XFILLER_0_67_141 VGND VGND VPWR VPWR sky130_fd_sc_hd__fill_1
XTAP_TAPCELL_ROW_71_776 VGND VPWR sky130_fd_sc_hd__tapvpwrvgnd_1
Xrebuffer4 _0580_ VGND VGND VPWR VPWR net68 sky130_fd_sc_hd__dlygate4sd1_1
X_2460_ _1917_ VGND VGND VPWR VPWR _0035_ sky130_fd_sc_hd__clkbuf_1
X_2391_ u_interface.u_compute_core.relu_data\[16\] VGND VGND VPWR VPWR _1868_ sky130_fd_sc_hd__buf_2
X_4130_ _1342_ _1350_ VGND VGND VPWR VPWR _1351_ sky130_fd_sc_hd__xor2_1
XPHY_EDGE_ROW_79_Left_161 VGND VGND VPWR VPWR sky130_fd_sc_hd__decap_3
X_4061_ _0468_ u_interface.u_compute_core.relu_data\[18\] _1228_ VGND VGND VPWR VPWR
+ _1283_ sky130_fd_sc_hd__and3_1
X_3012_ _0226_ _0229_ _0267_ VGND VGND VPWR VPWR _0269_ sky130_fd_sc_hd__nor3_1
XFILLER_0_3_69 VPWR VGND VPWR VGND sky130_ef_sc_hd__decap_12
XFILLER_0_78_406 VGND VGND VPWR VPWR sky130_fd_sc_hd__fill_2
XFILLER_0_64_77 VGND VGND VPWR VPWR sky130_fd_sc_hd__decap_6
XFILLER_0_78_439 VGND VGND VPWR VPWR sky130_fd_sc_hd__fill_2
XFILLER_0_58_141 VGND VGND VPWR VPWR sky130_fd_sc_hd__fill_1
XFILLER_0_80_65 VPWR VGND VPWR VGND sky130_ef_sc_hd__decap_12
XTAP_TAPCELL_ROW_34_467 VGND VPWR sky130_fd_sc_hd__tapvpwrvgnd_1
XFILLER_0_46_325 VGND VGND VPWR VPWR sky130_fd_sc_hd__decap_3
X_3914_ _0446_ _1862_ _1859_ _0450_ VGND VGND VPWR VPWR _1139_ sky130_fd_sc_hd__a22oi_1
X_3845_ _1018_ _1025_ _1071_ VGND VGND VPWR VPWR _1072_ sky130_fd_sc_hd__o21ba_1
XFILLER_0_6_477 VGND VGND VPWR VPWR sky130_fd_sc_hd__decap_3
X_3776_ _0960_ _1853_ _0689_ _1003_ VGND VGND VPWR VPWR _1004_ sky130_fd_sc_hd__a31o_1
X_2727_ _2133_ _2128_ _2129_ _2032_ VGND VGND VPWR VPWR _2135_ sky130_fd_sc_hd__o31a_1
XFILLER_0_73_3 VPWR VGND VPWR VGND sky130_ef_sc_hd__decap_12
X_2658_ _2064_ u_interface.u_compute_core.mac_accum\[15\] VGND VGND VPWR VPWR _2076_
+ sky130_fd_sc_hd__nor2_1
XFILLER_0_1_193 VPWR VGND VPWR VGND sky130_ef_sc_hd__decap_12
X_2589_ _1999_ _2010_ _2008_ _2009_ VGND VGND VPWR VPWR _2016_ sky130_fd_sc_hd__a31o_1
XFILLER_0_10_483 VGND VGND VPWR VPWR sky130_fd_sc_hd__fill_1
X_4328_ _1481_ _1480_ VGND VGND VPWR VPWR _1545_ sky130_fd_sc_hd__and2b_1
X_4259_ _0439_ _1887_ _1877_ _0454_ VGND VGND VPWR VPWR _1477_ sky130_fd_sc_hd__a22oi_1
XFILLER_0_77_483 VGND VGND VPWR VPWR sky130_fd_sc_hd__fill_1
XFILLER_0_37_303 VPWR VGND VPWR VGND sky130_ef_sc_hd__decap_12
XFILLER_0_49_163 VGND VGND VPWR VPWR sky130_fd_sc_hd__decap_4
XFILLER_0_9_293 VPWR VGND VPWR VGND sky130_ef_sc_hd__decap_12
XFILLER_0_37_369 VPWR VGND VPWR VGND sky130_ef_sc_hd__decap_12
XFILLER_0_45_391 VGND VGND VPWR VPWR sky130_fd_sc_hd__fill_1
XFILLER_0_20_203 VGND VGND VPWR VPWR sky130_fd_sc_hd__decap_4
XFILLER_0_60_383 VGND VGND VPWR VPWR sky130_fd_sc_hd__fill_2
XTAP_TAPCELL_ROW_76_824 VGND VPWR sky130_fd_sc_hd__tapvpwrvgnd_1
XFILLER_0_34_14 VGND VGND VPWR VPWR sky130_fd_sc_hd__fill_2
XFILLER_0_34_36 VPWR VGND VPWR VGND sky130_ef_sc_hd__decap_12
XFILLER_0_55_100 VGND VGND VPWR VPWR sky130_fd_sc_hd__fill_1
XFILLER_0_68_483 VGND VGND VPWR VPWR sky130_fd_sc_hd__fill_1
XTAP_TAPCELL_ROW_31_437 VGND VPWR sky130_fd_sc_hd__tapvpwrvgnd_1
X_3630_ net83 u_interface.u_compute_core.relu_data\[10\] VGND VGND VPWR VPWR _0861_
+ sky130_fd_sc_hd__nand2_1
X_3561_ _0747_ _0750_ _0793_ VGND VGND VPWR VPWR _0794_ sky130_fd_sc_hd__a21oi_2
XFILLER_0_3_447 VGND VGND VPWR VPWR sky130_fd_sc_hd__fill_1
X_2512_ _1812_ VGND VGND VPWR VPWR _1953_ sky130_fd_sc_hd__clkbuf_4
XFILLER_0_51_372 VGND VGND VPWR VPWR sky130_fd_sc_hd__fill_1
X_3492_ _0724_ _0725_ VGND VGND VPWR VPWR _0726_ sky130_fd_sc_hd__nor2_2
X_2443_ _1813_ _1905_ VGND VGND VPWR VPWR _1906_ sky130_fd_sc_hd__and2_1
X_2374_ _1848_ _1855_ VGND VGND VPWR VPWR _0011_ sky130_fd_sc_hd__nor2_1
X_4113_ _0446_ u_interface.u_compute_core.relu_data\[18\] _1871_ _0450_ VGND VGND
+ VPWR VPWR _1334_ sky130_fd_sc_hd__a22oi_1
XTAP_TAPCELL_ROW_39_504 VGND VPWR sky130_fd_sc_hd__tapvpwrvgnd_1
X_4044_ _1213_ _1264_ VGND VGND VPWR VPWR _1267_ sky130_fd_sc_hd__nor2_1
XFILLER_0_59_472 VPWR VGND VPWR VGND sky130_ef_sc_hd__decap_12
XFILLER_0_74_464 VPWR VGND VPWR VGND sky130_ef_sc_hd__decap_12
XFILLER_0_34_306 VGND VGND VPWR VPWR sky130_fd_sc_hd__fill_2
X_3828_ _0551_ _0634_ u_interface.u_compute_core.relu_data\[12\] u_interface.u_compute_core.relu_data\[11\]
+ VGND VGND VPWR VPWR _1055_ sky130_fd_sc_hd__and4_1
X_3759_ _0626_ _1859_ _0954_ _0953_ VGND VGND VPWR VPWR _0987_ sky130_fd_sc_hd__a31o_1
XTAP_TAPCELL_ROW_2_195 VGND VPWR sky130_fd_sc_hd__tapvpwrvgnd_1
XTAP_TAPCELL_ROW_81_871 VGND VPWR sky130_fd_sc_hd__tapvpwrvgnd_1
XFILLER_0_65_442 VGND VGND VPWR VPWR sky130_fd_sc_hd__fill_1
XFILLER_0_37_155 VGND VGND VPWR VPWR sky130_fd_sc_hd__fill_2
XFILLER_0_37_166 VGND VGND VPWR VPWR sky130_fd_sc_hd__fill_2
XFILLER_0_52_114 VGND VGND VPWR VPWR sky130_fd_sc_hd__decap_3
XFILLER_0_20_27 VGND VGND VPWR VPWR sky130_fd_sc_hd__fill_1
XFILLER_0_40_309 VPWR VGND VPWR VGND sky130_ef_sc_hd__decap_12
XFILLER_0_0_417 VGND VGND VPWR VPWR sky130_fd_sc_hd__decap_3
XFILLER_0_29_14 VGND VGND VPWR VPWR sky130_fd_sc_hd__fill_2
XFILLER_0_29_69 VGND VGND VPWR VPWR sky130_fd_sc_hd__decap_4
XFILLER_0_45_57 VGND VGND VPWR VPWR sky130_fd_sc_hd__decap_3
XFILLER_0_0_15 VPWR VGND VPWR VGND sky130_ef_sc_hd__decap_12
X_4800_ clknet_4_9_0_clk _0165_ VGND VGND VPWR VPWR net35 sky130_fd_sc_hd__dfxtp_1
X_2992_ _0243_ _0244_ _0248_ VGND VGND VPWR VPWR _0250_ sky130_fd_sc_hd__a21o_1
XTAP_TAPCELL_ROW_44_551 VGND VPWR sky130_fd_sc_hd__tapvpwrvgnd_1
X_4731_ clknet_4_0_0_clk _0096_ VGND VGND VPWR VPWR u_interface.u_compute_core.u_mac.product_reg\[5\]
+ sky130_fd_sc_hd__dfxtp_1
XFILLER_0_56_475 VGND VGND VPWR VPWR sky130_fd_sc_hd__fill_1
XFILLER_0_9_24 VGND VGND VPWR VPWR sky130_fd_sc_hd__fill_2
XFILLER_0_28_177 VGND VGND VPWR VPWR sky130_fd_sc_hd__decap_8
XFILLER_0_43_125 VGND VGND VPWR VPWR sky130_fd_sc_hd__fill_1
X_4662_ clknet_4_7_0_clk _0027_ VGND VGND VPWR VPWR u_interface.u_compute_core.relu_data\[27\]
+ sky130_fd_sc_hd__dfxtp_2
XFILLER_0_9_57 VGND VGND VPWR VPWR sky130_fd_sc_hd__decap_4
X_3613_ u_interface.core_attn_out\[9\] _0713_ VGND VGND VPWR VPWR _0845_ sky130_fd_sc_hd__or2_1
X_4593_ net38 u_interface.core_attn_out\[18\] _1782_ VGND VGND VPWR VPWR _1783_ sky130_fd_sc_hd__mux2_1
X_3544_ _0484_ u_interface.u_compute_core.relu_data\[8\] VGND VGND VPWR VPWR _0777_
+ sky130_fd_sc_hd__nand2_1
X_3475_ u_interface.core_attn_out\[5\] _0662_ VGND VGND VPWR VPWR _0710_ sky130_fd_sc_hd__nand2_1
X_2426_ _1893_ VGND VGND VPWR VPWR _1894_ sky130_fd_sc_hd__inv_2
XFILLER_0_36_3 VGND VGND VPWR VPWR sky130_fd_sc_hd__decap_8
X_2357_ _1841_ VGND VGND VPWR VPWR _1842_ sky130_fd_sc_hd__inv_2
X_4027_ _1245_ _1247_ _1249_ VGND VGND VPWR VPWR _1250_ sky130_fd_sc_hd__and3_1
XFILLER_0_66_217 VGND VGND VPWR VPWR sky130_fd_sc_hd__fill_1
XFILLER_0_19_111 VGND VGND VPWR VPWR sky130_fd_sc_hd__fill_1
XFILLER_0_81_209 VPWR VGND VPWR VGND sky130_ef_sc_hd__decap_12
XFILLER_0_19_166 VGND VGND VPWR VPWR sky130_fd_sc_hd__fill_2
XFILLER_0_47_442 VGND VGND VPWR VPWR sky130_fd_sc_hd__decap_6
XTAP_TAPCELL_ROW_50_598 VGND VPWR sky130_fd_sc_hd__tapvpwrvgnd_1
XFILLER_0_22_309 VGND VGND VPWR VPWR sky130_fd_sc_hd__decap_6
XFILLER_0_30_353 VGND VGND VPWR VPWR sky130_fd_sc_hd__decap_8
XTAP_TAPCELL_ROW_7_232 VGND VPWR sky130_fd_sc_hd__tapvpwrvgnd_1
XTAP_TAPCELL_ROW_58_665 VGND VPWR sky130_fd_sc_hd__tapvpwrvgnd_1
XFILLER_0_31_26 VPWR VGND VPWR VGND sky130_ef_sc_hd__decap_12
XTAP_TAPCELL_ROW_41_521 VGND VPWR sky130_fd_sc_hd__tapvpwrvgnd_1
XFILLER_0_31_48 VGND VGND VPWR VPWR sky130_fd_sc_hd__decap_4
XFILLER_0_80_253 VGND VGND VPWR VPWR sky130_fd_sc_hd__fill_2
XTAP_TAPCELL_ROW_13_289 VGND VPWR sky130_fd_sc_hd__tapvpwrvgnd_1
XFILLER_0_25_158 VGND VGND VPWR VPWR sky130_fd_sc_hd__decap_8
XFILLER_0_25_169 VGND VGND VPWR VPWR sky130_fd_sc_hd__fill_2
XFILLER_0_0_225 VPWR VGND VPWR VGND sky130_ef_sc_hd__decap_12
X_3260_ _0499_ _0464_ VGND VGND VPWR VPWR _0500_ sky130_fd_sc_hd__xnor2_1
X_3191_ _0436_ VGND VGND VPWR VPWR _0437_ sky130_fd_sc_hd__buf_8
XFILLER_0_56_56 VGND VGND VPWR VPWR sky130_fd_sc_hd__fill_1
XFILLER_0_8_303 VGND VGND VPWR VPWR sky130_fd_sc_hd__decap_4
XFILLER_0_56_250 VGND VGND VPWR VPWR sky130_fd_sc_hd__fill_2
X_2975_ _0231_ _0232_ VGND VGND VPWR VPWR _0233_ sky130_fd_sc_hd__and2_1
XFILLER_0_56_283 VGND VGND VPWR VPWR sky130_fd_sc_hd__decap_6
X_4714_ clknet_4_4_0_clk _0079_ VGND VGND VPWR VPWR u_interface.u_compute_core.mac_accum\[20\]
+ sky130_fd_sc_hd__dfxtp_1
XFILLER_0_21_81 VPWR VGND VPWR VGND sky130_ef_sc_hd__decap_12
X_4645_ clknet_4_12_0_clk _0010_ VGND VGND VPWR VPWR u_interface.u_compute_core.relu_data\[10\]
+ sky130_fd_sc_hd__dfxtp_4
XFILLER_0_31_139 VGND VGND VPWR VPWR sky130_fd_sc_hd__decap_6
X_4576_ net33 u_interface.core_attn_out\[13\] _1760_ VGND VGND VPWR VPWR _1771_ sky130_fd_sc_hd__mux2_1
X_3527_ _0742_ _0740_ VGND VGND VPWR VPWR _0760_ sky130_fd_sc_hd__and2b_1
X_3458_ _0683_ _0692_ VGND VGND VPWR VPWR _0693_ sky130_fd_sc_hd__xnor2_2
X_3389_ _0454_ _0587_ _0624_ VGND VGND VPWR VPWR _0625_ sky130_fd_sc_hd__a21bo_1
XTAP_TAPCELL_ROW_4_213 VGND VPWR sky130_fd_sc_hd__tapvpwrvgnd_1
X_2409_ _1879_ _1881_ VGND VGND VPWR VPWR _0020_ sky130_fd_sc_hd__nor2_1
XPHY_EDGE_ROW_24_Left_106 VGND VGND VPWR VPWR sky130_fd_sc_hd__decap_3
XTAP_TAPCELL_ROW_55_646 VGND VPWR sky130_fd_sc_hd__tapvpwrvgnd_1
XPHY_EDGE_ROW_33_Left_115 VGND VGND VPWR VPWR sky130_fd_sc_hd__decap_3
XFILLER_0_47_272 VGND VGND VPWR VPWR sky130_fd_sc_hd__fill_1
XFILLER_0_47_294 VGND VGND VPWR VPWR sky130_fd_sc_hd__decap_8
XFILLER_0_62_253 VGND VGND VPWR VPWR sky130_fd_sc_hd__decap_4
XTAP_TAPCELL_ROW_10_259 VGND VPWR sky130_fd_sc_hd__tapvpwrvgnd_1
XFILLER_0_62_286 VGND VGND VPWR VPWR sky130_fd_sc_hd__decap_4
XPHY_EDGE_ROW_42_Left_124 VGND VGND VPWR VPWR sky130_fd_sc_hd__decap_3
XFILLER_0_26_15 VPWR VGND VPWR VGND sky130_ef_sc_hd__decap_12
Xhold71 u_interface.u_compute_core.u_mac.product_reg\[0\] VGND VGND VPWR VPWR net135
+ sky130_fd_sc_hd__dlygate4sd3_1
Xhold82 u_interface.core_attn_out\[15\] VGND VGND VPWR VPWR net146 sky130_fd_sc_hd__dlygate4sd3_1
Xhold60 u_interface.core_attn_out\[25\] VGND VGND VPWR VPWR net124 sky130_fd_sc_hd__dlygate4sd3_1
XTAP_TAPCELL_ROW_18_326 VGND VPWR sky130_fd_sc_hd__tapvpwrvgnd_1
XPHY_EDGE_ROW_51_Left_133 VGND VGND VPWR VPWR sky130_fd_sc_hd__decap_3
X_2760_ net10 VGND VGND VPWR VPWR _2162_ sky130_fd_sc_hd__buf_2
XFILLER_0_5_317 VGND VGND VPWR VPWR sky130_fd_sc_hd__fill_1
XFILLER_0_38_294 VGND VGND VPWR VPWR sky130_fd_sc_hd__decap_6
Xclkbuf_4_14_0_clk clknet_0_clk VGND VGND VPWR VPWR clknet_4_14_0_clk sky130_fd_sc_hd__clkbuf_8
X_2691_ _2101_ _2102_ VGND VGND VPWR VPWR _2104_ sky130_fd_sc_hd__nand2_1
X_4430_ _1643_ _1644_ VGND VGND VPWR VPWR _1645_ sky130_fd_sc_hd__nor2_1
XFILLER_0_13_128 VGND VGND VPWR VPWR sky130_fd_sc_hd__decap_8
XANTENNA_2 _1879_ VGND VGND VPWR VPWR sky130_fd_sc_hd__diode_2
X_4361_ _1544_ _1546_ VGND VGND VPWR VPWR _1577_ sky130_fd_sc_hd__or2_1
X_3312_ _0548_ _0549_ VGND VGND VPWR VPWR _0550_ sky130_fd_sc_hd__or2_1
XPHY_EDGE_ROW_60_Left_142 VGND VGND VPWR VPWR sky130_fd_sc_hd__decap_3
X_4292_ _1508_ _1509_ VGND VGND VPWR VPWR _1510_ sky130_fd_sc_hd__nand2_1
X_3243_ u_interface.u_compute_core.u_av.v_extended\[2\] VGND VGND VPWR VPWR _0483_
+ sky130_fd_sc_hd__clkbuf_4
X_3174_ _0422_ VGND VGND VPWR VPWR _0423_ sky130_fd_sc_hd__buf_2
Xrebuffer14 _1653_ VGND VGND VPWR VPWR net78 sky130_fd_sc_hd__dlygate4sd1_1
XTAP_TAPCELL_ROW_52_616 VGND VPWR sky130_fd_sc_hd__tapvpwrvgnd_1
XFILLER_0_8_100 VGND VGND VPWR VPWR sky130_fd_sc_hd__decap_6
XFILLER_0_36_209 VGND VGND VPWR VPWR sky130_fd_sc_hd__fill_1
XFILLER_0_17_401 VGND VGND VPWR VPWR sky130_fd_sc_hd__decap_3
XFILLER_0_17_434 VGND VGND VPWR VPWR sky130_fd_sc_hd__decap_8
XFILLER_0_8_177 VPWR VGND VPWR VGND sky130_ef_sc_hd__decap_12
X_2958_ _2308_ _2310_ VGND VGND VPWR VPWR _0217_ sky130_fd_sc_hd__and2b_1
XTAP_TAPCELL_ROW_60_682 VGND VPWR sky130_fd_sc_hd__tapvpwrvgnd_1
XFILLER_0_44_253 VGND VGND VPWR VPWR sky130_fd_sc_hd__decap_4
X_4628_ _1806_ VGND VGND VPWR VPWR _0179_ sky130_fd_sc_hd__clkbuf_1
X_2889_ _2281_ _2283_ VGND VGND VPWR VPWR _2284_ sky130_fd_sc_hd__nand2_1
XFILLER_0_12_150 VGND VGND VPWR VPWR sky130_fd_sc_hd__fill_2
X_4559_ _1759_ VGND VGND VPWR VPWR _0157_ sky130_fd_sc_hd__clkbuf_1
XFILLER_0_67_301 VGND VGND VPWR VPWR sky130_fd_sc_hd__fill_1
XTAP_TAPCELL_ROW_15_307 VGND VPWR sky130_fd_sc_hd__tapvpwrvgnd_1
XFILLER_0_67_378 VPWR VGND VPWR VGND sky130_ef_sc_hd__decap_12
XTAP_TAPCELL_ROW_23_373 VGND VPWR sky130_fd_sc_hd__tapvpwrvgnd_1
XFILLER_0_2_309 VPWR VGND VPWR VGND sky130_ef_sc_hd__decap_12
XFILLER_0_50_201 VGND VGND VPWR VPWR sky130_fd_sc_hd__fill_1
Xoutput50 net50 VGND VGND VPWR VPWR m_tdata[29] sky130_fd_sc_hd__clkbuf_4
Xoutput61 net61 VGND VGND VPWR VPWR m_tvalid sky130_fd_sc_hd__buf_2
XFILLER_0_37_47 VGND VGND VPWR VPWR sky130_fd_sc_hd__fill_1
X_3930_ _1150_ _1154_ VGND VGND VPWR VPWR _1155_ sky130_fd_sc_hd__xnor2_1
X_3861_ u_interface.u_compute_core.relu_data\[11\] _0596_ VGND VGND VPWR VPWR _1087_
+ sky130_fd_sc_hd__nor2b_1
XFILLER_0_58_389 VGND VGND VPWR VPWR sky130_fd_sc_hd__decap_8
X_2812_ _2191_ _2209_ VGND VGND VPWR VPWR _2210_ sky130_fd_sc_hd__nor2_1
X_3792_ _0924_ _0926_ _0943_ _0973_ VGND VGND VPWR VPWR _1020_ sky130_fd_sc_hd__a2bb2o_1
XFILLER_0_5_125 VPWR VGND VPWR VGND sky130_ef_sc_hd__decap_12
XFILLER_0_26_253 VGND VGND VPWR VPWR sky130_fd_sc_hd__decap_8
X_2743_ _2146_ _2147_ VGND VGND VPWR VPWR _2148_ sky130_fd_sc_hd__nand2_1
XFILLER_0_14_437 VGND VGND VPWR VPWR sky130_fd_sc_hd__fill_1
XFILLER_0_5_169 VPWR VGND VPWR VGND sky130_ef_sc_hd__decap_12
X_2674_ _2020_ _2088_ _2089_ _1980_ net121 VGND VGND VPWR VPWR _0077_ sky130_fd_sc_hd__a32o_1
XFILLER_0_78_65 VPWR VGND VPWR VGND sky130_ef_sc_hd__decap_12
X_4413_ _0447_ _1890_ VGND VGND VPWR VPWR _1628_ sky130_fd_sc_hd__nand2_1
XFILLER_0_41_278 VGND VGND VPWR VPWR sky130_fd_sc_hd__fill_2
X_4344_ _1559_ _1560_ VGND VGND VPWR VPWR _1561_ sky130_fd_sc_hd__xnor2_1
X_4275_ _1434_ _1437_ VGND VGND VPWR VPWR _1493_ sky130_fd_sc_hd__nor2_1
X_3226_ _0431_ _1821_ _1818_ _0439_ VGND VGND VPWR VPWR _0467_ sky130_fd_sc_hd__a22oi_1
X_3157_ net147 _1979_ VGND VGND VPWR VPWR _0410_ sky130_fd_sc_hd__and2_1
XFILLER_0_27_91 VGND VGND VPWR VPWR sky130_fd_sc_hd__decap_3
XTAP_TAPCELL_ROW_65_730 VGND VPWR sky130_fd_sc_hd__tapvpwrvgnd_1
X_3088_ _0303_ _0304_ _0310_ VGND VGND VPWR VPWR _0343_ sky130_fd_sc_hd__a21oi_2
XFILLER_0_49_323 VGND VGND VPWR VPWR sky130_fd_sc_hd__decap_6
XTAP_TAPCELL_ROW_37_487 VGND VPWR sky130_fd_sc_hd__tapvpwrvgnd_1
XFILLER_0_76_175 VPWR VGND VPWR VGND sky130_ef_sc_hd__decap_12
XFILLER_0_76_153 VPWR VGND VPWR VGND sky130_ef_sc_hd__decap_12
XFILLER_0_76_197 VGND VGND VPWR VPWR sky130_fd_sc_hd__decap_8
XFILLER_0_64_359 VGND VGND VPWR VPWR sky130_fd_sc_hd__decap_4
XTAP_TAPCELL_ROW_20_343 VGND VPWR sky130_fd_sc_hd__tapvpwrvgnd_1
XFILLER_0_32_245 VGND VGND VPWR VPWR sky130_fd_sc_hd__fill_1
XFILLER_0_20_418 VGND VGND VPWR VPWR sky130_fd_sc_hd__fill_2
XTAP_TAPCELL_ROW_28_410 VGND VPWR sky130_fd_sc_hd__tapvpwrvgnd_1
XTAP_TAPCELL_ROW_71_777 VGND VPWR sky130_fd_sc_hd__tapvpwrvgnd_1
XFILLER_0_55_315 VGND VGND VPWR VPWR sky130_fd_sc_hd__decap_8
XFILLER_0_67_175 VGND VGND VPWR VPWR sky130_fd_sc_hd__fill_1
XFILLER_0_70_307 VGND VGND VPWR VPWR sky130_fd_sc_hd__fill_1
Xrebuffer5 _0747_ VGND VGND VPWR VPWR net69 sky130_fd_sc_hd__dlygate4sd1_1
XFILLER_0_2_139 VGND VGND VPWR VPWR sky130_fd_sc_hd__fill_1
X_2390_ _1848_ _1867_ VGND VGND VPWR VPWR _0015_ sky130_fd_sc_hd__nor2_1
XTAP_TAPCELL_ROW_79_844 VGND VPWR sky130_fd_sc_hd__tapvpwrvgnd_1
XFILLER_0_3_15 VPWR VGND VPWR VGND sky130_ef_sc_hd__decap_12
X_4060_ _1280_ _1281_ VGND VGND VPWR VPWR _1282_ sky130_fd_sc_hd__xnor2_1
X_3011_ _0226_ _0229_ _0267_ VGND VGND VPWR VPWR _0268_ sky130_fd_sc_hd__o21a_1
XTAP_TAPCELL_ROW_62_700 VGND VPWR sky130_fd_sc_hd__tapvpwrvgnd_1
X_3913_ _1135_ _1137_ VGND VGND VPWR VPWR _1138_ sky130_fd_sc_hd__xor2_1
XFILLER_0_80_77 VGND VGND VPWR VPWR sky130_fd_sc_hd__decap_6
XTAP_TAPCELL_ROW_34_468 VGND VPWR sky130_fd_sc_hd__tapvpwrvgnd_1
X_3844_ _1014_ _1017_ VGND VGND VPWR VPWR _1071_ sky130_fd_sc_hd__nor2_1
XFILLER_0_58_197 VGND VGND VPWR VPWR sky130_fd_sc_hd__decap_6
XFILLER_0_73_145 VGND VGND VPWR VPWR sky130_fd_sc_hd__fill_2
X_3775_ _0468_ u_interface.u_compute_core.relu_data\[12\] _0958_ VGND VGND VPWR VPWR
+ _1003_ sky130_fd_sc_hd__and3_1
X_2726_ _2128_ _2129_ _2133_ VGND VGND VPWR VPWR _2134_ sky130_fd_sc_hd__o21ai_1
X_2657_ _2073_ _2074_ VGND VGND VPWR VPWR _2075_ sky130_fd_sc_hd__nand2_1
XFILLER_0_1_161 VGND VGND VPWR VPWR sky130_fd_sc_hd__decap_6
XFILLER_0_66_3 VPWR VGND VPWR VGND sky130_ef_sc_hd__decap_12
X_2588_ u_interface.u_compute_core.u_mac.product_reg\[7\] u_interface.u_compute_core.mac_accum\[7\]
+ VGND VGND VPWR VPWR _2015_ sky130_fd_sc_hd__or2_1
X_4327_ _1538_ _1543_ VGND VGND VPWR VPWR _1544_ sky130_fd_sc_hd__xnor2_1
X_4258_ _0454_ _0439_ u_interface.u_compute_core.relu_data\[23\] _1877_ VGND VGND
+ VPWR VPWR _1476_ sky130_fd_sc_hd__and4_1
X_3209_ _0435_ _0451_ VGND VGND VPWR VPWR _0452_ sky130_fd_sc_hd__or2_1
X_4189_ _1406_ _1407_ VGND VGND VPWR VPWR _1409_ sky130_fd_sc_hd__nand2_1
XFILLER_0_37_315 VPWR VGND VPWR VGND sky130_ef_sc_hd__decap_12
XFILLER_0_9_250 VPWR VGND VPWR VGND sky130_ef_sc_hd__decap_12
XFILLER_0_49_186 VPWR VGND VPWR VGND sky130_ef_sc_hd__decap_12
XFILLER_0_45_370 VGND VGND VPWR VPWR sky130_fd_sc_hd__decap_6
XFILLER_0_60_362 VGND VGND VPWR VPWR sky130_fd_sc_hd__fill_2
XFILLER_0_18_27 VGND VGND VPWR VPWR sky130_fd_sc_hd__fill_1
XTAP_TAPCELL_ROW_76_825 VGND VPWR sky130_fd_sc_hd__tapvpwrvgnd_1
XPHY_EDGE_ROW_16_Right_16 VGND VGND VPWR VPWR sky130_fd_sc_hd__decap_3
XFILLER_0_34_48 VGND VGND VPWR VPWR sky130_fd_sc_hd__decap_4
XTAP_TAPCELL_ROW_31_438 VGND VPWR sky130_fd_sc_hd__tapvpwrvgnd_1
X_3560_ _0744_ _0746_ VGND VGND VPWR VPWR _0793_ sky130_fd_sc_hd__nor2_1
XPHY_EDGE_ROW_25_Right_25 VGND VGND VPWR VPWR sky130_fd_sc_hd__decap_3
XFILLER_0_36_392 VGND VGND VPWR VPWR sky130_fd_sc_hd__fill_2
X_2511_ _1952_ VGND VGND VPWR VPWR _0051_ sky130_fd_sc_hd__clkbuf_1
X_3491_ _0511_ _1832_ _1829_ _0680_ VGND VGND VPWR VPWR _0725_ sky130_fd_sc_hd__a22oi_1
XFILLER_0_51_384 VGND VGND VPWR VPWR sky130_fd_sc_hd__fill_1
X_2442_ u_interface.u_compute_core.scaled_data\[1\] u_interface.u_compute_core.mac_accum\[4\]
+ _1900_ VGND VGND VPWR VPWR _1905_ sky130_fd_sc_hd__mux2_1
X_2373_ u_interface.u_compute_core.scaled_data\[11\] _1849_ _1854_ _1843_ VGND VGND
+ VPWR VPWR _1855_ sky130_fd_sc_hd__o2bb2a_1
XFILLER_0_52_9 VGND VGND VPWR VPWR sky130_fd_sc_hd__fill_1
XFILLER_0_75_55 VGND VGND VPWR VPWR sky130_fd_sc_hd__fill_1
X_4112_ _1331_ _1332_ VGND VGND VPWR VPWR _1333_ sky130_fd_sc_hd__nor2_1
XTAP_TAPCELL_ROW_39_505 VGND VPWR sky130_fd_sc_hd__tapvpwrvgnd_1
X_4043_ _1215_ _1264_ VGND VGND VPWR VPWR _1266_ sky130_fd_sc_hd__nor2_1
XPHY_EDGE_ROW_34_Right_34 VGND VGND VPWR VPWR sky130_fd_sc_hd__decap_3
XFILLER_0_74_421 VPWR VGND VPWR VGND sky130_ef_sc_hd__decap_12
XFILLER_0_19_337 VGND VGND VPWR VPWR sky130_fd_sc_hd__decap_6
XFILLER_0_19_348 VGND VGND VPWR VPWR sky130_fd_sc_hd__decap_4
XFILLER_0_24_70 VGND VGND VPWR VPWR sky130_fd_sc_hd__decap_6
XFILLER_0_46_134 VGND VGND VPWR VPWR sky130_fd_sc_hd__decap_6
XFILLER_0_46_156 VGND VGND VPWR VPWR sky130_fd_sc_hd__fill_1
XFILLER_0_6_253 VPWR VGND VPWR VGND sky130_ef_sc_hd__decap_12
XPHY_EDGE_ROW_43_Right_43 VGND VGND VPWR VPWR sky130_fd_sc_hd__decap_3
X_3827_ _0445_ u_interface.u_compute_core.relu_data\[12\] _1853_ _0449_ VGND VGND
+ VPWR VPWR _1054_ sky130_fd_sc_hd__a22oi_1
X_3758_ _0899_ _0950_ _0985_ VGND VGND VPWR VPWR _0986_ sky130_fd_sc_hd__a21o_1
X_2709_ _2066_ u_interface.u_compute_core.mac_accum\[24\] VGND VGND VPWR VPWR _2119_
+ sky130_fd_sc_hd__or2_1
X_3689_ _0916_ _0918_ VGND VGND VPWR VPWR _0919_ sky130_fd_sc_hd__xnor2_2
XFILLER_0_42_395 VGND VGND VPWR VPWR sky130_fd_sc_hd__fill_1
XFILLER_0_10_270 VGND VGND VPWR VPWR sky130_fd_sc_hd__decap_8
XPHY_EDGE_ROW_52_Right_52 VGND VGND VPWR VPWR sky130_fd_sc_hd__decap_3
XTAP_TAPCELL_ROW_2_196 VGND VPWR sky130_fd_sc_hd__tapvpwrvgnd_1
XTAP_TAPCELL_ROW_81_872 VGND VPWR sky130_fd_sc_hd__tapvpwrvgnd_1
XTAP_TAPCELL_ROW_81_861 VGND VPWR sky130_fd_sc_hd__tapvpwrvgnd_1
XFILLER_0_77_281 VGND VGND VPWR VPWR sky130_fd_sc_hd__decap_4
XPHY_EDGE_ROW_61_Right_61 VGND VGND VPWR VPWR sky130_fd_sc_hd__decap_3
XFILLER_0_65_465 VPWR VGND VPWR VGND sky130_ef_sc_hd__decap_12
XPHY_EDGE_ROW_70_Right_70 VGND VGND VPWR VPWR sky130_fd_sc_hd__decap_3
XFILLER_0_45_36 VGND VGND VPWR VPWR sky130_fd_sc_hd__decap_4
XFILLER_0_75_207 VGND VGND VPWR VPWR sky130_fd_sc_hd__fill_2
XFILLER_0_0_27 VGND VGND VPWR VPWR sky130_fd_sc_hd__fill_1
X_2991_ _0243_ _0244_ _0248_ VGND VGND VPWR VPWR _0249_ sky130_fd_sc_hd__nand3_1
XTAP_TAPCELL_ROW_44_552 VGND VPWR sky130_fd_sc_hd__tapvpwrvgnd_1
XFILLER_0_56_410 VGND VGND VPWR VPWR sky130_fd_sc_hd__fill_1
XFILLER_0_61_57 VGND VGND VPWR VPWR sky130_fd_sc_hd__fill_2
XFILLER_0_28_134 VGND VGND VPWR VPWR sky130_fd_sc_hd__decap_6
X_4730_ clknet_4_3_0_clk _0095_ VGND VGND VPWR VPWR u_interface.u_compute_core.u_mac.product_reg\[4\]
+ sky130_fd_sc_hd__dfxtp_1
X_4661_ clknet_4_7_0_clk _0026_ VGND VGND VPWR VPWR u_interface.u_compute_core.relu_data\[26\]
+ sky130_fd_sc_hd__dfxtp_2
X_3612_ _0842_ _0843_ VGND VGND VPWR VPWR _0844_ sky130_fd_sc_hd__xnor2_1
XFILLER_0_43_137 VPWR VGND VPWR VGND sky130_ef_sc_hd__decap_12
XFILLER_0_71_479 VGND VGND VPWR VPWR sky130_fd_sc_hd__fill_1
XFILLER_0_3_223 VGND VGND VPWR VPWR sky130_fd_sc_hd__fill_1
X_4592_ u_interface.core_valid_out VGND VGND VPWR VPWR _1782_ sky130_fd_sc_hd__clkbuf_4
X_3543_ u_interface.u_compute_core.relu_data\[4\] _0596_ VGND VGND VPWR VPWR _0776_
+ sky130_fd_sc_hd__and2b_1
XFILLER_0_51_181 VGND VGND VPWR VPWR sky130_fd_sc_hd__fill_1
X_3474_ _0708_ u_interface.core_attn_out\[6\] VGND VGND VPWR VPWR _0709_ sky130_fd_sc_hd__xor2_1
X_2425_ u_interface.u_compute_core.relu_data\[25\] VGND VGND VPWR VPWR _1893_ sky130_fd_sc_hd__buf_2
XFILLER_0_19_81 VPWR VGND VPWR VGND sky130_ef_sc_hd__decap_12
X_2356_ u_interface.u_compute_core.relu_data\[8\] VGND VGND VPWR VPWR _1841_ sky130_fd_sc_hd__clkbuf_4
XFILLER_0_29_3 VGND VGND VPWR VPWR sky130_fd_sc_hd__decap_4
X_4026_ _1248_ VGND VGND VPWR VPWR _1249_ sky130_fd_sc_hd__inv_2
XFILLER_0_47_432 VGND VGND VPWR VPWR sky130_fd_sc_hd__decap_4
XFILLER_0_59_281 VGND VGND VPWR VPWR sky130_fd_sc_hd__decap_4
XFILLER_0_34_137 VGND VGND VPWR VPWR sky130_fd_sc_hd__decap_3
XTAP_TAPCELL_ROW_50_599 VGND VPWR sky130_fd_sc_hd__tapvpwrvgnd_1
XFILLER_0_15_384 VGND VGND VPWR VPWR sky130_fd_sc_hd__decap_8
XFILLER_0_15_373 VGND VGND VPWR VPWR sky130_fd_sc_hd__decap_4
XFILLER_0_30_365 VPWR VGND VPWR VGND sky130_ef_sc_hd__decap_12
XTAP_TAPCELL_ROW_7_233 VGND VPWR sky130_fd_sc_hd__tapvpwrvgnd_1
XTAP_TAPCELL_ROW_58_666 VGND VPWR sky130_fd_sc_hd__tapvpwrvgnd_1
XTAP_TAPCELL_ROW_41_522 VGND VPWR sky130_fd_sc_hd__tapvpwrvgnd_1
XFILLER_0_31_38 VGND VGND VPWR VPWR sky130_fd_sc_hd__fill_2
XFILLER_0_65_262 VPWR VGND VPWR VGND sky130_ef_sc_hd__decap_12
XFILLER_0_33_181 VGND VGND VPWR VPWR sky130_fd_sc_hd__decap_3
XFILLER_0_0_237 VPWR VGND VPWR VGND sky130_ef_sc_hd__decap_12
XFILLER_0_21_343 VPWR VGND VPWR VGND sky130_ef_sc_hd__decap_12
XFILLER_0_21_387 VGND VGND VPWR VPWR sky130_fd_sc_hd__decap_4
X_3190_ u_interface.u_compute_core.u_av.v_extended\[3\] VGND VGND VPWR VPWR _0436_
+ sky130_fd_sc_hd__buf_6
X_2974_ _0186_ _0188_ _0230_ VGND VGND VPWR VPWR _0232_ sky130_fd_sc_hd__or3_1
X_4713_ clknet_4_4_0_clk _0078_ VGND VGND VPWR VPWR u_interface.u_compute_core.mac_accum\[19\]
+ sky130_fd_sc_hd__dfxtp_1
XFILLER_0_71_232 VPWR VGND VPWR VGND sky130_ef_sc_hd__decap_12
XFILLER_0_71_254 VGND VGND VPWR VPWR sky130_fd_sc_hd__decap_4
X_4644_ clknet_4_8_0_clk _0009_ VGND VGND VPWR VPWR u_interface.u_compute_core.relu_data\[9\]
+ sky130_fd_sc_hd__dfxtp_2
XFILLER_0_21_93 VGND VGND VPWR VPWR sky130_fd_sc_hd__decap_4
XFILLER_0_31_129 VGND VGND VPWR VPWR sky130_fd_sc_hd__fill_1
X_4575_ _1770_ VGND VGND VPWR VPWR _0162_ sky130_fd_sc_hd__clkbuf_1
X_3526_ _0753_ _0756_ _0752_ VGND VGND VPWR VPWR _0759_ sky130_fd_sc_hd__a21oi_2
XFILLER_0_12_387 VPWR VGND VPWR VGND sky130_ef_sc_hd__decap_12
XFILLER_0_12_365 VGND VGND VPWR VPWR sky130_fd_sc_hd__decap_6
X_3457_ _0691_ _0688_ VGND VGND VPWR VPWR _0692_ sky130_fd_sc_hd__xor2_2
X_3388_ _0585_ _0586_ VGND VGND VPWR VPWR _0624_ sky130_fd_sc_hd__or2_1
XTAP_TAPCELL_ROW_4_214 VGND VPWR sky130_fd_sc_hd__tapvpwrvgnd_1
X_2408_ u_interface.u_compute_core.scaled_data\[20\] _1814_ _1880_ _1816_ VGND VGND
+ VPWR VPWR _1881_ sky130_fd_sc_hd__o2bb2a_1
X_2339_ _1820_ _1828_ VGND VGND VPWR VPWR _0003_ sky130_fd_sc_hd__nor2_1
XPHY_EDGE_ROW_2_Right_2 VGND VGND VPWR VPWR sky130_fd_sc_hd__decap_3
X_4009_ _1230_ _1231_ VGND VGND VPWR VPWR _1232_ sky130_fd_sc_hd__xnor2_1
XTAP_TAPCELL_ROW_55_647 VGND VPWR sky130_fd_sc_hd__tapvpwrvgnd_1
XFILLER_0_39_229 VGND VGND VPWR VPWR sky130_fd_sc_hd__fill_1
XFILLER_0_35_402 VPWR VGND VPWR VGND sky130_ef_sc_hd__decap_12
XFILLER_0_35_479 VGND VGND VPWR VPWR sky130_fd_sc_hd__decap_4
XFILLER_0_50_405 VGND VGND VPWR VPWR sky130_fd_sc_hd__decap_8
XFILLER_0_50_438 VGND VGND VPWR VPWR sky130_fd_sc_hd__decap_3
XFILLER_0_50_449 VGND VGND VPWR VPWR sky130_fd_sc_hd__fill_2
XFILLER_0_62_298 VGND VGND VPWR VPWR sky130_fd_sc_hd__decap_6
Xhold50 u_interface.u_compute_core.mac_accum\[14\] VGND VGND VPWR VPWR net114 sky130_fd_sc_hd__dlygate4sd3_1
Xhold72 u_interface.core_attn_out\[26\] VGND VGND VPWR VPWR net136 sky130_fd_sc_hd__dlygate4sd3_1
XFILLER_0_26_27 VGND VGND VPWR VPWR sky130_fd_sc_hd__fill_1
Xhold83 u_interface.u_compute_core.u_mac.product_reg\[14\] VGND VGND VPWR VPWR net147
+ sky130_fd_sc_hd__dlygate4sd3_1
Xhold61 u_interface.core_attn_out\[23\] VGND VGND VPWR VPWR net125 sky130_fd_sc_hd__dlygate4sd3_1
XTAP_TAPCELL_ROW_18_327 VGND VPWR sky130_fd_sc_hd__tapvpwrvgnd_1
XTAP_TAPCELL_ROW_26_393 VGND VPWR sky130_fd_sc_hd__tapvpwrvgnd_1
XFILLER_0_38_251 VGND VGND VPWR VPWR sky130_fd_sc_hd__fill_1
XFILLER_0_26_446 VGND VGND VPWR VPWR sky130_fd_sc_hd__decap_3
XFILLER_0_53_232 VPWR VGND VPWR VGND sky130_ef_sc_hd__decap_12
XFILLER_0_41_405 VGND VGND VPWR VPWR sky130_fd_sc_hd__decap_4
X_2690_ _2101_ _2102_ VGND VGND VPWR VPWR _2103_ sky130_fd_sc_hd__or2_1
XANTENNA_3 clknet_4_12_0_clk VGND VGND VPWR VPWR sky130_fd_sc_hd__diode_2
XFILLER_0_6_15 VPWR VGND VPWR VGND sky130_ef_sc_hd__decap_12
X_4360_ _1464_ _1514_ _1574_ _1575_ VGND VGND VPWR VPWR _1576_ sky130_fd_sc_hd__a31o_1
X_3311_ _0542_ _0547_ VGND VGND VPWR VPWR _0549_ sky130_fd_sc_hd__and2b_1
XFILLER_0_6_37 VGND VGND VPWR VPWR sky130_fd_sc_hd__decap_6
XFILLER_0_21_195 VGND VGND VPWR VPWR sky130_fd_sc_hd__decap_4
X_4291_ _1506_ _1507_ VGND VGND VPWR VPWR _1509_ sky130_fd_sc_hd__nand2_1
X_3242_ _0466_ _0470_ VGND VGND VPWR VPWR _0482_ sky130_fd_sc_hd__nor2_1
X_3173_ u_interface.u_compute_core.u_av.v_extended\[0\] VGND VGND VPWR VPWR _0422_
+ sky130_fd_sc_hd__buf_2
Xrebuffer15 _0829_ VGND VGND VPWR VPWR net79 sky130_fd_sc_hd__buf_6
XFILLER_0_16_82 VGND VGND VPWR VPWR sky130_fd_sc_hd__fill_2
XTAP_TAPCELL_ROW_52_617 VGND VPWR sky130_fd_sc_hd__tapvpwrvgnd_1
XFILLER_0_29_240 VPWR VGND VPWR VGND sky130_ef_sc_hd__decap_12
X_2957_ _2305_ _2307_ VGND VGND VPWR VPWR _0216_ sky130_fd_sc_hd__and2b_1
XTAP_TAPCELL_ROW_60_683 VGND VPWR sky130_fd_sc_hd__tapvpwrvgnd_1
XFILLER_0_8_189 VGND VGND VPWR VPWR sky130_fd_sc_hd__decap_6
X_2888_ _2282_ VGND VGND VPWR VPWR _2283_ sky130_fd_sc_hd__inv_2
X_4627_ _1901_ _1805_ VGND VGND VPWR VPWR _1806_ sky130_fd_sc_hd__and2_1
XFILLER_0_32_449 VGND VGND VPWR VPWR sky130_fd_sc_hd__decap_6
X_4558_ _1753_ _1758_ VGND VGND VPWR VPWR _1759_ sky130_fd_sc_hd__and2_1
X_4489_ _1682_ _1683_ net75 VGND VGND VPWR VPWR _1702_ sky130_fd_sc_hd__o21ai_4
XFILLER_0_12_195 VGND VGND VPWR VPWR sky130_fd_sc_hd__fill_1
X_3509_ _0742_ _0740_ VGND VGND VPWR VPWR _0743_ sky130_fd_sc_hd__xnor2_2
XTAP_TAPCELL_ROW_68_750 VGND VPWR sky130_fd_sc_hd__tapvpwrvgnd_1
XFILLER_0_67_357 VGND VGND VPWR VPWR sky130_fd_sc_hd__fill_1
XTAP_TAPCELL_ROW_23_374 VGND VPWR sky130_fd_sc_hd__tapvpwrvgnd_1
XFILLER_0_23_427 VGND VGND VPWR VPWR sky130_fd_sc_hd__fill_1
XFILLER_0_23_449 VGND VGND VPWR VPWR sky130_fd_sc_hd__decap_3
XFILLER_0_50_268 VGND VGND VPWR VPWR sky130_fd_sc_hd__decap_3
Xoutput51 net51 VGND VGND VPWR VPWR m_tdata[2] sky130_fd_sc_hd__buf_2
Xoutput40 net40 VGND VGND VPWR VPWR m_tdata[1] sky130_fd_sc_hd__buf_2
Xoutput62 net62 VGND VGND VPWR VPWR s_tready sky130_fd_sc_hd__buf_2
X_3860_ _0989_ _1044_ _1085_ VGND VGND VPWR VPWR _1086_ sky130_fd_sc_hd__a21bo_1
XFILLER_0_73_349 VGND VGND VPWR VPWR sky130_fd_sc_hd__decap_6
X_2811_ _2207_ _2208_ VGND VGND VPWR VPWR _2209_ sky130_fd_sc_hd__xnor2_1
X_3791_ _0974_ _0927_ VGND VGND VPWR VPWR _1019_ sky130_fd_sc_hd__and2_1
XFILLER_0_5_137 VPWR VGND VPWR VGND sky130_ef_sc_hd__decap_12
X_2742_ _2068_ u_interface.u_compute_core.mac_accum\[29\] VGND VGND VPWR VPWR _2147_
+ sky130_fd_sc_hd__nand2_1
XFILLER_0_81_393 VPWR VGND VPWR VGND sky130_ef_sc_hd__decap_12
X_4412_ _0451_ _1887_ VGND VGND VPWR VPWR _1627_ sky130_fd_sc_hd__nand2_1
XFILLER_0_41_257 VGND VGND VPWR VPWR sky130_fd_sc_hd__decap_4
X_2673_ _2087_ _2083_ _2084_ VGND VGND VPWR VPWR _2089_ sky130_fd_sc_hd__nand3_1
XFILLER_0_78_77 VGND VGND VPWR VPWR sky130_fd_sc_hd__decap_6
X_4343_ _1493_ _1496_ _1497_ _1501_ VGND VGND VPWR VPWR _1560_ sky130_fd_sc_hd__o31a_1
X_4274_ _1489_ _1491_ VGND VGND VPWR VPWR _1492_ sky130_fd_sc_hd__xnor2_1
X_3225_ _0464_ _0465_ VGND VGND VPWR VPWR _0466_ sky130_fd_sc_hd__or2_1
X_3156_ _0387_ _0390_ _0407_ VGND VGND VPWR VPWR _0409_ sky130_fd_sc_hd__o21ai_1
X_3087_ _0308_ _0341_ VGND VGND VPWR VPWR _0342_ sky130_fd_sc_hd__xnor2_1
XTAP_TAPCELL_ROW_65_731 VGND VPWR sky130_fd_sc_hd__tapvpwrvgnd_1
XFILLER_0_11_3 VGND VGND VPWR VPWR sky130_fd_sc_hd__decap_8
XFILLER_0_76_121 VPWR VGND VPWR VGND sky130_ef_sc_hd__decap_12
XTAP_TAPCELL_ROW_37_488 VGND VPWR sky130_fd_sc_hd__tapvpwrvgnd_1
XFILLER_0_76_165 VGND VGND VPWR VPWR sky130_fd_sc_hd__decap_3
XFILLER_0_64_305 VGND VGND VPWR VPWR sky130_fd_sc_hd__decap_3
XFILLER_0_76_187 VGND VGND VPWR VPWR sky130_fd_sc_hd__decap_8
XFILLER_0_17_210 VGND VGND VPWR VPWR sky130_fd_sc_hd__decap_3
XFILLER_0_9_465 VGND VGND VPWR VPWR sky130_fd_sc_hd__fill_2
X_3989_ _1210_ _1212_ VGND VGND VPWR VPWR _1213_ sky130_fd_sc_hd__or2_1
XTAP_TAPCELL_ROW_20_344 VGND VPWR sky130_fd_sc_hd__tapvpwrvgnd_1
XFILLER_0_20_408 VGND VGND VPWR VPWR sky130_fd_sc_hd__decap_3
XFILLER_0_13_482 VGND VGND VPWR VPWR sky130_fd_sc_hd__fill_2
Xclkbuf_4_13_0_clk clknet_0_clk VGND VGND VPWR VPWR clknet_4_13_0_clk sky130_fd_sc_hd__clkbuf_8
XTAP_TAPCELL_ROW_28_411 VGND VPWR sky130_fd_sc_hd__tapvpwrvgnd_1
XFILLER_0_67_121 VGND VGND VPWR VPWR sky130_fd_sc_hd__fill_2
XTAP_TAPCELL_ROW_71_778 VGND VPWR sky130_fd_sc_hd__tapvpwrvgnd_1
XFILLER_0_67_187 VPWR VGND VPWR VGND sky130_ef_sc_hd__decap_12
Xrebuffer6 _0878_ VGND VGND VPWR VPWR net70 sky130_fd_sc_hd__dlygate4sd1_1
XFILLER_0_63_393 VGND VGND VPWR VPWR sky130_fd_sc_hd__decap_8
XTAP_TAPCELL_ROW_79_845 VGND VPWR sky130_fd_sc_hd__tapvpwrvgnd_1
XFILLER_0_3_27 VPWR VGND VPWR VGND sky130_ef_sc_hd__decap_12
X_3010_ _0265_ _0266_ VGND VGND VPWR VPWR _0267_ sky130_fd_sc_hd__nor2_1
XTAP_TAPCELL_ROW_62_701 VGND VPWR sky130_fd_sc_hd__tapvpwrvgnd_1
XFILLER_0_46_305 VGND VGND VPWR VPWR sky130_fd_sc_hd__decap_3
X_3912_ _0442_ _1862_ _1089_ _1136_ VGND VGND VPWR VPWR _1137_ sky130_fd_sc_hd__a31o_1
XFILLER_0_58_154 VGND VGND VPWR VPWR sky130_fd_sc_hd__fill_1
XFILLER_0_58_176 VGND VGND VPWR VPWR sky130_fd_sc_hd__fill_2
XFILLER_0_73_113 VGND VGND VPWR VPWR sky130_fd_sc_hd__fill_2
XTAP_TAPCELL_ROW_34_469 VGND VPWR sky130_fd_sc_hd__tapvpwrvgnd_1
X_3843_ _1068_ _1069_ VGND VGND VPWR VPWR _1070_ sky130_fd_sc_hd__or2_4
XFILLER_0_39_390 VGND VGND VPWR VPWR sky130_fd_sc_hd__fill_2
X_3774_ _1000_ _1001_ VGND VGND VPWR VPWR _1002_ sky130_fd_sc_hd__xnor2_1
X_2725_ _2132_ VGND VGND VPWR VPWR _2133_ sky130_fd_sc_hd__inv_2
X_2656_ _2064_ u_interface.u_compute_core.mac_accum\[16\] VGND VGND VPWR VPWR _2074_
+ sky130_fd_sc_hd__nand2_1
XFILLER_0_10_452 VGND VGND VPWR VPWR sky130_fd_sc_hd__fill_2
X_2587_ u_interface.u_compute_core.u_mac.product_reg\[7\] u_interface.u_compute_core.mac_accum\[7\]
+ VGND VGND VPWR VPWR _2014_ sky130_fd_sc_hd__nand2_1
XFILLER_0_59_3 VPWR VGND VPWR VGND sky130_ef_sc_hd__decap_12
X_4326_ _1541_ _1542_ VGND VGND VPWR VPWR _1543_ sky130_fd_sc_hd__xnor2_1
X_4257_ _1442_ _1450_ _1474_ VGND VGND VPWR VPWR _1475_ sky130_fd_sc_hd__o21a_1
X_4188_ _1406_ _1407_ VGND VGND VPWR VPWR _1408_ sky130_fd_sc_hd__or2_1
X_3208_ _0450_ VGND VGND VPWR VPWR _0451_ sky130_fd_sc_hd__clkbuf_4
X_3139_ _2275_ _2294_ VGND VGND VPWR VPWR _0392_ sky130_fd_sc_hd__or2_1
XFILLER_0_69_408 VPWR VGND VPWR VGND sky130_ef_sc_hd__decap_12
XFILLER_0_49_121 VGND VGND VPWR VPWR sky130_fd_sc_hd__fill_2
XFILLER_0_37_327 VGND VGND VPWR VPWR sky130_fd_sc_hd__decap_8
XFILLER_0_49_198 VGND VGND VPWR VPWR sky130_fd_sc_hd__decap_8
XFILLER_0_9_262 VGND VGND VPWR VPWR sky130_fd_sc_hd__fill_2
XFILLER_0_64_157 VGND VGND VPWR VPWR sky130_fd_sc_hd__decap_4
XFILLER_0_20_216 VGND VGND VPWR VPWR sky130_fd_sc_hd__fill_1
XFILLER_0_60_396 VPWR VGND VPWR VGND sky130_ef_sc_hd__decap_12
XFILLER_0_0_3 VPWR VGND VPWR VGND sky130_ef_sc_hd__decap_12
XTAP_TAPCELL_ROW_76_826 VGND VPWR sky130_fd_sc_hd__tapvpwrvgnd_1
XFILLER_0_34_27 VGND VGND VPWR VPWR sky130_fd_sc_hd__fill_1
XFILLER_0_50_15 VGND VGND VPWR VPWR sky130_fd_sc_hd__decap_8
XTAP_TAPCELL_ROW_31_439 VGND VPWR sky130_fd_sc_hd__tapvpwrvgnd_1
XFILLER_0_43_308 VGND VGND VPWR VPWR sky130_fd_sc_hd__fill_1
XFILLER_0_3_405 VPWR VGND VPWR VGND sky130_ef_sc_hd__decap_12
XFILLER_0_36_382 VGND VGND VPWR VPWR sky130_fd_sc_hd__decap_3
XFILLER_0_70_138 VGND VGND VPWR VPWR sky130_fd_sc_hd__fill_2
XFILLER_0_3_449 VPWR VGND VPWR VGND sky130_ef_sc_hd__decap_12
X_3490_ _0551_ _0634_ u_interface.u_compute_core.relu_data\[5\] u_interface.u_compute_core.relu_data\[4\]
+ VGND VGND VPWR VPWR _0724_ sky130_fd_sc_hd__and4_1
X_2510_ _1931_ _1951_ VGND VGND VPWR VPWR _1952_ sky130_fd_sc_hd__and2_1
X_2441_ _1904_ VGND VGND VPWR VPWR _0029_ sky130_fd_sc_hd__clkbuf_1
X_2372_ _1853_ VGND VGND VPWR VPWR _1854_ sky130_fd_sc_hd__inv_2
X_4111_ _1330_ _1325_ VGND VGND VPWR VPWR _1332_ sky130_fd_sc_hd__nor2b_1
XTAP_TAPCELL_ROW_39_506 VGND VPWR sky130_fd_sc_hd__tapvpwrvgnd_1
X_4042_ _1213_ _1264_ VGND VGND VPWR VPWR _1265_ sky130_fd_sc_hd__and2_1
XFILLER_0_78_227 VGND VGND VPWR VPWR sky130_fd_sc_hd__decap_8
XFILLER_0_78_205 VGND VGND VPWR VPWR sky130_fd_sc_hd__decap_3
XTAP_TAPCELL_ROW_47_572 VGND VPWR sky130_fd_sc_hd__tapvpwrvgnd_1
XFILLER_0_74_433 VGND VGND VPWR VPWR sky130_fd_sc_hd__decap_8
XFILLER_0_74_477 VGND VGND VPWR VPWR sky130_fd_sc_hd__decap_6
XFILLER_0_6_221 VGND VGND VPWR VPWR sky130_fd_sc_hd__fill_2
X_3826_ _1050_ _1052_ VGND VGND VPWR VPWR _1053_ sky130_fd_sc_hd__xor2_1
XFILLER_0_46_168 VPWR VGND VPWR VGND sky130_ef_sc_hd__decap_12
XFILLER_0_6_265 VGND VGND VPWR VPWR sky130_fd_sc_hd__fill_1
X_3757_ _0949_ _0946_ VGND VGND VPWR VPWR _0985_ sky130_fd_sc_hd__and2b_1
XFILLER_0_42_363 VGND VGND VPWR VPWR sky130_fd_sc_hd__fill_1
X_2708_ u_interface.u_compute_core.mac_accum\[23\] u_interface.u_compute_core.mac_accum\[22\]
+ u_interface.u_compute_core.mac_accum\[21\] u_interface.u_compute_core.mac_accum\[20\]
+ _2066_ VGND VGND VPWR VPWR _2118_ sky130_fd_sc_hd__o41a_1
X_3688_ _0858_ _0866_ _0917_ VGND VGND VPWR VPWR _0918_ sky130_fd_sc_hd__a21oi_2
X_2639_ _2057_ _2058_ VGND VGND VPWR VPWR _2059_ sky130_fd_sc_hd__nand2_1
X_4309_ _1363_ _1468_ _1525_ VGND VGND VPWR VPWR _1526_ sky130_fd_sc_hd__nand3_1
XTAP_TAPCELL_ROW_2_197 VGND VPWR sky130_fd_sc_hd__tapvpwrvgnd_1
XFILLER_0_69_238 VPWR VGND VPWR VGND sky130_ef_sc_hd__decap_12
XTAP_TAPCELL_ROW_81_873 VGND VPWR sky130_fd_sc_hd__tapvpwrvgnd_1
XTAP_TAPCELL_ROW_81_862 VGND VPWR sky130_fd_sc_hd__tapvpwrvgnd_1
XFILLER_0_65_411 VPWR VGND VPWR VGND sky130_ef_sc_hd__decap_12
XFILLER_0_65_477 VGND VGND VPWR VPWR sky130_fd_sc_hd__decap_3
XFILLER_0_20_29 VPWR VGND VPWR VGND sky130_ef_sc_hd__decap_12
X_2990_ _0246_ _0247_ VGND VGND VPWR VPWR _0248_ sky130_fd_sc_hd__and2_1
XFILLER_0_28_124 VGND VGND VPWR VPWR sky130_fd_sc_hd__decap_3
XTAP_TAPCELL_ROW_44_553 VGND VPWR sky130_fd_sc_hd__tapvpwrvgnd_1
XFILLER_0_56_444 VGND VGND VPWR VPWR sky130_fd_sc_hd__decap_6
XFILLER_0_56_477 VGND VGND VPWR VPWR sky130_fd_sc_hd__decap_6
X_4660_ clknet_4_7_0_clk _0025_ VGND VGND VPWR VPWR u_interface.u_compute_core.relu_data\[25\]
+ sky130_fd_sc_hd__dfxtp_1
X_3611_ u_interface.core_attn_out\[8\] _0795_ _0797_ VGND VGND VPWR VPWR _0843_ sky130_fd_sc_hd__a21oi_1
XFILLER_0_43_149 VGND VGND VPWR VPWR sky130_fd_sc_hd__decap_8
X_4591_ _1781_ VGND VGND VPWR VPWR _0167_ sky130_fd_sc_hd__clkbuf_1
X_3542_ _0639_ _1838_ VGND VGND VPWR VPWR _0775_ sky130_fd_sc_hd__nand2_1
X_3473_ _0707_ _0706_ VGND VGND VPWR VPWR _0708_ sky130_fd_sc_hd__xnor2_1
XFILLER_0_3_279 VGND VGND VPWR VPWR sky130_fd_sc_hd__fill_1
X_2424_ _1879_ _1892_ VGND VGND VPWR VPWR _0024_ sky130_fd_sc_hd__nor2_1
X_2355_ _1820_ _1840_ VGND VGND VPWR VPWR _0007_ sky130_fd_sc_hd__nor2_1
XFILLER_0_19_93 VPWR VGND VPWR VGND sky130_ef_sc_hd__decap_12
X_4025_ _0426_ _0422_ u_interface.u_compute_core.relu_data\[21\] u_interface.u_compute_core.relu_data\[20\]
+ VGND VGND VPWR VPWR _1248_ sky130_fd_sc_hd__and4_1
XFILLER_0_59_271 VGND VGND VPWR VPWR sky130_fd_sc_hd__decap_8
XFILLER_0_19_135 VGND VGND VPWR VPWR sky130_fd_sc_hd__fill_2
XFILLER_0_34_149 VPWR VGND VPWR VGND sky130_ef_sc_hd__decap_12
X_3809_ _1012_ _1010_ VGND VGND VPWR VPWR _1036_ sky130_fd_sc_hd__or2b_1
X_4789_ clknet_4_11_0_clk _0154_ VGND VGND VPWR VPWR net55 sky130_fd_sc_hd__dfxtp_1
XFILLER_0_30_377 VGND VGND VPWR VPWR sky130_fd_sc_hd__decap_4
XTAP_TAPCELL_ROW_7_234 VGND VPWR sky130_fd_sc_hd__tapvpwrvgnd_1
XTAP_TAPCELL_ROW_58_667 VGND VPWR sky130_fd_sc_hd__tapvpwrvgnd_1
XFILLER_0_15_18 VPWR VGND VPWR VGND sky130_ef_sc_hd__decap_12
XFILLER_0_57_219 VGND VGND VPWR VPWR sky130_fd_sc_hd__decap_4
XFILLER_0_31_17 VGND VGND VPWR VPWR sky130_fd_sc_hd__decap_6
XTAP_TAPCELL_ROW_41_523 VGND VPWR sky130_fd_sc_hd__tapvpwrvgnd_1
XFILLER_0_38_466 VGND VGND VPWR VPWR sky130_fd_sc_hd__fill_1
XFILLER_0_38_477 VGND VGND VPWR VPWR sky130_fd_sc_hd__decap_6
XFILLER_0_53_403 VGND VGND VPWR VPWR sky130_fd_sc_hd__decap_6
XFILLER_0_0_216 VGND VGND VPWR VPWR sky130_fd_sc_hd__decap_8
XFILLER_0_21_355 VGND VGND VPWR VPWR sky130_fd_sc_hd__decap_3
XFILLER_0_0_249 VGND VGND VPWR VPWR sky130_fd_sc_hd__decap_3
XFILLER_0_29_411 VPWR VGND VPWR VGND sky130_ef_sc_hd__decap_12
XFILLER_0_48_219 VGND VGND VPWR VPWR sky130_fd_sc_hd__decap_8
X_2973_ _0186_ _0188_ _0230_ VGND VGND VPWR VPWR _0231_ sky130_fd_sc_hd__o21ai_1
X_4712_ clknet_4_4_0_clk _0077_ VGND VGND VPWR VPWR u_interface.u_compute_core.mac_accum\[18\]
+ sky130_fd_sc_hd__dfxtp_1
XFILLER_0_44_458 VGND VGND VPWR VPWR sky130_fd_sc_hd__fill_1
XFILLER_0_71_244 VGND VGND VPWR VPWR sky130_fd_sc_hd__decap_6
XTAP_TAPCELL_ROW_12_280 VGND VPWR sky130_fd_sc_hd__tapvpwrvgnd_1
X_4643_ clknet_4_8_0_clk _0008_ VGND VGND VPWR VPWR u_interface.u_compute_core.relu_data\[8\]
+ sky130_fd_sc_hd__dfxtp_2
X_4574_ _1753_ _1769_ VGND VGND VPWR VPWR _1770_ sky130_fd_sc_hd__and2_1
XFILLER_0_24_182 VGND VGND VPWR VPWR sky130_fd_sc_hd__fill_2
X_3525_ net137 _0715_ _0434_ _0758_ VGND VGND VPWR VPWR _0124_ sky130_fd_sc_hd__o211a_1
XFILLER_0_12_399 VPWR VGND VPWR VGND sky130_ef_sc_hd__decap_12
X_3456_ _0643_ _1829_ _0689_ _0690_ VGND VGND VPWR VPWR _0691_ sky130_fd_sc_hd__a31o_1
X_3387_ _0545_ _0589_ _0622_ VGND VGND VPWR VPWR _0623_ sky130_fd_sc_hd__a21o_1
XFILLER_0_41_3 VPWR VGND VPWR VGND sky130_ef_sc_hd__decap_12
X_2407_ u_interface.u_compute_core.relu_data\[20\] VGND VGND VPWR VPWR _1880_ sky130_fd_sc_hd__inv_2
X_2338_ u_interface.u_compute_core.scaled_data\[3\] _1815_ _1827_ _1817_ VGND VGND
+ VPWR VPWR _1828_ sky130_fd_sc_hd__o2bb2a_1
XFILLER_0_46_80 VGND VGND VPWR VPWR sky130_fd_sc_hd__decap_4
X_4008_ _0442_ _1871_ VGND VGND VPWR VPWR _1231_ sky130_fd_sc_hd__nand2_1
XFILLER_0_47_230 VPWR VGND VPWR VGND sky130_ef_sc_hd__decap_12
XFILLER_0_35_414 VGND VGND VPWR VPWR sky130_fd_sc_hd__decap_6
XFILLER_0_7_360 VGND VGND VPWR VPWR sky130_fd_sc_hd__decap_8
XFILLER_0_35_447 VGND VGND VPWR VPWR sky130_fd_sc_hd__fill_1
XFILLER_0_7_393 VPWR VGND VPWR VGND sky130_ef_sc_hd__decap_12
XFILLER_0_50_428 VGND VGND VPWR VPWR sky130_fd_sc_hd__fill_2
XFILLER_0_30_141 VGND VGND VPWR VPWR sky130_fd_sc_hd__decap_8
XFILLER_0_30_185 VGND VGND VPWR VPWR sky130_fd_sc_hd__decap_3
Xhold40 u_interface.u_compute_core.mac_accum\[3\] VGND VGND VPWR VPWR net104 sky130_fd_sc_hd__dlygate4sd3_1
Xhold73 u_interface.core_attn_out\[7\] VGND VGND VPWR VPWR net137 sky130_fd_sc_hd__dlygate4sd3_1
Xhold51 u_interface.u_compute_core.mac_accum\[12\] VGND VGND VPWR VPWR net115 sky130_fd_sc_hd__dlygate4sd3_1
Xhold62 u_interface.u_compute_core.mac_accum\[30\] VGND VGND VPWR VPWR net126 sky130_fd_sc_hd__dlygate4sd3_1
Xhold84 u_interface.u_compute_core.mac_accum\[9\] VGND VGND VPWR VPWR net148 sky130_fd_sc_hd__dlygate4sd3_1
XTAP_TAPCELL_ROW_18_328 VGND VPWR sky130_fd_sc_hd__tapvpwrvgnd_1
XTAP_TAPCELL_ROW_26_394 VGND VPWR sky130_fd_sc_hd__tapvpwrvgnd_1
XFILLER_0_53_244 VPWR VGND VPWR VGND sky130_ef_sc_hd__decap_12
XFILLER_0_13_108 VGND VGND VPWR VPWR sky130_fd_sc_hd__fill_1
XFILLER_0_41_428 VGND VGND VPWR VPWR sky130_fd_sc_hd__decap_4
XFILLER_0_53_277 VGND VGND VPWR VPWR sky130_fd_sc_hd__decap_3
X_3310_ _0492_ _0507_ _0547_ VGND VGND VPWR VPWR _0548_ sky130_fd_sc_hd__nor3_1
XFILLER_0_6_27 VGND VGND VPWR VPWR sky130_fd_sc_hd__fill_1
X_4290_ _1506_ _1507_ VGND VGND VPWR VPWR _1508_ sky130_fd_sc_hd__or2_1
X_3241_ u_interface.core_attn_out\[1\] VGND VGND VPWR VPWR _0481_ sky130_fd_sc_hd__inv_2
X_3172_ _1966_ VGND VGND VPWR VPWR _0421_ sky130_fd_sc_hd__clkbuf_4
Xrebuffer16 _0870_ VGND VGND VPWR VPWR net80 sky130_fd_sc_hd__dlymetal6s2s_1
XFILLER_0_16_72 VGND VGND VPWR VPWR sky130_fd_sc_hd__decap_3
XFILLER_0_76_347 VGND VGND VPWR VPWR sky130_fd_sc_hd__decap_3
XFILLER_0_76_336 VGND VGND VPWR VPWR sky130_fd_sc_hd__decap_6
XTAP_TAPCELL_ROW_52_618 VGND VPWR sky130_fd_sc_hd__tapvpwrvgnd_1
XFILLER_0_29_252 VPWR VGND VPWR VGND sky130_ef_sc_hd__decap_12
XFILLER_0_17_447 VGND VGND VPWR VPWR sky130_fd_sc_hd__fill_1
X_2956_ _0182_ _2303_ _0213_ VGND VGND VPWR VPWR _0215_ sky130_fd_sc_hd__and3_1
XFILLER_0_44_222 VGND VGND VPWR VPWR sky130_fd_sc_hd__decap_4
X_2887_ net12 net7 net9 VGND VGND VPWR VPWR _2282_ sky130_fd_sc_hd__and3_1
XTAP_TAPCELL_ROW_60_684 VGND VPWR sky130_fd_sc_hd__tapvpwrvgnd_1
X_4626_ net50 u_interface.core_attn_out\[29\] u_interface.core_valid_out VGND VGND
+ VPWR VPWR _1805_ sky130_fd_sc_hd__mux2_1
XFILLER_0_4_363 VGND VGND VPWR VPWR sky130_fd_sc_hd__fill_1
XFILLER_0_12_141 VGND VGND VPWR VPWR sky130_fd_sc_hd__fill_1
X_4557_ net58 u_interface.core_attn_out\[7\] _1742_ VGND VGND VPWR VPWR _1758_ sky130_fd_sc_hd__mux2_1
X_4488_ _1697_ _1700_ VGND VGND VPWR VPWR _1701_ sky130_fd_sc_hd__nand2_1
X_3508_ _0696_ _0677_ _0741_ VGND VGND VPWR VPWR _0742_ sky130_fd_sc_hd__o21a_1
XFILLER_0_40_483 VGND VGND VPWR VPWR sky130_fd_sc_hd__fill_1
X_3439_ _0633_ net64 _0673_ VGND VGND VPWR VPWR _0674_ sky130_fd_sc_hd__o21ba_1
XTAP_TAPCELL_ROW_68_751 VGND VPWR sky130_fd_sc_hd__tapvpwrvgnd_1
XTAP_TAPCELL_ROW_23_375 VGND VPWR sky130_fd_sc_hd__tapvpwrvgnd_1
XFILLER_0_35_244 VPWR VGND VPWR VGND sky130_ef_sc_hd__decap_12
Xoutput52 net52 VGND VGND VPWR VPWR m_tdata[30] sky130_fd_sc_hd__buf_2
Xoutput30 net30 VGND VGND VPWR VPWR m_tdata[10] sky130_fd_sc_hd__buf_2
Xoutput41 net41 VGND VGND VPWR VPWR m_tdata[20] sky130_fd_sc_hd__buf_2
XFILLER_0_37_38 VGND VGND VPWR VPWR sky130_fd_sc_hd__fill_1
XFILLER_0_53_15 VGND VGND VPWR VPWR sky130_fd_sc_hd__decap_4
X_2810_ _2185_ _2188_ VGND VGND VPWR VPWR _2208_ sky130_fd_sc_hd__nand2_1
X_3790_ _1014_ _1017_ VGND VGND VPWR VPWR _1018_ sky130_fd_sc_hd__xnor2_1
XFILLER_0_66_391 VPWR VGND VPWR VGND sky130_ef_sc_hd__decap_12
X_2741_ _2067_ u_interface.u_compute_core.mac_accum\[29\] VGND VGND VPWR VPWR _2146_
+ sky130_fd_sc_hd__or2_1
XFILLER_0_81_361 VGND VGND VPWR VPWR sky130_fd_sc_hd__decap_3
XFILLER_0_5_149 VPWR VGND VPWR VGND sky130_ef_sc_hd__decap_12
XFILLER_0_41_203 VGND VGND VPWR VPWR sky130_fd_sc_hd__fill_1
X_4411_ _1624_ _1625_ VGND VGND VPWR VPWR _1626_ sky130_fd_sc_hd__nor2_1
X_2672_ _2083_ _2084_ _2087_ VGND VGND VPWR VPWR _2088_ sky130_fd_sc_hd__a21o_1
X_4342_ _1557_ _1558_ VGND VGND VPWR VPWR _1559_ sky130_fd_sc_hd__nand2_1
X_4273_ _1432_ _1438_ _1490_ VGND VGND VPWR VPWR _1491_ sky130_fd_sc_hd__a21oi_1
X_3224_ _1824_ _0463_ _0461_ _0462_ VGND VGND VPWR VPWR _0465_ sky130_fd_sc_hd__o2bb2a_1
.ends
