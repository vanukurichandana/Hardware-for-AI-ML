* NGSPICE file created from top.ext - technology: sky130A

* Black-box entry subcircuit for sky130_fd_sc_hd__nor2_1 abstract view
.subckt sky130_fd_sc_hd__nor2_1 A B VGND VNB VPB VPWR Y
.ends

* Black-box entry subcircuit for sky130_fd_sc_hd__buf_2 abstract view
.subckt sky130_fd_sc_hd__buf_2 A VGND VNB VPB VPWR X
.ends

* Black-box entry subcircuit for sky130_ef_sc_hd__decap_12 abstract view
.subckt sky130_ef_sc_hd__decap_12 VPWR VGND VPB VNB
.ends

* Black-box entry subcircuit for sky130_fd_sc_hd__decap_4 abstract view
.subckt sky130_fd_sc_hd__decap_4 VGND VNB VPB VPWR
.ends

* Black-box entry subcircuit for sky130_fd_sc_hd__decap_3 abstract view
.subckt sky130_fd_sc_hd__decap_3 VGND VNB VPB VPWR
.ends

* Black-box entry subcircuit for sky130_fd_sc_hd__fill_2 abstract view
.subckt sky130_fd_sc_hd__fill_2 VGND VNB VPB VPWR
.ends

* Black-box entry subcircuit for sky130_fd_sc_hd__o211a_1 abstract view
.subckt sky130_fd_sc_hd__o211a_1 A1 A2 B1 C1 VGND VNB VPB VPWR X
.ends

* Black-box entry subcircuit for sky130_fd_sc_hd__fill_1 abstract view
.subckt sky130_fd_sc_hd__fill_1 VGND VNB VPB VPWR
.ends

* Black-box entry subcircuit for sky130_fd_sc_hd__mux2_1 abstract view
.subckt sky130_fd_sc_hd__mux2_1 A0 A1 S VGND VNB VPB VPWR X
.ends

* Black-box entry subcircuit for sky130_fd_sc_hd__tapvpwrvgnd_1 abstract view
.subckt sky130_fd_sc_hd__tapvpwrvgnd_1 VGND VPWR
.ends

* Black-box entry subcircuit for sky130_fd_sc_hd__and2_1 abstract view
.subckt sky130_fd_sc_hd__and2_1 A B VGND VNB VPB VPWR X
.ends

* Black-box entry subcircuit for sky130_fd_sc_hd__a21oi_1 abstract view
.subckt sky130_fd_sc_hd__a21oi_1 A1 A2 B1 VGND VNB VPB VPWR Y
.ends

* Black-box entry subcircuit for sky130_fd_sc_hd__decap_8 abstract view
.subckt sky130_fd_sc_hd__decap_8 VGND VNB VPB VPWR
.ends

* Black-box entry subcircuit for sky130_fd_sc_hd__dlygate4sd1_1 abstract view
.subckt sky130_fd_sc_hd__dlygate4sd1_1 A VGND VNB VPB VPWR X
.ends

* Black-box entry subcircuit for sky130_fd_sc_hd__decap_6 abstract view
.subckt sky130_fd_sc_hd__decap_6 VGND VNB VPB VPWR
.ends

* Black-box entry subcircuit for sky130_fd_sc_hd__nand3_1 abstract view
.subckt sky130_fd_sc_hd__nand3_1 A B C VGND VNB VPB VPWR Y
.ends

* Black-box entry subcircuit for sky130_fd_sc_hd__nand2_1 abstract view
.subckt sky130_fd_sc_hd__nand2_1 A B VGND VNB VPB VPWR Y
.ends

* Black-box entry subcircuit for sky130_fd_sc_hd__o21ba_1 abstract view
.subckt sky130_fd_sc_hd__o21ba_1 A1 A2 B1_N VGND VNB VPB VPWR X
.ends

* Black-box entry subcircuit for sky130_fd_sc_hd__xnor2_1 abstract view
.subckt sky130_fd_sc_hd__xnor2_1 A B VGND VNB VPB VPWR Y
.ends

* Black-box entry subcircuit for sky130_fd_sc_hd__nor3b_1 abstract view
.subckt sky130_fd_sc_hd__nor3b_1 A B C_N VGND VNB VPB VPWR Y
.ends

* Black-box entry subcircuit for sky130_fd_sc_hd__a211o_1 abstract view
.subckt sky130_fd_sc_hd__a211o_1 A1 A2 B1 C1 VGND VNB VPB VPWR X
.ends

* Black-box entry subcircuit for sky130_fd_sc_hd__clkbuf_4 abstract view
.subckt sky130_fd_sc_hd__clkbuf_4 A VGND VNB VPB VPWR X
.ends

* Black-box entry subcircuit for sky130_fd_sc_hd__clkbuf_1 abstract view
.subckt sky130_fd_sc_hd__clkbuf_1 A VGND VNB VPB VPWR X
.ends

* Black-box entry subcircuit for sky130_fd_sc_hd__nand3_2 abstract view
.subckt sky130_fd_sc_hd__nand3_2 A B C VGND VNB VPB VPWR Y
.ends

* Black-box entry subcircuit for sky130_fd_sc_hd__o2bb2a_1 abstract view
.subckt sky130_fd_sc_hd__o2bb2a_1 A1_N A2_N B1 B2 VGND VNB VPB VPWR X
.ends

* Black-box entry subcircuit for sky130_fd_sc_hd__a22oi_2 abstract view
.subckt sky130_fd_sc_hd__a22oi_2 A1 A2 B1 B2 VGND VNB VPB VPWR Y
.ends

* Black-box entry subcircuit for sky130_fd_sc_hd__xor2_1 abstract view
.subckt sky130_fd_sc_hd__xor2_1 A B VGND VNB VPB VPWR X
.ends

* Black-box entry subcircuit for sky130_fd_sc_hd__xnor2_4 abstract view
.subckt sky130_fd_sc_hd__xnor2_4 A B VGND VNB VPB VPWR Y
.ends

* Black-box entry subcircuit for sky130_fd_sc_hd__and3_1 abstract view
.subckt sky130_fd_sc_hd__and3_1 A B C VGND VNB VPB VPWR X
.ends

* Black-box entry subcircuit for sky130_fd_sc_hd__a21boi_1 abstract view
.subckt sky130_fd_sc_hd__a21boi_1 A1 A2 B1_N VGND VNB VPB VPWR Y
.ends

* Black-box entry subcircuit for sky130_fd_sc_hd__nand3_4 abstract view
.subckt sky130_fd_sc_hd__nand3_4 A B C VGND VNB VPB VPWR Y
.ends

* Black-box entry subcircuit for sky130_fd_sc_hd__and2_4 abstract view
.subckt sky130_fd_sc_hd__and2_4 A B VGND VNB VPB VPWR X
.ends

* Black-box entry subcircuit for sky130_fd_sc_hd__nor3_2 abstract view
.subckt sky130_fd_sc_hd__nor3_2 A B C VGND VNB VPB VPWR Y
.ends

* Black-box entry subcircuit for sky130_fd_sc_hd__and2b_1 abstract view
.subckt sky130_fd_sc_hd__and2b_1 A_N B VGND VNB VPB VPWR X
.ends

* Black-box entry subcircuit for sky130_fd_sc_hd__dfxtp_1 abstract view
.subckt sky130_fd_sc_hd__dfxtp_1 CLK D VGND VNB VPB VPWR Q
.ends

* Black-box entry subcircuit for sky130_fd_sc_hd__or4_4 abstract view
.subckt sky130_fd_sc_hd__or4_4 A B C D VGND VNB VPB VPWR X
.ends

* Black-box entry subcircuit for sky130_fd_sc_hd__or2b_1 abstract view
.subckt sky130_fd_sc_hd__or2b_1 A B_N VGND VNB VPB VPWR X
.ends

* Black-box entry subcircuit for sky130_fd_sc_hd__a21o_1 abstract view
.subckt sky130_fd_sc_hd__a21o_1 A1 A2 B1 VGND VNB VPB VPWR X
.ends

* Black-box entry subcircuit for sky130_fd_sc_hd__inv_2 abstract view
.subckt sky130_fd_sc_hd__inv_2 A VGND VNB VPB VPWR Y
.ends

* Black-box entry subcircuit for sky130_fd_sc_hd__or4_1 abstract view
.subckt sky130_fd_sc_hd__or4_1 A B C D VGND VNB VPB VPWR X
.ends

* Black-box entry subcircuit for sky130_fd_sc_hd__a32o_1 abstract view
.subckt sky130_fd_sc_hd__a32o_1 A1 A2 A3 B1 B2 VGND VNB VPB VPWR X
.ends

* Black-box entry subcircuit for sky130_fd_sc_hd__o21ai_1 abstract view
.subckt sky130_fd_sc_hd__o21ai_1 A1 A2 B1 VGND VNB VPB VPWR Y
.ends

* Black-box entry subcircuit for sky130_fd_sc_hd__xnor2_2 abstract view
.subckt sky130_fd_sc_hd__xnor2_2 A B VGND VNB VPB VPWR Y
.ends

* Black-box entry subcircuit for sky130_fd_sc_hd__dlygate4sd3_1 abstract view
.subckt sky130_fd_sc_hd__dlygate4sd3_1 A VGND VNB VPB VPWR X
.ends

* Black-box entry subcircuit for sky130_fd_sc_hd__buf_6 abstract view
.subckt sky130_fd_sc_hd__buf_6 A VGND VNB VPB VPWR X
.ends

* Black-box entry subcircuit for sky130_fd_sc_hd__dlymetal6s4s_1 abstract view
.subckt sky130_fd_sc_hd__dlymetal6s4s_1 A VGND VNB VPB VPWR X
.ends

* Black-box entry subcircuit for sky130_fd_sc_hd__o21bai_1 abstract view
.subckt sky130_fd_sc_hd__o21bai_1 A1 A2 B1_N VGND VNB VPB VPWR Y
.ends

* Black-box entry subcircuit for sky130_fd_sc_hd__or2_1 abstract view
.subckt sky130_fd_sc_hd__or2_1 A B VGND VNB VPB VPWR X
.ends

* Black-box entry subcircuit for sky130_fd_sc_hd__clkbuf_2 abstract view
.subckt sky130_fd_sc_hd__clkbuf_2 A VGND VNB VPB VPWR X
.ends

* Black-box entry subcircuit for sky130_fd_sc_hd__o211a_4 abstract view
.subckt sky130_fd_sc_hd__o211a_4 A1 A2 B1 C1 VGND VNB VPB VPWR X
.ends

* Black-box entry subcircuit for sky130_fd_sc_hd__o21a_1 abstract view
.subckt sky130_fd_sc_hd__o21a_1 A1 A2 B1 VGND VNB VPB VPWR X
.ends

* Black-box entry subcircuit for sky130_fd_sc_hd__dlymetal6s2s_1 abstract view
.subckt sky130_fd_sc_hd__dlymetal6s2s_1 A VGND VNB VPB VPWR X
.ends

* Black-box entry subcircuit for sky130_fd_sc_hd__o211ai_2 abstract view
.subckt sky130_fd_sc_hd__o211ai_2 A1 A2 B1 C1 VGND VNB VPB VPWR Y
.ends

* Black-box entry subcircuit for sky130_fd_sc_hd__and3b_1 abstract view
.subckt sky130_fd_sc_hd__and3b_1 A_N B C VGND VNB VPB VPWR X
.ends

* Black-box entry subcircuit for sky130_fd_sc_hd__a31o_1 abstract view
.subckt sky130_fd_sc_hd__a31o_1 A1 A2 A3 B1 VGND VNB VPB VPWR X
.ends

* Black-box entry subcircuit for sky130_fd_sc_hd__o22ai_1 abstract view
.subckt sky130_fd_sc_hd__o22ai_1 A1 A2 B1 B2 VGND VNB VPB VPWR Y
.ends

* Black-box entry subcircuit for sky130_fd_sc_hd__a2bb2o_1 abstract view
.subckt sky130_fd_sc_hd__a2bb2o_1 A1_N A2_N B1 B2 VGND VNB VPB VPWR X
.ends

* Black-box entry subcircuit for sky130_fd_sc_hd__or3b_4 abstract view
.subckt sky130_fd_sc_hd__or3b_4 A B C_N VGND VNB VPB VPWR X
.ends

* Black-box entry subcircuit for sky130_fd_sc_hd__a311o_1 abstract view
.subckt sky130_fd_sc_hd__a311o_1 A1 A2 A3 B1 C1 VGND VNB VPB VPWR X
.ends

* Black-box entry subcircuit for sky130_fd_sc_hd__a21oi_2 abstract view
.subckt sky130_fd_sc_hd__a21oi_2 A1 A2 B1 VGND VNB VPB VPWR Y
.ends

* Black-box entry subcircuit for sky130_fd_sc_hd__and4_1 abstract view
.subckt sky130_fd_sc_hd__and4_1 A B C D VGND VNB VPB VPWR X
.ends

* Black-box entry subcircuit for sky130_fd_sc_hd__o211ai_1 abstract view
.subckt sky130_fd_sc_hd__o211ai_1 A1 A2 B1 C1 VGND VNB VPB VPWR Y
.ends

* Black-box entry subcircuit for sky130_fd_sc_hd__nand2b_4 abstract view
.subckt sky130_fd_sc_hd__nand2b_4 A_N B VGND VNB VPB VPWR Y
.ends

* Black-box entry subcircuit for sky130_fd_sc_hd__o221a_1 abstract view
.subckt sky130_fd_sc_hd__o221a_1 A1 A2 B1 B2 C1 VGND VNB VPB VPWR X
.ends

* Black-box entry subcircuit for sky130_fd_sc_hd__or3_4 abstract view
.subckt sky130_fd_sc_hd__or3_4 A B C VGND VNB VPB VPWR X
.ends

* Black-box entry subcircuit for sky130_fd_sc_hd__a2111o_1 abstract view
.subckt sky130_fd_sc_hd__a2111o_1 A1 A2 B1 C1 D1 VGND VNB VPB VPWR X
.ends

* Black-box entry subcircuit for sky130_fd_sc_hd__a21bo_1 abstract view
.subckt sky130_fd_sc_hd__a21bo_1 A1 A2 B1_N VGND VNB VPB VPWR X
.ends

* Black-box entry subcircuit for sky130_fd_sc_hd__a211oi_1 abstract view
.subckt sky130_fd_sc_hd__a211oi_1 A1 A2 B1 C1 VGND VNB VPB VPWR Y
.ends

* Black-box entry subcircuit for sky130_fd_sc_hd__or3_1 abstract view
.subckt sky130_fd_sc_hd__or3_1 A B C VGND VNB VPB VPWR X
.ends

* Black-box entry subcircuit for sky130_fd_sc_hd__buf_4 abstract view
.subckt sky130_fd_sc_hd__buf_4 A VGND VNB VPB VPWR X
.ends

* Black-box entry subcircuit for sky130_fd_sc_hd__or3b_1 abstract view
.subckt sky130_fd_sc_hd__or3b_1 A B C_N VGND VNB VPB VPWR X
.ends

* Black-box entry subcircuit for sky130_fd_sc_hd__or2b_4 abstract view
.subckt sky130_fd_sc_hd__or2b_4 A B_N VGND VNB VPB VPWR X
.ends

* Black-box entry subcircuit for sky130_fd_sc_hd__nand2_2 abstract view
.subckt sky130_fd_sc_hd__nand2_2 A B VGND VNB VPB VPWR Y
.ends

* Black-box entry subcircuit for sky130_fd_sc_hd__or2_4 abstract view
.subckt sky130_fd_sc_hd__or2_4 A B VGND VNB VPB VPWR X
.ends

* Black-box entry subcircuit for sky130_fd_sc_hd__a22o_1 abstract view
.subckt sky130_fd_sc_hd__a22o_1 A1 A2 B1 B2 VGND VNB VPB VPWR X
.ends

* Black-box entry subcircuit for sky130_fd_sc_hd__o311a_1 abstract view
.subckt sky130_fd_sc_hd__o311a_1 A1 A2 A3 B1 C1 VGND VNB VPB VPWR X
.ends

* Black-box entry subcircuit for sky130_fd_sc_hd__dfxtp_2 abstract view
.subckt sky130_fd_sc_hd__dfxtp_2 CLK D VGND VNB VPB VPWR Q
.ends

* Black-box entry subcircuit for sky130_fd_sc_hd__o21ai_2 abstract view
.subckt sky130_fd_sc_hd__o21ai_2 A1 A2 B1 VGND VNB VPB VPWR Y
.ends

* Black-box entry subcircuit for sky130_fd_sc_hd__o31a_1 abstract view
.subckt sky130_fd_sc_hd__o31a_1 A1 A2 A3 B1 VGND VNB VPB VPWR X
.ends

* Black-box entry subcircuit for sky130_fd_sc_hd__a22oi_1 abstract view
.subckt sky130_fd_sc_hd__a22oi_1 A1 A2 B1 B2 VGND VNB VPB VPWR Y
.ends

* Black-box entry subcircuit for sky130_fd_sc_hd__nor2_4 abstract view
.subckt sky130_fd_sc_hd__nor2_4 A B VGND VNB VPB VPWR Y
.ends

* Black-box entry subcircuit for sky130_fd_sc_hd__clkbuf_8 abstract view
.subckt sky130_fd_sc_hd__clkbuf_8 A VGND VNB VPB VPWR X
.ends

* Black-box entry subcircuit for sky130_fd_sc_hd__nor2b_2 abstract view
.subckt sky130_fd_sc_hd__nor2b_2 A B_N VGND VNB VPB VPWR Y
.ends

* Black-box entry subcircuit for sky130_fd_sc_hd__and4b_1 abstract view
.subckt sky130_fd_sc_hd__and4b_1 A_N B C D VGND VNB VPB VPWR X
.ends

* Black-box entry subcircuit for sky130_fd_sc_hd__xor2_2 abstract view
.subckt sky130_fd_sc_hd__xor2_2 A B VGND VNB VPB VPWR X
.ends

* Black-box entry subcircuit for sky130_fd_sc_hd__a211oi_4 abstract view
.subckt sky130_fd_sc_hd__a211oi_4 A1 A2 B1 C1 VGND VNB VPB VPWR Y
.ends

* Black-box entry subcircuit for sky130_fd_sc_hd__o31ai_2 abstract view
.subckt sky130_fd_sc_hd__o31ai_2 A1 A2 A3 B1 VGND VNB VPB VPWR Y
.ends

* Black-box entry subcircuit for sky130_fd_sc_hd__nor3_1 abstract view
.subckt sky130_fd_sc_hd__nor3_1 A B C VGND VNB VPB VPWR Y
.ends

* Black-box entry subcircuit for sky130_fd_sc_hd__clkinv_4 abstract view
.subckt sky130_fd_sc_hd__clkinv_4 A VGND VNB VPB VPWR Y
.ends

* Black-box entry subcircuit for sky130_fd_sc_hd__nand3b_1 abstract view
.subckt sky130_fd_sc_hd__nand3b_1 A_N B C VGND VNB VPB VPWR Y
.ends

* Black-box entry subcircuit for sky130_fd_sc_hd__a211oi_2 abstract view
.subckt sky130_fd_sc_hd__a211oi_2 A1 A2 B1 C1 VGND VNB VPB VPWR Y
.ends

* Black-box entry subcircuit for sky130_fd_sc_hd__a31oi_2 abstract view
.subckt sky130_fd_sc_hd__a31oi_2 A1 A2 A3 B1 VGND VNB VPB VPWR Y
.ends

* Black-box entry subcircuit for sky130_fd_sc_hd__inv_8 abstract view
.subckt sky130_fd_sc_hd__inv_8 A VGND VNB VPB VPWR Y
.ends

* Black-box entry subcircuit for sky130_fd_sc_hd__o311ai_4 abstract view
.subckt sky130_fd_sc_hd__o311ai_4 A1 A2 A3 B1 C1 VGND VNB VPB VPWR Y
.ends

* Black-box entry subcircuit for sky130_fd_sc_hd__o2bb2ai_1 abstract view
.subckt sky130_fd_sc_hd__o2bb2ai_1 A1_N A2_N B1 B2 VGND VNB VPB VPWR Y
.ends

* Black-box entry subcircuit for sky130_fd_sc_hd__buf_8 abstract view
.subckt sky130_fd_sc_hd__buf_8 A VGND VNB VPB VPWR X
.ends

* Black-box entry subcircuit for sky130_fd_sc_hd__clkinv_1 abstract view
.subckt sky130_fd_sc_hd__clkinv_1 A VGND VNB VPB VPWR Y
.ends

* Black-box entry subcircuit for sky130_fd_sc_hd__clkinvlp_4 abstract view
.subckt sky130_fd_sc_hd__clkinvlp_4 A VGND VNB VPB VPWR Y
.ends

* Black-box entry subcircuit for sky130_fd_sc_hd__a211o_4 abstract view
.subckt sky130_fd_sc_hd__a211o_4 A1 A2 B1 C1 VGND VNB VPB VPWR X
.ends

* Black-box entry subcircuit for sky130_fd_sc_hd__nor2b_1 abstract view
.subckt sky130_fd_sc_hd__nor2b_1 A B_N VGND VNB VPB VPWR Y
.ends

* Black-box entry subcircuit for sky130_fd_sc_hd__o21ai_4 abstract view
.subckt sky130_fd_sc_hd__o21ai_4 A1 A2 B1 VGND VNB VPB VPWR Y
.ends

* Black-box entry subcircuit for sky130_fd_sc_hd__and4_4 abstract view
.subckt sky130_fd_sc_hd__and4_4 A B C D VGND VNB VPB VPWR X
.ends

* Black-box entry subcircuit for sky130_fd_sc_hd__o22a_1 abstract view
.subckt sky130_fd_sc_hd__o22a_1 A1 A2 B1 B2 VGND VNB VPB VPWR X
.ends

* Black-box entry subcircuit for sky130_fd_sc_hd__clkbuf_16 abstract view
.subckt sky130_fd_sc_hd__clkbuf_16 A VGND VNB VPB VPWR X
.ends

* Black-box entry subcircuit for sky130_fd_sc_hd__inv_6 abstract view
.subckt sky130_fd_sc_hd__inv_6 A VGND VNB VPB VPWR Y
.ends

* Black-box entry subcircuit for sky130_fd_sc_hd__a2bb2o_4 abstract view
.subckt sky130_fd_sc_hd__a2bb2o_4 A1_N A2_N B1 B2 VGND VNB VPB VPWR X
.ends

* Black-box entry subcircuit for sky130_fd_sc_hd__clkinv_8 abstract view
.subckt sky130_fd_sc_hd__clkinv_8 A VGND VNB VPB VPWR Y
.ends

* Black-box entry subcircuit for sky130_fd_sc_hd__o31ai_1 abstract view
.subckt sky130_fd_sc_hd__o31ai_1 A1 A2 A3 B1 VGND VNB VPB VPWR Y
.ends

* Black-box entry subcircuit for sky130_fd_sc_hd__a21boi_2 abstract view
.subckt sky130_fd_sc_hd__a21boi_2 A1 A2 B1_N VGND VNB VPB VPWR Y
.ends

* Black-box entry subcircuit for sky130_fd_sc_hd__nor2_2 abstract view
.subckt sky130_fd_sc_hd__nor2_2 A B VGND VNB VPB VPWR Y
.ends

* Black-box entry subcircuit for sky130_fd_sc_hd__a41o_1 abstract view
.subckt sky130_fd_sc_hd__a41o_1 A1 A2 A3 A4 B1 VGND VNB VPB VPWR X
.ends

* Black-box entry subcircuit for sky130_fd_sc_hd__bufinv_16 abstract view
.subckt sky130_fd_sc_hd__bufinv_16 A VGND VNB VPB VPWR Y
.ends

* Black-box entry subcircuit for sky130_fd_sc_hd__a221o_1 abstract view
.subckt sky130_fd_sc_hd__a221o_1 A1 A2 B1 B2 C1 VGND VNB VPB VPWR X
.ends

* Black-box entry subcircuit for sky130_fd_sc_hd__nand2_4 abstract view
.subckt sky130_fd_sc_hd__nand2_4 A B VGND VNB VPB VPWR Y
.ends

* Black-box entry subcircuit for sky130_fd_sc_hd__nor3_4 abstract view
.subckt sky130_fd_sc_hd__nor3_4 A B C VGND VNB VPB VPWR Y
.ends

* Black-box entry subcircuit for sky130_fd_sc_hd__and4bb_1 abstract view
.subckt sky130_fd_sc_hd__and4bb_1 A_N B_N C D VGND VNB VPB VPWR X
.ends

* Black-box entry subcircuit for sky130_fd_sc_hd__clkinvlp_2 abstract view
.subckt sky130_fd_sc_hd__clkinvlp_2 A VGND VNB VPB VPWR Y
.ends

* Black-box entry subcircuit for sky130_fd_sc_hd__a31o_4 abstract view
.subckt sky130_fd_sc_hd__a31o_4 A1 A2 A3 B1 VGND VNB VPB VPWR X
.ends

* Black-box entry subcircuit for sky130_fd_sc_hd__buf_12 abstract view
.subckt sky130_fd_sc_hd__buf_12 A VGND VNB VPB VPWR X
.ends

* Black-box entry subcircuit for sky130_fd_sc_hd__nand4_1 abstract view
.subckt sky130_fd_sc_hd__nand4_1 A B C D VGND VNB VPB VPWR Y
.ends

* Black-box entry subcircuit for sky130_fd_sc_hd__and3_4 abstract view
.subckt sky130_fd_sc_hd__and3_4 A B C VGND VNB VPB VPWR X
.ends

* Black-box entry subcircuit for sky130_fd_sc_hd__nand3b_2 abstract view
.subckt sky130_fd_sc_hd__nand3b_2 A_N B C VGND VNB VPB VPWR Y
.ends

* Black-box entry subcircuit for sky130_fd_sc_hd__buf_1 abstract view
.subckt sky130_fd_sc_hd__buf_1 A VGND VNB VPB VPWR X
.ends

* Black-box entry subcircuit for sky130_fd_sc_hd__mux2_4 abstract view
.subckt sky130_fd_sc_hd__mux2_4 A0 A1 S VGND VNB VPB VPWR X
.ends

* Black-box entry subcircuit for sky130_fd_sc_hd__or4b_1 abstract view
.subckt sky130_fd_sc_hd__or4b_1 A B C D_N VGND VNB VPB VPWR X
.ends

* Black-box entry subcircuit for sky130_fd_sc_hd__o21ba_4 abstract view
.subckt sky130_fd_sc_hd__o21ba_4 A1 A2 B1_N VGND VNB VPB VPWR X
.ends

* Black-box entry subcircuit for sky130_fd_sc_hd__nand4_2 abstract view
.subckt sky130_fd_sc_hd__nand4_2 A B C D VGND VNB VPB VPWR Y
.ends

* Black-box entry subcircuit for sky130_fd_sc_hd__o2111ai_4 abstract view
.subckt sky130_fd_sc_hd__o2111ai_4 A1 A2 B1 C1 D1 VGND VNB VPB VPWR Y
.ends

* Black-box entry subcircuit for sky130_fd_sc_hd__nor3b_4 abstract view
.subckt sky130_fd_sc_hd__nor3b_4 A B C_N VGND VNB VPB VPWR Y
.ends

* Black-box entry subcircuit for sky130_fd_sc_hd__nor4_1 abstract view
.subckt sky130_fd_sc_hd__nor4_1 A B C D VGND VNB VPB VPWR Y
.ends

* Black-box entry subcircuit for sky130_fd_sc_hd__dfxtp_4 abstract view
.subckt sky130_fd_sc_hd__dfxtp_4 CLK D VGND VNB VPB VPWR Q
.ends

* Black-box entry subcircuit for sky130_fd_sc_hd__and3b_2 abstract view
.subckt sky130_fd_sc_hd__and3b_2 A_N B C VGND VNB VPB VPWR X
.ends

* Black-box entry subcircuit for sky130_fd_sc_hd__a31oi_1 abstract view
.subckt sky130_fd_sc_hd__a31oi_1 A1 A2 A3 B1 VGND VNB VPB VPWR Y
.ends

* Black-box entry subcircuit for sky130_fd_sc_hd__o32a_1 abstract view
.subckt sky130_fd_sc_hd__o32a_1 A1 A2 A3 B1 B2 VGND VNB VPB VPWR X
.ends

* Black-box entry subcircuit for sky130_fd_sc_hd__or3_2 abstract view
.subckt sky130_fd_sc_hd__or3_2 A B C VGND VNB VPB VPWR X
.ends

* Black-box entry subcircuit for sky130_fd_sc_hd__a311o_4 abstract view
.subckt sky130_fd_sc_hd__a311o_4 A1 A2 A3 B1 C1 VGND VNB VPB VPWR X
.ends

* Black-box entry subcircuit for sky130_fd_sc_hd__o21bai_4 abstract view
.subckt sky130_fd_sc_hd__o21bai_4 A1 A2 B1_N VGND VNB VPB VPWR Y
.ends

* Black-box entry subcircuit for sky130_fd_sc_hd__o41a_1 abstract view
.subckt sky130_fd_sc_hd__o41a_1 A1 A2 A3 A4 B1 VGND VNB VPB VPWR X
.ends

* Black-box entry subcircuit for sky130_fd_sc_hd__a221oi_1 abstract view
.subckt sky130_fd_sc_hd__a221oi_1 A1 A2 B1 B2 C1 VGND VNB VPB VPWR Y
.ends

* Black-box entry subcircuit for sky130_fd_sc_hd__nor4b_1 abstract view
.subckt sky130_fd_sc_hd__nor4b_1 A B C D_N VGND VNB VPB VPWR Y
.ends

* Black-box entry subcircuit for sky130_fd_sc_hd__nand4bb_4 abstract view
.subckt sky130_fd_sc_hd__nand4bb_4 A_N B_N C D VGND VNB VPB VPWR Y
.ends

* Black-box entry subcircuit for sky130_fd_sc_hd__or2_2 abstract view
.subckt sky130_fd_sc_hd__or2_2 A B VGND VNB VPB VPWR X
.ends

* Black-box entry subcircuit for sky130_fd_sc_hd__nand4bb_2 abstract view
.subckt sky130_fd_sc_hd__nand4bb_2 A_N B_N C D VGND VNB VPB VPWR Y
.ends

.subckt top VGND VPWR clk m_tdata[0] m_tdata[10] m_tdata[11] m_tdata[12] m_tdata[13]
+ m_tdata[14] m_tdata[15] m_tdata[16] m_tdata[17] m_tdata[18] m_tdata[19] m_tdata[1]
+ m_tdata[20] m_tdata[21] m_tdata[22] m_tdata[23] m_tdata[24] m_tdata[25] m_tdata[26]
+ m_tdata[27] m_tdata[28] m_tdata[29] m_tdata[2] m_tdata[30] m_tdata[31] m_tdata[3]
+ m_tdata[4] m_tdata[5] m_tdata[6] m_tdata[7] m_tdata[8] m_tdata[9] m_tready m_tvalid
+ rst s_tdata[0] s_tdata[10] s_tdata[11] s_tdata[12] s_tdata[13] s_tdata[14] s_tdata[15]
+ s_tdata[16] s_tdata[17] s_tdata[18] s_tdata[19] s_tdata[1] s_tdata[20] s_tdata[21]
+ s_tdata[22] s_tdata[23] s_tdata[2] s_tdata[3] s_tdata[4] s_tdata[5] s_tdata[6] s_tdata[7]
+ s_tdata[8] s_tdata[9] s_tlast s_tready s_tvalid
X_3155_ _2643_ _2664_ VGND VGND VPWR VPWR _0025_ sky130_fd_sc_hd__nor2_1
X_3086_ u_interface.u_compute_core.scaled_valid VGND VGND VPWR VPWR _2613_ sky130_fd_sc_hd__buf_2
XFILLER_0_89_461 VPWR VGND VPWR VGND sky130_ef_sc_hd__decap_12
XFILLER_0_49_325 VGND VGND VPWR VPWR sky130_fd_sc_hd__decap_4
XFILLER_0_49_347 VGND VGND VPWR VPWR sky130_fd_sc_hd__decap_3
XFILLER_0_91_125 VGND VGND VPWR VPWR sky130_fd_sc_hd__fill_2
X_3988_ _0485_ net155 _0486_ _0572_ VGND VGND VPWR VPWR _0111_ sky130_fd_sc_hd__o211a_1
XFILLER_0_57_391 VGND VGND VPWR VPWR sky130_fd_sc_hd__fill_1
XFILLER_0_91_169 VPWR VGND VPWR VGND sky130_ef_sc_hd__decap_12
X_5727_ _2083_ _2156_ _1593_ VGND VGND VPWR VPWR _2286_ sky130_fd_sc_hd__mux2_1
XFILLER_0_72_372 VPWR VGND VPWR VGND sky130_ef_sc_hd__decap_12
XFILLER_0_17_266 VGND VGND VPWR VPWR sky130_fd_sc_hd__fill_1
XTAP_TAPCELL_ROW_20_389 VGND VPWR sky130_fd_sc_hd__tapvpwrvgnd_1
X_5658_ _2142_ _2150_ VGND VGND VPWR VPWR _2218_ sky130_fd_sc_hd__and2_1
XFILLER_0_60_545 VGND VGND VPWR VPWR sky130_fd_sc_hd__fill_2
X_4609_ _1034_ _1110_ _1109_ VGND VGND VPWR VPWR _1183_ sky130_fd_sc_hd__a21oi_1
X_5589_ _2148_ _2149_ VGND VGND VPWR VPWR _2150_ sky130_fd_sc_hd__nor2_1
XTAP_TAPCELL_ROW_56_732 VGND VPWR sky130_fd_sc_hd__tapvpwrvgnd_1
XFILLER_0_67_111 VGND VGND VPWR VPWR sky130_fd_sc_hd__fill_1
XTAP_TAPCELL_ROW_28_467 VGND VPWR sky130_fd_sc_hd__tapvpwrvgnd_1
XFILLER_0_70_309 VGND VGND VPWR VPWR sky130_fd_sc_hd__decap_8
XTAP_TAPCELL_ROW_11_301 VGND VPWR sky130_fd_sc_hd__tapvpwrvgnd_1
XFILLER_0_63_350 VPWR VGND VPWR VGND sky130_ef_sc_hd__decap_12
XFILLER_0_51_512 VPWR VGND VPWR VGND sky130_ef_sc_hd__decap_12
Xrebuffer7 _1244_ VGND VGND VPWR VPWR net72 sky130_fd_sc_hd__dlygate4sd1_1
XFILLER_0_51_545 VGND VGND VPWR VPWR sky130_fd_sc_hd__fill_2
XFILLER_0_23_258 VGND VGND VPWR VPWR sky130_fd_sc_hd__decap_6
XPHY_EDGE_ROW_39_Left_132 VGND VGND VPWR VPWR sky130_fd_sc_hd__decap_3
XFILLER_0_48_15 VPWR VGND VPWR VGND sky130_ef_sc_hd__decap_12
XFILLER_0_48_37 VGND VGND VPWR VPWR sky130_fd_sc_hd__decap_3
XFILLER_0_3_39 VPWR VGND VPWR VGND sky130_ef_sc_hd__decap_12
XPHY_EDGE_ROW_48_Left_141 VGND VGND VPWR VPWR sky130_fd_sc_hd__decap_3
X_4960_ _1521_ _1527_ _1528_ VGND VGND VPWR VPWR _1529_ sky130_fd_sc_hd__nand3_1
X_4891_ _1458_ _1459_ _1365_ VGND VGND VPWR VPWR _1461_ sky130_fd_sc_hd__a21oi_1
X_3911_ net19 VGND VGND VPWR VPWR _0498_ sky130_fd_sc_hd__buf_2
XFILLER_0_58_155 VPWR VGND VPWR VGND sky130_ef_sc_hd__decap_12
X_3842_ _0371_ _0433_ VGND VGND VPWR VPWR _0434_ sky130_fd_sc_hd__nand2_1
XFILLER_0_73_169 VPWR VGND VPWR VGND sky130_ef_sc_hd__decap_12
XFILLER_0_13_73 VGND VGND VPWR VPWR sky130_fd_sc_hd__fill_1
XFILLER_0_27_542 VGND VGND VPWR VPWR sky130_fd_sc_hd__fill_1
XFILLER_0_6_469 VGND VGND VPWR VPWR sky130_fd_sc_hd__decap_6
X_3773_ _0329_ _0332_ _0330_ VGND VGND VPWR VPWR _0367_ sky130_fd_sc_hd__o21ba_1
X_5512_ _2059_ _2073_ VGND VGND VPWR VPWR _2074_ sky130_fd_sc_hd__nand2_1
XFILLER_0_89_55 VGND VGND VPWR VPWR sky130_fd_sc_hd__fill_1
XFILLER_0_80_7 VPWR VGND VPWR VGND sky130_ef_sc_hd__decap_12
XFILLER_0_42_545 VGND VGND VPWR VPWR sky130_fd_sc_hd__fill_2
XPHY_EDGE_ROW_57_Left_150 VGND VGND VPWR VPWR sky130_fd_sc_hd__decap_3
X_5443_ _1994_ _2005_ VGND VGND VPWR VPWR _2006_ sky130_fd_sc_hd__xnor2_1
X_5374_ _1933_ _1934_ _1937_ VGND VGND VPWR VPWR _1938_ sky130_fd_sc_hd__nor3b_1
X_4325_ _0897_ _0901_ net73 _0843_ VGND VGND VPWR VPWR _0903_ sky130_fd_sc_hd__a211o_1
XFILLER_0_10_475 VGND VGND VPWR VPWR sky130_fd_sc_hd__fill_1
X_4256_ _0812_ VGND VGND VPWR VPWR _0835_ sky130_fd_sc_hd__clkbuf_4
X_3207_ _2700_ VGND VGND VPWR VPWR _0041_ sky130_fd_sc_hd__clkbuf_1
X_4187_ _0755_ _0765_ _0766_ VGND VGND VPWR VPWR _0767_ sky130_fd_sc_hd__nand3_2
X_3138_ _2643_ _2652_ VGND VGND VPWR VPWR _0020_ sky130_fd_sc_hd__nor2_1
X_3069_ u_interface.u_compute_core.scaled_data\[4\] _2584_ _2599_ _2587_ VGND VGND
+ VPWR VPWR _2600_ sky130_fd_sc_hd__o2bb2a_1
XTAP_TAPCELL_ROW_53_702 VGND VPWR sky130_fd_sc_hd__tapvpwrvgnd_1
XTAP_TAPCELL_ROW_25_437 VGND VPWR sky130_fd_sc_hd__tapvpwrvgnd_1
XFILLER_0_92_445 VGND VGND VPWR VPWR sky130_fd_sc_hd__decap_3
XFILLER_0_64_147 VGND VGND VPWR VPWR sky130_fd_sc_hd__decap_3
XFILLER_0_9_285 VGND VGND VPWR VPWR sky130_fd_sc_hd__fill_1
XFILLER_0_52_309 VPWR VGND VPWR VGND sky130_ef_sc_hd__decap_12
XFILLER_0_92_489 VPWR VGND VPWR VGND sky130_ef_sc_hd__decap_12
XFILLER_0_45_361 VGND VGND VPWR VPWR sky130_fd_sc_hd__fill_1
XFILLER_0_87_217 VGND VGND VPWR VPWR sky130_fd_sc_hd__decap_6
XFILLER_0_50_27 VGND VGND VPWR VPWR sky130_fd_sc_hd__fill_1
XFILLER_0_70_139 VGND VGND VPWR VPWR sky130_fd_sc_hd__fill_1
XFILLER_0_3_417 VPWR VGND VPWR VGND sky130_ef_sc_hd__decap_12
XFILLER_0_24_523 VGND VGND VPWR VPWR sky130_fd_sc_hd__decap_8
XFILLER_0_63_180 VGND VGND VPWR VPWR sky130_fd_sc_hd__fill_2
XFILLER_0_63_191 VGND VGND VPWR VPWR sky130_fd_sc_hd__fill_1
XFILLER_0_51_375 VPWR VGND VPWR VGND sky130_ef_sc_hd__decap_12
X_5090_ _2650_ _0816_ _0535_ _2647_ VGND VGND VPWR VPWR _1657_ sky130_fd_sc_hd__a22oi_2
X_4110_ _0645_ net69 _0690_ VGND VGND VPWR VPWR _0691_ sky130_fd_sc_hd__a21oi_1
X_4041_ _2589_ _0595_ VGND VGND VPWR VPWR _0624_ sky130_fd_sc_hd__nand2_1
XTAP_TAPCELL_ROW_67_838 VGND VPWR sky130_fd_sc_hd__tapvpwrvgnd_1
X_5992_ _2515_ VGND VGND VPWR VPWR _0172_ sky130_fd_sc_hd__clkbuf_1
X_4943_ _1507_ _1511_ VGND VGND VPWR VPWR _1512_ sky130_fd_sc_hd__xor2_1
XFILLER_0_74_434 VPWR VGND VPWR VGND sky130_ef_sc_hd__decap_12
XTAP_TAPCELL_ROW_22_407 VGND VPWR sky130_fd_sc_hd__tapvpwrvgnd_1
X_4874_ _1443_ _1143_ VGND VGND VPWR VPWR _1444_ sky130_fd_sc_hd__xnor2_4
XFILLER_0_74_467 VGND VGND VPWR VPWR sky130_fd_sc_hd__fill_1
X_3825_ _0380_ _0417_ VGND VGND VPWR VPWR _0418_ sky130_fd_sc_hd__xnor2_1
XFILLER_0_34_309 VGND VGND VPWR VPWR sky130_fd_sc_hd__decap_3
X_3756_ _0349_ _0350_ VGND VGND VPWR VPWR _0351_ sky130_fd_sc_hd__nor2_1
XFILLER_0_6_277 VPWR VGND VPWR VGND sky130_ef_sc_hd__decap_12
XFILLER_0_61_139 VGND VGND VPWR VPWR sky130_fd_sc_hd__fill_2
XTAP_TAPCELL_ROW_30_484 VGND VPWR sky130_fd_sc_hd__tapvpwrvgnd_1
XFILLER_0_71_3 VPWR VGND VPWR VGND sky130_ef_sc_hd__decap_12
X_3687_ _0242_ _0246_ _0283_ VGND VGND VPWR VPWR _0284_ sky130_fd_sc_hd__and3_1
X_5426_ _1975_ _1988_ VGND VGND VPWR VPWR _1989_ sky130_fd_sc_hd__xnor2_1
X_5357_ _1918_ _1919_ _1908_ VGND VGND VPWR VPWR _1921_ sky130_fd_sc_hd__a21oi_1
XFILLER_0_10_250 VGND VGND VPWR VPWR sky130_fd_sc_hd__fill_2
X_5288_ _1850_ _1851_ _1784_ VGND VGND VPWR VPWR _1853_ sky130_fd_sc_hd__a21boi_1
X_4308_ _0885_ _0884_ _0873_ VGND VGND VPWR VPWR _0886_ sky130_fd_sc_hd__nand3_4
X_4239_ _2598_ _0656_ VGND VGND VPWR VPWR _0818_ sky130_fd_sc_hd__and2_4
XFILLER_0_4_93 VGND VGND VPWR VPWR sky130_fd_sc_hd__fill_2
XTAP_TAPCELL_ROW_38_562 VGND VPWR sky130_fd_sc_hd__tapvpwrvgnd_1
XFILLER_0_77_272 VGND VGND VPWR VPWR sky130_fd_sc_hd__decap_8
XFILLER_0_77_261 VGND VGND VPWR VPWR sky130_fd_sc_hd__decap_4
XFILLER_0_92_253 VPWR VGND VPWR VGND sky130_ef_sc_hd__decap_12
XFILLER_0_80_415 VGND VGND VPWR VPWR sky130_fd_sc_hd__decap_4
XFILLER_0_18_361 VGND VGND VPWR VPWR sky130_fd_sc_hd__decap_3
XFILLER_0_45_191 VGND VGND VPWR VPWR sky130_fd_sc_hd__decap_6
XFILLER_0_45_27 VGND VGND VPWR VPWR sky130_fd_sc_hd__decap_8
XTAP_TAPCELL_ROW_64_808 VGND VPWR sky130_fd_sc_hd__tapvpwrvgnd_1
XFILLER_0_0_29 VPWR VGND VPWR VGND sky130_ef_sc_hd__decap_12
XFILLER_0_61_15 VPWR VGND VPWR VGND sky130_ef_sc_hd__decap_12
XFILLER_0_28_114 VGND VGND VPWR VPWR sky130_fd_sc_hd__decap_6
XTAP_TAPCELL_ROW_72_885 VGND VPWR sky130_fd_sc_hd__tapvpwrvgnd_1
XFILLER_0_71_415 VPWR VGND VPWR VGND sky130_ef_sc_hd__decap_12
XFILLER_0_56_489 VGND VGND VPWR VPWR sky130_fd_sc_hd__decap_6
X_4590_ _1068_ _1162_ _1163_ VGND VGND VPWR VPWR _1164_ sky130_fd_sc_hd__nor3_2
XFILLER_0_71_437 VGND VGND VPWR VPWR sky130_fd_sc_hd__decap_8
X_3610_ _2988_ _3023_ VGND VGND VPWR VPWR _0208_ sky130_fd_sc_hd__and2b_1
X_3541_ _2966_ _2967_ _2974_ VGND VGND VPWR VPWR _2980_ sky130_fd_sc_hd__and3_1
XFILLER_0_3_225 VPWR VGND VPWR VGND sky130_ef_sc_hd__decap_12
XFILLER_0_10_41 VPWR VGND VPWR VGND sky130_ef_sc_hd__decap_12
XFILLER_0_10_74 VGND VGND VPWR VPWR sky130_fd_sc_hd__decap_8
X_3472_ _2834_ u_interface.u_compute_core.mac_accum\[30\] VGND VGND VPWR VPWR _2918_
+ sky130_fd_sc_hd__nand2_1
X_6260_ clknet_leaf_17_clk _0173_ VGND VGND VPWR VPWR net39 sky130_fd_sc_hd__dfxtp_1
X_5211_ _1638_ _1698_ VGND VGND VPWR VPWR _1777_ sky130_fd_sc_hd__and2_1
X_6191_ clknet_leaf_0_clk _0104_ VGND VGND VPWR VPWR u_interface.u_compute_core.u_mac.product_reg\[13\]
+ sky130_fd_sc_hd__dfxtp_1
X_5142_ _1706_ _1480_ _1631_ _1185_ VGND VGND VPWR VPWR _1708_ sky130_fd_sc_hd__or4_4
X_5073_ _1568_ _1564_ VGND VGND VPWR VPWR _1640_ sky130_fd_sc_hd__or2b_1
X_4024_ _0606_ _0607_ _2735_ VGND VGND VPWR VPWR _0608_ sky130_fd_sc_hd__a21o_1
XFILLER_0_66_209 VGND VGND VPWR VPWR sky130_fd_sc_hd__fill_2
X_5975_ u_interface.core_attn_out\[29\] u_interface.u_compute_core.u_av.product_reg\[31\]
+ _2496_ VGND VGND VPWR VPWR _2503_ sky130_fd_sc_hd__a21o_1
XTAP_TAPCELL_ROW_35_532 VGND VPWR sky130_fd_sc_hd__tapvpwrvgnd_1
XFILLER_0_47_412 VPWR VGND VPWR VGND sky130_ef_sc_hd__decap_12
X_4926_ _1417_ VGND VGND VPWR VPWR _1495_ sky130_fd_sc_hd__inv_2
XFILLER_0_74_253 VGND VGND VPWR VPWR sky130_fd_sc_hd__fill_1
X_4857_ _2641_ _0547_ _0490_ _1426_ VGND VGND VPWR VPWR _1427_ sky130_fd_sc_hd__or4_1
X_3808_ _3013_ _0265_ _0400_ VGND VGND VPWR VPWR _0401_ sky130_fd_sc_hd__and3_1
XFILLER_0_62_437 VGND VGND VPWR VPWR sky130_fd_sc_hd__fill_1
X_4788_ u_interface.u_compute_core.relu_data\[18\] _0500_ _1212_ _1305_ _1358_ VGND
+ VGND VPWR VPWR _1359_ sky130_fd_sc_hd__a32o_1
XFILLER_0_70_481 VGND VGND VPWR VPWR sky130_fd_sc_hd__decap_8
X_3739_ _0327_ _0333_ VGND VGND VPWR VPWR _0334_ sky130_fd_sc_hd__and2b_1
X_5409_ _1963_ _1971_ VGND VGND VPWR VPWR _1972_ sky130_fd_sc_hd__xnor2_1
XTAP_TAPCELL_ROW_7_268 VGND VPWR sky130_fd_sc_hd__tapvpwrvgnd_1
XFILLER_0_15_19 VPWR VGND VPWR VGND sky130_ef_sc_hd__decap_12
XFILLER_0_85_529 VPWR VGND VPWR VGND sky130_ef_sc_hd__decap_12
XFILLER_0_38_489 VGND VGND VPWR VPWR sky130_fd_sc_hd__decap_8
XFILLER_0_80_256 VPWR VGND VPWR VGND sky130_ef_sc_hd__decap_12
XFILLER_0_21_312 VGND VGND VPWR VPWR sky130_fd_sc_hd__fill_2
XFILLER_0_56_15 VPWR VGND VPWR VGND sky130_ef_sc_hd__decap_12
XTAP_TAPCELL_ROW_77_933 VGND VPWR sky130_fd_sc_hd__tapvpwrvgnd_1
XTAP_TAPCELL_ROW_49_668 VGND VPWR sky130_fd_sc_hd__tapvpwrvgnd_1
XFILLER_0_72_36 VGND VGND VPWR VPWR sky130_fd_sc_hd__fill_1
XFILLER_0_29_401 VGND VGND VPWR VPWR sky130_fd_sc_hd__decap_3
XFILLER_0_8_306 VGND VGND VPWR VPWR sky130_fd_sc_hd__fill_2
X_5760_ _2311_ _2312_ _2314_ VGND VGND VPWR VPWR _2316_ sky130_fd_sc_hd__a21oi_1
XFILLER_0_29_445 VGND VGND VPWR VPWR sky130_fd_sc_hd__decap_3
XTAP_TAPCELL_ROW_32_502 VGND VPWR sky130_fd_sc_hd__tapvpwrvgnd_1
X_4711_ _1281_ _1282_ _1217_ VGND VGND VPWR VPWR _1283_ sky130_fd_sc_hd__o21ai_1
X_5691_ _2240_ _2239_ VGND VGND VPWR VPWR _2250_ sky130_fd_sc_hd__and2b_1
XFILLER_0_56_253 VGND VGND VPWR VPWR sky130_fd_sc_hd__fill_2
X_4642_ _1051_ _1160_ VGND VGND VPWR VPWR _1215_ sky130_fd_sc_hd__and2_1
XFILLER_0_71_223 VGND VGND VPWR VPWR sky130_fd_sc_hd__fill_1
XFILLER_0_4_501 VPWR VGND VPWR VGND sky130_ef_sc_hd__decap_12
XFILLER_0_16_139 VGND VGND VPWR VPWR sky130_fd_sc_hd__fill_1
X_4573_ _2625_ _0586_ _0556_ net114 VGND VGND VPWR VPWR _1147_ sky130_fd_sc_hd__a22oi_2
XFILLER_0_71_289 VPWR VGND VPWR VGND sky130_ef_sc_hd__decap_12
XFILLER_0_71_278 VGND VGND VPWR VPWR sky130_fd_sc_hd__fill_2
XFILLER_0_4_545 VGND VGND VPWR VPWR sky130_fd_sc_hd__fill_2
XFILLER_0_21_84 VGND VGND VPWR VPWR sky130_fd_sc_hd__fill_2
X_3524_ _2960_ _2962_ _2963_ VGND VGND VPWR VPWR _2964_ sky130_fd_sc_hd__a21o_1
X_6243_ clknet_leaf_13_clk _0156_ VGND VGND VPWR VPWR u_interface.core_attn_out\[18\]
+ sky130_fd_sc_hd__dfxtp_1
X_3455_ _2898_ _2901_ VGND VGND VPWR VPWR _2904_ sky130_fd_sc_hd__nand2_1
X_6174_ clknet_leaf_20_clk _0087_ VGND VGND VPWR VPWR u_interface.u_compute_core.mac_accum\[28\]
+ sky130_fd_sc_hd__dfxtp_1
X_3386_ _2832_ u_interface.u_compute_core.mac_accum\[17\] VGND VGND VPWR VPWR _2845_
+ sky130_fd_sc_hd__xnor2_1
X_5125_ _1689_ _1691_ VGND VGND VPWR VPWR _1692_ sky130_fd_sc_hd__xnor2_1
XTAP_TAPCELL_ROW_4_238 VGND VPWR sky130_fd_sc_hd__tapvpwrvgnd_1
XFILLER_0_34_3 VPWR VGND VPWR VGND sky130_ef_sc_hd__decap_12
X_5056_ _1622_ _1621_ _1561_ _1562_ VGND VGND VPWR VPWR _1624_ sky130_fd_sc_hd__a211o_1
XFILLER_0_79_334 VGND VGND VPWR VPWR sky130_fd_sc_hd__fill_2
X_4007_ _0589_ _0590_ VGND VGND VPWR VPWR _0591_ sky130_fd_sc_hd__xnor2_2
X_5958_ _2319_ _2487_ _2488_ _2327_ VGND VGND VPWR VPWR _0165_ sky130_fd_sc_hd__o211a_1
XFILLER_0_1_94 VGND VGND VPWR VPWR sky130_fd_sc_hd__decap_8
XFILLER_0_62_80 VGND VGND VPWR VPWR sky130_fd_sc_hd__decap_4
X_4909_ _1477_ _1478_ VGND VGND VPWR VPWR _1479_ sky130_fd_sc_hd__xnor2_2
XFILLER_0_47_264 VPWR VGND VPWR VGND sky130_ef_sc_hd__decap_12
X_5889_ _2427_ VGND VGND VPWR VPWR _2428_ sky130_fd_sc_hd__inv_2
XFILLER_0_15_194 VPWR VGND VPWR VGND sky130_ef_sc_hd__decap_12
XFILLER_0_30_164 VPWR VGND VPWR VGND sky130_ef_sc_hd__decap_12
Xhold74 net40 VGND VGND VPWR VPWR net139 sky130_fd_sc_hd__dlygate4sd3_1
XTAP_TAPCELL_ROW_74_903 VGND VPWR sky130_fd_sc_hd__tapvpwrvgnd_1
XPHY_EDGE_ROW_11_Left_104 VGND VGND VPWR VPWR sky130_fd_sc_hd__decap_3
Xhold96 u_interface.u_compute_core.mac_accum\[6\] VGND VGND VPWR VPWR net161 sky130_fd_sc_hd__dlygate4sd3_1
Xhold85 u_interface.u_compute_core.mac_accum\[14\] VGND VGND VPWR VPWR net150 sky130_fd_sc_hd__dlygate4sd3_1
XTAP_TAPCELL_ROW_46_638 VGND VPWR sky130_fd_sc_hd__tapvpwrvgnd_1
XFILLER_0_85_348 VGND VGND VPWR VPWR sky130_fd_sc_hd__fill_2
XTAP_TAPCELL_ROW_82_980 VGND VPWR sky130_fd_sc_hd__tapvpwrvgnd_1
XFILLER_0_26_437 VGND VGND VPWR VPWR sky130_fd_sc_hd__fill_2
XPHY_EDGE_ROW_20_Left_113 VGND VGND VPWR VPWR sky130_fd_sc_hd__decap_3
X_3240_ u_interface.u_compute_core.scaled_data\[23\] u_interface.u_compute_core.mac_accum\[26\]
+ _2713_ VGND VGND VPWR VPWR _2723_ sky130_fd_sc_hd__mux2_1
X_3171_ _2672_ _2675_ VGND VGND VPWR VPWR _2676_ sky130_fd_sc_hd__and2_1
Xrebuffer17 _1244_ VGND VGND VPWR VPWR net224 sky130_fd_sc_hd__dlygate4sd1_1
XTAP_TAPCELL_ROW_1_208 VGND VPWR sky130_fd_sc_hd__tapvpwrvgnd_1
Xrebuffer39 _1472_ VGND VGND VPWR VPWR net104 sky130_fd_sc_hd__buf_6
Xrebuffer28 _0830_ VGND VGND VPWR VPWR net93 sky130_fd_sc_hd__dlymetal6s4s_1
XFILLER_0_76_304 VGND VGND VPWR VPWR sky130_fd_sc_hd__decap_4
X_5812_ u_interface.core_attn_out\[9\] u_interface.u_compute_core.u_av.product_reg\[12\]
+ VGND VGND VPWR VPWR _2361_ sky130_fd_sc_hd__nor2_1
XTAP_TAPCELL_ROW_17_362 VGND VPWR sky130_fd_sc_hd__tapvpwrvgnd_1
X_5743_ u_interface.u_compute_core.u_av.valid_a VGND VGND VPWR VPWR _2301_ sky130_fd_sc_hd__buf_2
XFILLER_0_29_297 VGND VGND VPWR VPWR sky130_fd_sc_hd__fill_1
X_5674_ _2228_ _2233_ VGND VGND VPWR VPWR _2234_ sky130_fd_sc_hd__xnor2_1
X_4625_ _1189_ _1196_ _1197_ VGND VGND VPWR VPWR _1198_ sky130_fd_sc_hd__nand3_1
X_4556_ _1118_ _1128_ _1129_ VGND VGND VPWR VPWR _1130_ sky130_fd_sc_hd__nand3_1
X_3507_ _2935_ _2947_ VGND VGND VPWR VPWR _2948_ sky130_fd_sc_hd__nand2_1
XFILLER_0_40_462 VPWR VGND VPWR VGND sky130_ef_sc_hd__decap_12
X_4487_ _1059_ _1060_ _1058_ VGND VGND VPWR VPWR _1062_ sky130_fd_sc_hd__o21ai_1
X_6226_ clknet_leaf_17_clk _0139_ VGND VGND VPWR VPWR u_interface.core_attn_out\[1\]
+ sky130_fd_sc_hd__dfxtp_1
X_3438_ _2781_ _2888_ _2889_ _2867_ net208 VGND VGND VPWR VPWR _0083_ sky130_fd_sc_hd__a32o_1
X_3369_ _2824_ _2827_ VGND VGND VPWR VPWR _2830_ sky130_fd_sc_hd__nand2_1
X_6157_ clknet_leaf_0_clk _0070_ VGND VGND VPWR VPWR u_interface.u_compute_core.mac_accum\[11\]
+ sky130_fd_sc_hd__dfxtp_1
X_5108_ _1595_ _1603_ _1602_ VGND VGND VPWR VPWR _1675_ sky130_fd_sc_hd__o21bai_1
X_6088_ clknet_leaf_8_clk _0001_ VGND VGND VPWR VPWR u_interface.u_compute_core.relu_data\[1\]
+ sky130_fd_sc_hd__dfxtp_1
X_5039_ _1604_ _1605_ _1606_ VGND VGND VPWR VPWR _1607_ sky130_fd_sc_hd__nand3_1
XFILLER_0_73_90 VGND VGND VPWR VPWR sky130_fd_sc_hd__decap_3
XTAP_TAPCELL_ROW_43_608 VGND VPWR sky130_fd_sc_hd__tapvpwrvgnd_1
XFILLER_0_67_337 VGND VGND VPWR VPWR sky130_fd_sc_hd__fill_2
XTAP_TAPCELL_ROW_51_685 VGND VPWR sky130_fd_sc_hd__tapvpwrvgnd_1
XFILLER_0_50_215 VGND VGND VPWR VPWR sky130_fd_sc_hd__decap_4
XFILLER_0_50_226 VPWR VGND VPWR VGND sky130_ef_sc_hd__decap_12
Xoutput31 net31 VGND VGND VPWR VPWR m_tdata[12] sky130_fd_sc_hd__buf_2
Xoutput42 net42 VGND VGND VPWR VPWR m_tdata[22] sky130_fd_sc_hd__buf_2
Xoutput53 net53 VGND VGND VPWR VPWR m_tdata[3] sky130_fd_sc_hd__buf_2
XTAP_TAPCELL_ROW_59_763 VGND VPWR sky130_fd_sc_hd__tapvpwrvgnd_1
XFILLER_0_53_27 VPWR VGND VPWR VGND sky130_ef_sc_hd__decap_12
XFILLER_0_85_167 VGND VGND VPWR VPWR sky130_fd_sc_hd__fill_1
XTAP_TAPCELL_ROW_14_332 VGND VPWR sky130_fd_sc_hd__tapvpwrvgnd_1
XFILLER_0_26_234 VGND VGND VPWR VPWR sky130_fd_sc_hd__decap_4
XFILLER_0_81_384 VGND VGND VPWR VPWR sky130_fd_sc_hd__decap_8
XFILLER_0_14_429 VGND VGND VPWR VPWR sky130_fd_sc_hd__fill_2
XFILLER_0_14_407 VPWR VGND VPWR VGND sky130_ef_sc_hd__decap_12
X_4410_ _0984_ _0985_ VGND VGND VPWR VPWR _0986_ sky130_fd_sc_hd__or2_1
XFILLER_0_41_237 VGND VGND VPWR VPWR sky130_fd_sc_hd__decap_8
X_5390_ _0571_ _1952_ _1953_ _1337_ VGND VGND VPWR VPWR _0132_ sky130_fd_sc_hd__o211a_1
X_4341_ _0917_ VGND VGND VPWR VPWR _0918_ sky130_fd_sc_hd__clkbuf_2
X_4272_ _0782_ _0849_ _0848_ _0847_ VGND VGND VPWR VPWR _0851_ sky130_fd_sc_hd__o211a_4
X_6011_ _2528_ VGND VGND VPWR VPWR _0178_ sky130_fd_sc_hd__clkbuf_1
X_3223_ u_interface.u_compute_core.scaled_data\[18\] u_interface.u_compute_core.mac_accum\[21\]
+ _2691_ VGND VGND VPWR VPWR _2711_ sky130_fd_sc_hd__mux2_1
X_3154_ u_interface.u_compute_core.scaled_data\[25\] _2583_ _2663_ _2586_ VGND VGND
+ VPWR VPWR _2664_ sky130_fd_sc_hd__o2bb2a_1
X_3085_ _2611_ VGND VGND VPWR VPWR _2612_ sky130_fd_sc_hd__inv_2
XFILLER_0_89_473 VPWR VGND VPWR VGND sky130_ef_sc_hd__decap_12
XFILLER_0_49_337 VGND VGND VPWR VPWR sky130_fd_sc_hd__decap_3
XFILLER_0_64_307 VGND VGND VPWR VPWR sky130_fd_sc_hd__fill_1
X_3987_ _0569_ _0570_ _0571_ VGND VGND VPWR VPWR _0572_ sky130_fd_sc_hd__a21o_1
XFILLER_0_45_521 VGND VGND VPWR VPWR sky130_fd_sc_hd__fill_1
X_5726_ _2209_ _2213_ _2208_ VGND VGND VPWR VPWR _2285_ sky130_fd_sc_hd__o21a_1
XFILLER_0_72_384 VGND VGND VPWR VPWR sky130_fd_sc_hd__fill_1
X_5657_ _1996_ _2160_ _2156_ VGND VGND VPWR VPWR _2217_ sky130_fd_sc_hd__o21a_1
XFILLER_0_32_237 VGND VGND VPWR VPWR sky130_fd_sc_hd__decap_6
XFILLER_0_4_161 VGND VGND VPWR VPWR sky130_fd_sc_hd__decap_4
X_4608_ net75 _1181_ VGND VGND VPWR VPWR _1182_ sky130_fd_sc_hd__or2_1
X_5588_ _2054_ _2143_ _2147_ VGND VGND VPWR VPWR _2149_ sky130_fd_sc_hd__and3_1
X_4539_ _1112_ _1113_ VGND VGND VPWR VPWR _1114_ sky130_fd_sc_hd__xnor2_1
X_6209_ clknet_leaf_10_clk _0122_ VGND VGND VPWR VPWR u_interface.u_compute_core.u_av.product_reg\[16\]
+ sky130_fd_sc_hd__dfxtp_1
XTAP_TAPCELL_ROW_56_733 VGND VPWR sky130_fd_sc_hd__tapvpwrvgnd_1
XTAP_TAPCELL_ROW_28_468 VGND VPWR sky130_fd_sc_hd__tapvpwrvgnd_1
XFILLER_0_67_145 VGND VGND VPWR VPWR sky130_fd_sc_hd__decap_8
XTAP_TAPCELL_ROW_11_302 VGND VPWR sky130_fd_sc_hd__tapvpwrvgnd_1
XFILLER_0_90_181 VGND VGND VPWR VPWR sky130_fd_sc_hd__fill_2
XFILLER_0_23_248 VGND VGND VPWR VPWR sky130_fd_sc_hd__decap_6
Xrebuffer8 _0841_ VGND VGND VPWR VPWR net73 sky130_fd_sc_hd__dlymetal6s2s_1
XFILLER_0_51_524 VGND VGND VPWR VPWR sky130_fd_sc_hd__fill_1
XFILLER_0_31_281 VGND VGND VPWR VPWR sky130_fd_sc_hd__fill_2
XFILLER_0_48_27 VGND VGND VPWR VPWR sky130_fd_sc_hd__fill_1
XFILLER_0_64_15 VPWR VGND VPWR VGND sky130_ef_sc_hd__decap_12
X_4890_ _1458_ _1365_ _1459_ VGND VGND VPWR VPWR _1460_ sky130_fd_sc_hd__and3_1
XFILLER_0_46_307 VGND VGND VPWR VPWR sky130_fd_sc_hd__fill_1
X_3910_ _2592_ _2589_ _0496_ VGND VGND VPWR VPWR _0497_ sky130_fd_sc_hd__and3_1
XFILLER_0_58_167 VPWR VGND VPWR VGND sky130_ef_sc_hd__decap_12
XFILLER_0_86_487 VPWR VGND VPWR VGND sky130_ef_sc_hd__decap_12
X_3841_ _0431_ _0432_ VGND VGND VPWR VPWR _0433_ sky130_fd_sc_hd__and2_1
XFILLER_0_27_510 VPWR VGND VPWR VGND sky130_ef_sc_hd__decap_12
XFILLER_0_73_159 VGND VGND VPWR VPWR sky130_fd_sc_hd__decap_8
X_3772_ _0364_ _0365_ VGND VGND VPWR VPWR _0366_ sky130_fd_sc_hd__xnor2_1
X_5511_ _2061_ _2072_ VGND VGND VPWR VPWR _2073_ sky130_fd_sc_hd__xnor2_1
XFILLER_0_81_181 VPWR VGND VPWR VGND sky130_ef_sc_hd__decap_12
X_5442_ _1995_ _2004_ VGND VGND VPWR VPWR _2005_ sky130_fd_sc_hd__xor2_1
X_5373_ _1935_ _1846_ _1936_ VGND VGND VPWR VPWR _1937_ sky130_fd_sc_hd__o21ai_1
XFILLER_0_10_421 VGND VGND VPWR VPWR sky130_fd_sc_hd__fill_2
X_4324_ net73 _0843_ _0897_ _0901_ VGND VGND VPWR VPWR _0902_ sky130_fd_sc_hd__o211ai_2
X_4255_ _0813_ _0832_ _0833_ VGND VGND VPWR VPWR _0834_ sky130_fd_sc_hd__nand3_1
X_3206_ _2694_ _2699_ VGND VGND VPWR VPWR _2700_ sky130_fd_sc_hd__and2_1
X_4186_ _0763_ _0764_ _0756_ VGND VGND VPWR VPWR _0766_ sky130_fd_sc_hd__a21o_1
X_3137_ u_interface.u_compute_core.scaled_data\[20\] _2583_ _2651_ _2586_ VGND VGND
+ VPWR VPWR _2652_ sky130_fd_sc_hd__o2bb2a_1
XFILLER_0_49_101 VGND VGND VPWR VPWR sky130_fd_sc_hd__fill_1
X_3068_ _2598_ VGND VGND VPWR VPWR _2599_ sky130_fd_sc_hd__inv_2
XTAP_TAPCELL_ROW_53_703 VGND VPWR sky130_fd_sc_hd__tapvpwrvgnd_1
XFILLER_0_77_443 VGND VGND VPWR VPWR sky130_fd_sc_hd__decap_4
XTAP_TAPCELL_ROW_25_438 VGND VPWR sky130_fd_sc_hd__tapvpwrvgnd_1
XFILLER_0_77_487 VGND VGND VPWR VPWR sky130_fd_sc_hd__decap_8
XFILLER_0_64_104 VGND VGND VPWR VPWR sky130_fd_sc_hd__fill_2
XFILLER_0_9_231 VPWR VGND VPWR VGND sky130_ef_sc_hd__decap_12
XFILLER_0_49_167 VGND VGND VPWR VPWR sky130_fd_sc_hd__fill_1
XTAP_TAPCELL_ROW_61_780 VGND VPWR sky130_fd_sc_hd__tapvpwrvgnd_1
XFILLER_0_9_297 VGND VGND VPWR VPWR sky130_fd_sc_hd__decap_6
XFILLER_0_33_502 VGND VGND VPWR VPWR sky130_fd_sc_hd__fill_2
XFILLER_0_72_181 VGND VGND VPWR VPWR sky130_fd_sc_hd__decap_8
X_5709_ _2262_ _2267_ VGND VGND VPWR VPWR _2268_ sky130_fd_sc_hd__xnor2_1
XFILLER_0_60_332 VGND VGND VPWR VPWR sky130_fd_sc_hd__fill_1
XFILLER_0_60_365 VPWR VGND VPWR VGND sky130_ef_sc_hd__decap_12
XFILLER_0_13_281 VPWR VGND VPWR VGND sky130_ef_sc_hd__decap_12
XFILLER_0_68_421 VPWR VGND VPWR VGND sky130_ef_sc_hd__decap_12
XFILLER_0_55_104 VGND VGND VPWR VPWR sky130_fd_sc_hd__decap_8
XFILLER_0_55_148 VGND VGND VPWR VPWR sky130_fd_sc_hd__decap_6
XFILLER_0_51_332 VGND VGND VPWR VPWR sky130_fd_sc_hd__decap_4
XFILLER_0_3_429 VPWR VGND VPWR VGND sky130_ef_sc_hd__decap_12
XFILLER_0_59_15 VPWR VGND VPWR VGND sky130_ef_sc_hd__decap_12
XFILLER_0_51_387 VGND VGND VPWR VPWR sky130_fd_sc_hd__decap_4
X_4040_ net65 _0622_ VGND VGND VPWR VPWR _0623_ sky130_fd_sc_hd__xnor2_2
XTAP_TAPCELL_ROW_67_839 VGND VPWR sky130_fd_sc_hd__tapvpwrvgnd_1
XFILLER_0_91_57 VPWR VGND VPWR VGND sky130_ef_sc_hd__decap_12
X_5991_ _2716_ _2514_ VGND VGND VPWR VPWR _2515_ sky130_fd_sc_hd__and2_1
X_4942_ _1508_ _1510_ VGND VGND VPWR VPWR _1511_ sky130_fd_sc_hd__or2_1
X_4873_ _1415_ _1442_ VGND VGND VPWR VPWR _1443_ sky130_fd_sc_hd__or2b_1
XFILLER_0_74_446 VGND VGND VPWR VPWR sky130_fd_sc_hd__decap_4
XTAP_TAPCELL_ROW_22_408 VGND VPWR sky130_fd_sc_hd__tapvpwrvgnd_1
XFILLER_0_46_137 VGND VGND VPWR VPWR sky130_fd_sc_hd__decap_3
X_3824_ _0415_ _0416_ VGND VGND VPWR VPWR _0417_ sky130_fd_sc_hd__xnor2_1
X_3755_ _0308_ _0313_ _0307_ VGND VGND VPWR VPWR _0350_ sky130_fd_sc_hd__a21boi_1
XFILLER_0_40_50 VGND VGND VPWR VPWR sky130_fd_sc_hd__decap_4
X_3686_ _0281_ _0282_ VGND VGND VPWR VPWR _0283_ sky130_fd_sc_hd__or2b_1
XFILLER_0_6_289 VPWR VGND VPWR VGND sky130_ef_sc_hd__decap_12
XTAP_TAPCELL_ROW_30_485 VGND VPWR sky130_fd_sc_hd__tapvpwrvgnd_1
XFILLER_0_40_83 VGND VGND VPWR VPWR sky130_fd_sc_hd__fill_1
XFILLER_0_42_365 VGND VGND VPWR VPWR sky130_fd_sc_hd__fill_2
XPHY_EDGE_ROW_12_Right_12 VGND VGND VPWR VPWR sky130_fd_sc_hd__decap_3
X_5425_ _1981_ _1987_ VGND VGND VPWR VPWR _1988_ sky130_fd_sc_hd__xnor2_1
XFILLER_0_64_3 VPWR VGND VPWR VGND sky130_ef_sc_hd__decap_12
X_5356_ _1908_ _1918_ _1919_ VGND VGND VPWR VPWR _1920_ sky130_fd_sc_hd__and3_1
XFILLER_0_49_81 VPWR VGND VPWR VGND sky130_ef_sc_hd__decap_12
X_5287_ _1784_ _1850_ _1851_ VGND VGND VPWR VPWR _1852_ sky130_fd_sc_hd__and3b_1
XFILLER_0_10_273 VGND VGND VPWR VPWR sky130_fd_sc_hd__decap_3
X_4307_ _0882_ _0883_ _0805_ VGND VGND VPWR VPWR _0885_ sky130_fd_sc_hd__a21o_1
X_4238_ _0612_ _0816_ _0742_ _0741_ VGND VGND VPWR VPWR _0817_ sky130_fd_sc_hd__a31o_1
X_4169_ _0748_ _0721_ _0723_ _0711_ VGND VGND VPWR VPWR _0749_ sky130_fd_sc_hd__o22ai_1
XPHY_EDGE_ROW_21_Right_21 VGND VGND VPWR VPWR sky130_fd_sc_hd__decap_3
XTAP_TAPCELL_ROW_38_563 VGND VPWR sky130_fd_sc_hd__tapvpwrvgnd_1
XFILLER_0_77_240 VGND VGND VPWR VPWR sky130_fd_sc_hd__decap_3
XFILLER_0_65_413 VGND VGND VPWR VPWR sky130_fd_sc_hd__fill_1
XFILLER_0_92_221 VGND VGND VPWR VPWR sky130_fd_sc_hd__decap_3
XFILLER_0_65_446 VGND VGND VPWR VPWR sky130_fd_sc_hd__fill_2
XFILLER_0_37_137 VGND VGND VPWR VPWR sky130_fd_sc_hd__decap_8
XFILLER_0_92_265 VPWR VGND VPWR VGND sky130_ef_sc_hd__decap_12
XFILLER_0_18_395 VPWR VGND VPWR VGND sky130_ef_sc_hd__decap_12
XFILLER_0_21_505 VGND VGND VPWR VPWR sky130_fd_sc_hd__fill_2
XPHY_EDGE_ROW_30_Right_30 VGND VGND VPWR VPWR sky130_fd_sc_hd__decap_3
XFILLER_0_33_354 VGND VGND VPWR VPWR sky130_fd_sc_hd__fill_2
XFILLER_0_60_151 VGND VGND VPWR VPWR sky130_fd_sc_hd__decap_8
XFILLER_0_60_195 VGND VGND VPWR VPWR sky130_fd_sc_hd__fill_1
XPHY_EDGE_ROW_76_Left_169 VGND VGND VPWR VPWR sky130_fd_sc_hd__decap_3
XTAP_TAPCELL_ROW_64_809 VGND VPWR sky130_fd_sc_hd__tapvpwrvgnd_1
XPHY_EDGE_ROW_85_Left_178 VGND VGND VPWR VPWR sky130_fd_sc_hd__decap_3
XFILLER_0_61_27 VPWR VGND VPWR VGND sky130_ef_sc_hd__decap_12
XFILLER_0_83_243 VPWR VGND VPWR VGND sky130_ef_sc_hd__decap_12
XFILLER_0_83_221 VGND VGND VPWR VPWR sky130_fd_sc_hd__decap_3
XTAP_TAPCELL_ROW_72_886 VGND VPWR sky130_fd_sc_hd__tapvpwrvgnd_1
XFILLER_0_56_446 VGND VGND VPWR VPWR sky130_fd_sc_hd__decap_6
XFILLER_0_56_468 VGND VGND VPWR VPWR sky130_fd_sc_hd__decap_8
XFILLER_0_71_449 VGND VGND VPWR VPWR sky130_fd_sc_hd__fill_1
XFILLER_0_71_427 VGND VGND VPWR VPWR sky130_fd_sc_hd__fill_1
XFILLER_0_36_170 VGND VGND VPWR VPWR sky130_fd_sc_hd__decap_6
X_3540_ _2978_ _2979_ net147 _2756_ VGND VGND VPWR VPWR _0095_ sky130_fd_sc_hd__a2bb2o_1
XFILLER_0_10_53 VGND VGND VPWR VPWR sky130_fd_sc_hd__decap_4
XFILLER_0_3_237 VPWR VGND VPWR VGND sky130_ef_sc_hd__decap_12
X_3471_ _2916_ _2917_ net167 _2756_ VGND VGND VPWR VPWR _0088_ sky130_fd_sc_hd__a2bb2o_1
X_5210_ _0982_ _1775_ VGND VGND VPWR VPWR _1776_ sky130_fd_sc_hd__xnor2_1
X_6190_ clknet_leaf_0_clk _0103_ VGND VGND VPWR VPWR u_interface.u_compute_core.u_mac.product_reg\[12\]
+ sky130_fd_sc_hd__dfxtp_1
X_5141_ _1631_ net105 _1482_ VGND VGND VPWR VPWR _1707_ sky130_fd_sc_hd__or3b_4
X_5072_ net131 VGND VGND VPWR VPWR _1639_ sky130_fd_sc_hd__clkbuf_4
X_4023_ _0573_ _0569_ _0605_ VGND VGND VPWR VPWR _0607_ sky130_fd_sc_hd__nand3_1
X_5974_ net189 VGND VGND VPWR VPWR _2502_ sky130_fd_sc_hd__inv_2
XTAP_TAPCELL_ROW_35_533 VGND VPWR sky130_fd_sc_hd__tapvpwrvgnd_1
X_4925_ net120 _1442_ _1415_ VGND VGND VPWR VPWR _1494_ sky130_fd_sc_hd__a21o_1
XFILLER_0_47_424 VPWR VGND VPWR VGND sky130_ef_sc_hd__decap_12
X_4856_ u_interface.u_compute_core.relu_data\[18\] _0525_ VGND VGND VPWR VPWR _1426_
+ sky130_fd_sc_hd__nand2_1
XFILLER_0_74_298 VGND VGND VPWR VPWR sky130_fd_sc_hd__decap_3
X_3807_ _0396_ _0397_ VGND VGND VPWR VPWR _0400_ sky130_fd_sc_hd__nor2_1
XFILLER_0_62_449 VGND VGND VPWR VPWR sky130_fd_sc_hd__fill_1
X_4787_ _1209_ _0525_ VGND VGND VPWR VPWR _1358_ sky130_fd_sc_hd__nand2_1
XFILLER_0_15_354 VGND VGND VPWR VPWR sky130_fd_sc_hd__fill_2
X_3738_ _0331_ _0332_ VGND VGND VPWR VPWR _0333_ sky130_fd_sc_hd__xnor2_1
X_3669_ _2993_ _0225_ VGND VGND VPWR VPWR _0266_ sky130_fd_sc_hd__nor2_1
X_5408_ _1964_ _1970_ VGND VGND VPWR VPWR _1971_ sky130_fd_sc_hd__xor2_1
X_5339_ _1900_ _1901_ _1882_ VGND VGND VPWR VPWR _1903_ sky130_fd_sc_hd__a21o_1
XTAP_TAPCELL_ROW_7_269 VGND VPWR sky130_fd_sc_hd__tapvpwrvgnd_1
XTAP_TAPCELL_ROW_87_1030 VGND VPWR sky130_fd_sc_hd__tapvpwrvgnd_1
XFILLER_0_53_449 VPWR VGND VPWR VGND sky130_ef_sc_hd__decap_12
XFILLER_0_18_181 VGND VGND VPWR VPWR sky130_fd_sc_hd__decap_3
XFILLER_0_61_482 VGND VGND VPWR VPWR sky130_fd_sc_hd__decap_4
XFILLER_0_61_493 VGND VGND VPWR VPWR sky130_fd_sc_hd__decap_8
XFILLER_0_56_27 VGND VGND VPWR VPWR sky130_fd_sc_hd__fill_1
XTAP_TAPCELL_ROW_77_934 VGND VPWR sky130_fd_sc_hd__tapvpwrvgnd_1
XFILLER_0_72_15 VPWR VGND VPWR VGND sky130_ef_sc_hd__decap_12
XTAP_TAPCELL_ROW_49_669 VGND VPWR sky130_fd_sc_hd__tapvpwrvgnd_1
XTAP_TAPCELL_ROW_32_503 VGND VPWR sky130_fd_sc_hd__tapvpwrvgnd_1
X_4710_ _2625_ _0594_ _0632_ _2622_ VGND VGND VPWR VPWR _1282_ sky130_fd_sc_hd__a22oi_2
X_5690_ _2118_ _2115_ _2186_ _2244_ _2185_ VGND VGND VPWR VPWR _2249_ sky130_fd_sc_hd__a311o_1
X_4641_ _1210_ _1211_ _1213_ VGND VGND VPWR VPWR _1214_ sky130_fd_sc_hd__a21oi_2
XFILLER_0_44_449 VGND VGND VPWR VPWR sky130_fd_sc_hd__decap_6
XFILLER_0_4_513 VPWR VGND VPWR VGND sky130_ef_sc_hd__decap_12
XTAP_TAPCELL_ROW_40_580 VGND VPWR sky130_fd_sc_hd__tapvpwrvgnd_1
X_4572_ _0927_ u_interface.u_compute_core.relu_data\[12\] net21 _0556_ VGND VGND VPWR
+ VPWR _1146_ sky130_fd_sc_hd__and4_1
X_3523_ net24 _2930_ _2949_ _2961_ VGND VGND VPWR VPWR _2963_ sky130_fd_sc_hd__and4_1
XFILLER_0_24_173 VGND VGND VPWR VPWR sky130_fd_sc_hd__fill_1
XFILLER_0_24_195 VGND VGND VPWR VPWR sky130_fd_sc_hd__fill_1
XFILLER_0_12_357 VGND VGND VPWR VPWR sky130_fd_sc_hd__fill_1
X_3454_ _2833_ u_interface.u_compute_core.mac_accum\[27\] VGND VGND VPWR VPWR _2903_
+ sky130_fd_sc_hd__xor2_1
X_6242_ clknet_leaf_10_clk _0155_ VGND VGND VPWR VPWR u_interface.core_attn_out\[17\]
+ sky130_fd_sc_hd__dfxtp_1
X_6173_ clknet_leaf_19_clk _0086_ VGND VGND VPWR VPWR u_interface.u_compute_core.mac_accum\[27\]
+ sky130_fd_sc_hd__dfxtp_1
X_3385_ _2781_ _2843_ _2844_ _2746_ net193 VGND VGND VPWR VPWR _0075_ sky130_fd_sc_hd__a32o_1
X_5124_ net126 _1690_ VGND VGND VPWR VPWR _1691_ sky130_fd_sc_hd__xor2_1
XTAP_TAPCELL_ROW_4_239 VGND VPWR sky130_fd_sc_hd__tapvpwrvgnd_1
X_5055_ _1561_ _1562_ _1621_ _1622_ VGND VGND VPWR VPWR _1623_ sky130_fd_sc_hd__o211ai_1
XFILLER_0_27_3 VGND VGND VPWR VPWR sky130_fd_sc_hd__decap_8
XFILLER_0_46_82 VGND VGND VPWR VPWR sky130_fd_sc_hd__fill_2
X_4006_ _2589_ _0558_ VGND VGND VPWR VPWR _0590_ sky130_fd_sc_hd__nand2_1
XFILLER_0_79_346 VPWR VGND VPWR VGND sky130_ef_sc_hd__decap_12
XFILLER_0_1_51 VGND VGND VPWR VPWR sky130_fd_sc_hd__decap_4
XFILLER_0_87_390 VGND VGND VPWR VPWR sky130_fd_sc_hd__fill_2
XFILLER_0_75_541 VGND VGND VPWR VPWR sky130_fd_sc_hd__decap_6
X_5957_ u_interface.core_attn_out\[27\] _2308_ VGND VGND VPWR VPWR _2488_ sky130_fd_sc_hd__or2_1
XFILLER_0_47_232 VGND VGND VPWR VPWR sky130_fd_sc_hd__decap_4
X_4908_ _1398_ _1400_ VGND VGND VPWR VPWR _1478_ sky130_fd_sc_hd__nand2b_4
XFILLER_0_90_533 VPWR VGND VPWR VGND sky130_ef_sc_hd__decap_12
X_5888_ u_interface.core_attn_out\[19\] u_interface.u_compute_core.u_av.product_reg\[22\]
+ VGND VGND VPWR VPWR _2427_ sky130_fd_sc_hd__nor2_1
XFILLER_0_47_276 VGND VGND VPWR VPWR sky130_fd_sc_hd__decap_4
X_4839_ _1314_ _1390_ VGND VGND VPWR VPWR _1409_ sky130_fd_sc_hd__or2_1
XFILLER_0_35_449 VGND VGND VPWR VPWR sky130_fd_sc_hd__decap_8
XFILLER_0_50_419 VGND VGND VPWR VPWR sky130_fd_sc_hd__fill_1
XFILLER_0_30_176 VPWR VGND VPWR VGND sky130_ef_sc_hd__decap_12
XTAP_TAPCELL_ROW_74_904 VGND VPWR sky130_fd_sc_hd__tapvpwrvgnd_1
Xhold75 net51 VGND VGND VPWR VPWR net140 sky130_fd_sc_hd__dlygate4sd3_1
Xhold97 u_interface.u_compute_core.mac_accum\[3\] VGND VGND VPWR VPWR net162 sky130_fd_sc_hd__dlygate4sd3_1
Xhold86 u_interface.u_compute_core.mac_accum\[22\] VGND VGND VPWR VPWR net151 sky130_fd_sc_hd__dlygate4sd3_1
XTAP_TAPCELL_ROW_46_639 VGND VPWR sky130_fd_sc_hd__tapvpwrvgnd_1
XTAP_TAPCELL_ROW_82_981 VGND VPWR sky130_fd_sc_hd__tapvpwrvgnd_1
XFILLER_0_53_202 VPWR VGND VPWR VGND sky130_ef_sc_hd__decap_12
XFILLER_0_1_505 VPWR VGND VPWR VGND sky130_ef_sc_hd__decap_12
XFILLER_0_21_143 VPWR VGND VPWR VGND sky130_ef_sc_hd__decap_12
XFILLER_0_67_15 VPWR VGND VPWR VGND sky130_ef_sc_hd__decap_12
X_3170_ u_interface.u_compute_core.scaled_data\[1\] u_interface.u_compute_core.mac_accum\[4\]
+ _2669_ VGND VGND VPWR VPWR _2675_ sky130_fd_sc_hd__mux2_1
XTAP_TAPCELL_ROW_1_209 VGND VPWR sky130_fd_sc_hd__tapvpwrvgnd_1
Xrebuffer18 _0721_ VGND VGND VPWR VPWR net83 sky130_fd_sc_hd__dlymetal6s2s_1
Xrebuffer29 _1637_ VGND VGND VPWR VPWR net94 sky130_fd_sc_hd__dlygate4sd1_1
X_5811_ _2356_ _2357_ VGND VGND VPWR VPWR _2360_ sky130_fd_sc_hd__nand2_1
XTAP_TAPCELL_ROW_17_363 VGND VPWR sky130_fd_sc_hd__tapvpwrvgnd_1
XFILLER_0_29_210 VGND VGND VPWR VPWR sky130_fd_sc_hd__decap_6
XFILLER_0_29_221 VGND VGND VPWR VPWR sky130_fd_sc_hd__decap_3
XFILLER_0_8_104 VGND VGND VPWR VPWR sky130_fd_sc_hd__decap_8
X_5742_ u_interface.u_compute_core.u_av.product_reg\[31\] _0485_ _2299_ _2300_ _0855_
+ VGND VGND VPWR VPWR _0137_ sky130_fd_sc_hd__o221a_1
XFILLER_0_17_416 VGND VGND VPWR VPWR sky130_fd_sc_hd__decap_8
XFILLER_0_17_438 VGND VGND VPWR VPWR sky130_fd_sc_hd__decap_3
XFILLER_0_32_62 VPWR VGND VPWR VGND sky130_ef_sc_hd__decap_12
XFILLER_0_72_533 VPWR VGND VPWR VGND sky130_ef_sc_hd__decap_12
XFILLER_0_17_449 VPWR VGND VPWR VGND sky130_ef_sc_hd__decap_12
X_5673_ _1935_ _2232_ VGND VGND VPWR VPWR _2233_ sky130_fd_sc_hd__xor2_1
X_4624_ _1193_ _1194_ _1195_ VGND VGND VPWR VPWR _1197_ sky130_fd_sc_hd__a21o_1
XPHY_EDGE_ROW_6_Right_6 VGND VGND VPWR VPWR sky130_fd_sc_hd__decap_3
XFILLER_0_4_321 VPWR VGND VPWR VGND sky130_ef_sc_hd__decap_12
X_4555_ _1126_ _1127_ _1119_ VGND VGND VPWR VPWR _1129_ sky130_fd_sc_hd__a21o_1
XFILLER_0_4_365 VPWR VGND VPWR VGND sky130_ef_sc_hd__decap_12
XFILLER_0_25_493 VGND VGND VPWR VPWR sky130_fd_sc_hd__fill_1
X_3506_ net10 _2931_ net5 VGND VGND VPWR VPWR _2947_ sky130_fd_sc_hd__and3_1
X_4486_ _1058_ _1059_ _1060_ VGND VGND VPWR VPWR _1061_ sky130_fd_sc_hd__or3_4
XFILLER_0_40_474 VGND VGND VPWR VPWR sky130_fd_sc_hd__fill_2
XFILLER_0_40_496 VGND VGND VPWR VPWR sky130_fd_sc_hd__decap_4
X_6225_ clknet_leaf_18_clk _0138_ VGND VGND VPWR VPWR u_interface.core_attn_out\[0\]
+ sky130_fd_sc_hd__dfxtp_1
X_3437_ _2885_ _2886_ _2883_ _2884_ _2863_ VGND VGND VPWR VPWR _2889_ sky130_fd_sc_hd__a2111o_1
X_6156_ clknet_leaf_0_clk _0069_ VGND VGND VPWR VPWR u_interface.u_compute_core.mac_accum\[10\]
+ sky130_fd_sc_hd__dfxtp_1
X_3368_ _2781_ _2827_ _2829_ _2746_ net150 VGND VGND VPWR VPWR _0073_ sky130_fd_sc_hd__a32o_1
X_5107_ _1671_ _1672_ _1669_ VGND VGND VPWR VPWR _1674_ sky130_fd_sc_hd__o21ai_1
X_3299_ u_interface.u_compute_core.u_mac.product_reg\[5\] u_interface.u_compute_core.mac_accum\[5\]
+ VGND VGND VPWR VPWR _2770_ sky130_fd_sc_hd__nand2_1
X_6087_ clknet_leaf_8_clk _0000_ VGND VGND VPWR VPWR u_interface.u_compute_core.relu_data\[0\]
+ sky130_fd_sc_hd__dfxtp_1
XTAP_TAPCELL_ROW_84_1000 VGND VPWR sky130_fd_sc_hd__tapvpwrvgnd_1
X_5038_ _1521_ _1528_ _1527_ VGND VGND VPWR VPWR _1606_ sky130_fd_sc_hd__a21bo_1
XFILLER_0_67_349 VPWR VGND VPWR VGND sky130_ef_sc_hd__decap_12
XTAP_TAPCELL_ROW_43_609 VGND VPWR sky130_fd_sc_hd__tapvpwrvgnd_1
XTAP_TAPCELL_ROW_51_686 VGND VPWR sky130_fd_sc_hd__tapvpwrvgnd_1
XFILLER_0_90_363 VGND VGND VPWR VPWR sky130_fd_sc_hd__fill_1
XFILLER_0_35_279 VGND VGND VPWR VPWR sky130_fd_sc_hd__fill_1
XFILLER_0_16_471 VGND VGND VPWR VPWR sky130_fd_sc_hd__decap_4
XFILLER_0_50_238 VGND VGND VPWR VPWR sky130_fd_sc_hd__decap_3
Xoutput32 net32 VGND VGND VPWR VPWR m_tdata[13] sky130_fd_sc_hd__buf_2
Xoutput43 net43 VGND VGND VPWR VPWR m_tdata[23] sky130_fd_sc_hd__buf_2
Xoutput54 net54 VGND VGND VPWR VPWR m_tdata[4] sky130_fd_sc_hd__buf_2
XTAP_TAPCELL_ROW_59_764 VGND VPWR sky130_fd_sc_hd__tapvpwrvgnd_1
XFILLER_0_53_39 VPWR VGND VPWR VGND sky130_ef_sc_hd__decap_12
XTAP_TAPCELL_ROW_14_333 VGND VPWR sky130_fd_sc_hd__tapvpwrvgnd_1
XFILLER_0_54_533 VPWR VGND VPWR VGND sky130_ef_sc_hd__decap_12
XPHY_EDGE_ROW_59_Right_59 VGND VGND VPWR VPWR sky130_fd_sc_hd__decap_3
XFILLER_0_14_419 VGND VGND VPWR VPWR sky130_fd_sc_hd__fill_1
XFILLER_0_26_268 VGND VGND VPWR VPWR sky130_fd_sc_hd__fill_1
XFILLER_0_1_335 VGND VGND VPWR VPWR sky130_fd_sc_hd__fill_1
X_4340_ _0795_ _0810_ VGND VGND VPWR VPWR _0917_ sky130_fd_sc_hd__nor2_1
X_4271_ _0847_ _0848_ _0782_ _0849_ VGND VGND VPWR VPWR _0850_ sky130_fd_sc_hd__a211oi_1
X_6010_ _2516_ _2527_ VGND VGND VPWR VPWR _2528_ sky130_fd_sc_hd__and2_1
X_3222_ _2710_ VGND VGND VPWR VPWR _0046_ sky130_fd_sc_hd__clkbuf_1
XPHY_EDGE_ROW_68_Right_68 VGND VGND VPWR VPWR sky130_fd_sc_hd__decap_3
X_3153_ u_interface.u_compute_core.relu_data\[25\] VGND VGND VPWR VPWR _2663_ sky130_fd_sc_hd__inv_2
X_3084_ _2610_ VGND VGND VPWR VPWR _2611_ sky130_fd_sc_hd__buf_6
XFILLER_0_89_485 VPWR VGND VPWR VGND sky130_ef_sc_hd__decap_12
XFILLER_0_91_105 VGND VGND VPWR VPWR sky130_fd_sc_hd__decap_6
XPHY_EDGE_ROW_77_Right_77 VGND VGND VPWR VPWR sky130_fd_sc_hd__decap_3
X_3986_ _2735_ VGND VGND VPWR VPWR _0571_ sky130_fd_sc_hd__buf_2
XFILLER_0_91_149 VPWR VGND VPWR VGND sky130_ef_sc_hd__decap_12
XFILLER_0_72_341 VGND VGND VPWR VPWR sky130_fd_sc_hd__decap_3
X_5725_ _2282_ _2283_ VGND VGND VPWR VPWR _2284_ sky130_fd_sc_hd__xnor2_1
XFILLER_0_57_393 VPWR VGND VPWR VGND sky130_ef_sc_hd__decap_12
XFILLER_0_17_279 VGND VGND VPWR VPWR sky130_fd_sc_hd__fill_1
X_5656_ _2190_ _2191_ _2214_ VGND VGND VPWR VPWR _2216_ sky130_fd_sc_hd__or3_1
XFILLER_0_4_151 VGND VGND VPWR VPWR sky130_fd_sc_hd__decap_4
X_4607_ _1178_ net89 _1116_ VGND VGND VPWR VPWR _1181_ sky130_fd_sc_hd__a21oi_1
X_5587_ _2054_ _2143_ _2147_ VGND VGND VPWR VPWR _2148_ sky130_fd_sc_hd__a21oi_1
XFILLER_0_4_195 VGND VGND VPWR VPWR sky130_fd_sc_hd__fill_1
X_4538_ _1036_ _1039_ _1034_ VGND VGND VPWR VPWR _1113_ sky130_fd_sc_hd__a21oi_1
X_4469_ _1042_ _1032_ _1043_ VGND VGND VPWR VPWR _1044_ sky130_fd_sc_hd__a21o_1
XPHY_EDGE_ROW_86_Right_86 VGND VGND VPWR VPWR sky130_fd_sc_hd__decap_3
X_6208_ clknet_leaf_10_clk _0121_ VGND VGND VPWR VPWR u_interface.u_compute_core.u_av.product_reg\[15\]
+ sky130_fd_sc_hd__dfxtp_1
X_6139_ clknet_leaf_19_clk _0052_ VGND VGND VPWR VPWR u_interface.u_compute_core.scaled_data\[23\]
+ sky130_fd_sc_hd__dfxtp_1
XFILLER_0_84_90 VGND VGND VPWR VPWR sky130_fd_sc_hd__decap_3
XTAP_TAPCELL_ROW_56_734 VGND VPWR sky130_fd_sc_hd__tapvpwrvgnd_1
XTAP_TAPCELL_ROW_28_469 VGND VPWR sky130_fd_sc_hd__tapvpwrvgnd_1
XFILLER_0_67_179 VGND VGND VPWR VPWR sky130_fd_sc_hd__decap_8
XTAP_TAPCELL_ROW_11_303 VGND VPWR sky130_fd_sc_hd__tapvpwrvgnd_1
XFILLER_0_36_533 VPWR VGND VPWR VGND sky130_ef_sc_hd__decap_12
XFILLER_0_63_374 VGND VGND VPWR VPWR sky130_fd_sc_hd__decap_4
XFILLER_0_51_503 VGND VGND VPWR VPWR sky130_fd_sc_hd__fill_1
Xrebuffer9 _1464_ VGND VGND VPWR VPWR net74 sky130_fd_sc_hd__dlymetal6s2s_1
XFILLER_0_64_27 VGND VGND VPWR VPWR sky130_fd_sc_hd__fill_1
XFILLER_0_86_499 VGND VGND VPWR VPWR sky130_fd_sc_hd__decap_4
X_3840_ _0397_ _0401_ _0430_ VGND VGND VPWR VPWR _0432_ sky130_fd_sc_hd__or3_1
XFILLER_0_58_179 VPWR VGND VPWR VGND sky130_ef_sc_hd__decap_12
X_3771_ _3013_ _0300_ VGND VGND VPWR VPWR _0365_ sky130_fd_sc_hd__nand2_1
XFILLER_0_6_405 VPWR VGND VPWR VGND sky130_ef_sc_hd__decap_12
XFILLER_0_27_522 VPWR VGND VPWR VGND sky130_ef_sc_hd__decap_12
XFILLER_0_14_205 VGND VGND VPWR VPWR sky130_fd_sc_hd__fill_2
XFILLER_0_54_352 VGND VGND VPWR VPWR sky130_fd_sc_hd__fill_1
XFILLER_0_54_363 VGND VGND VPWR VPWR sky130_fd_sc_hd__fill_1
X_5510_ _2063_ _2071_ VGND VGND VPWR VPWR _2072_ sky130_fd_sc_hd__xnor2_1
XFILLER_0_89_57 VPWR VGND VPWR VGND sky130_ef_sc_hd__decap_12
XFILLER_0_81_193 VPWR VGND VPWR VGND sky130_ef_sc_hd__decap_12
X_5441_ _1996_ _2003_ VGND VGND VPWR VPWR _2004_ sky130_fd_sc_hd__xnor2_1
X_5372_ _1639_ _1845_ VGND VGND VPWR VPWR _1936_ sky130_fd_sc_hd__or2b_1
X_4323_ _0899_ _0900_ _0856_ VGND VGND VPWR VPWR _0901_ sky130_fd_sc_hd__o21ai_1
XFILLER_0_10_477 VPWR VGND VPWR VGND sky130_ef_sc_hd__decap_12
X_4254_ _0830_ _0831_ _0767_ VGND VGND VPWR VPWR _0833_ sky130_fd_sc_hd__o21ai_1
XFILLER_0_38_83 VGND VGND VPWR VPWR sky130_fd_sc_hd__fill_1
X_3205_ u_interface.u_compute_core.scaled_data\[12\] u_interface.u_compute_core.mac_accum\[15\]
+ _2691_ VGND VGND VPWR VPWR _2699_ sky130_fd_sc_hd__mux2_1
X_4185_ _0756_ _0763_ _0764_ VGND VGND VPWR VPWR _0765_ sky130_fd_sc_hd__nand3_1
X_3136_ _2650_ VGND VGND VPWR VPWR _2651_ sky130_fd_sc_hd__inv_2
X_3067_ u_interface.u_compute_core.relu_data\[4\] VGND VGND VPWR VPWR _2598_ sky130_fd_sc_hd__buf_4
XFILLER_0_77_411 VGND VGND VPWR VPWR sky130_fd_sc_hd__decap_3
XFILLER_0_49_113 VPWR VGND VPWR VGND sky130_ef_sc_hd__decap_12
XTAP_TAPCELL_ROW_53_704 VGND VPWR sky130_fd_sc_hd__tapvpwrvgnd_1
XTAP_TAPCELL_ROW_25_439 VGND VPWR sky130_fd_sc_hd__tapvpwrvgnd_1
XFILLER_0_9_243 VPWR VGND VPWR VGND sky130_ef_sc_hd__decap_12
XFILLER_0_18_500 VGND VGND VPWR VPWR sky130_fd_sc_hd__fill_1
XFILLER_0_18_522 VGND VGND VPWR VPWR sky130_fd_sc_hd__decap_8
XFILLER_0_18_533 VPWR VGND VPWR VGND sky130_ef_sc_hd__decap_12
XTAP_TAPCELL_ROW_61_781 VGND VPWR sky130_fd_sc_hd__tapvpwrvgnd_1
XFILLER_0_70_81 VGND VGND VPWR VPWR sky130_fd_sc_hd__decap_3
XFILLER_0_45_341 VPWR VGND VPWR VGND sky130_ef_sc_hd__decap_12
X_5708_ _2263_ _2266_ VGND VGND VPWR VPWR _2267_ sky130_fd_sc_hd__xnor2_1
X_3969_ _0527_ _0529_ _0526_ VGND VGND VPWR VPWR _0554_ sky130_fd_sc_hd__o21ba_1
X_5639_ _2125_ _2128_ _2126_ VGND VGND VPWR VPWR _2199_ sky130_fd_sc_hd__o21ba_1
XFILLER_0_60_377 VPWR VGND VPWR VGND sky130_ef_sc_hd__decap_12
XFILLER_0_13_293 VGND VGND VPWR VPWR sky130_fd_sc_hd__fill_1
Xhold150 u_interface.u_compute_core.mac_accum\[23\] VGND VGND VPWR VPWR net215 sky130_fd_sc_hd__dlygate4sd3_1
XFILLER_0_68_400 VPWR VGND VPWR VGND sky130_ef_sc_hd__decap_12
XFILLER_0_68_466 VGND VGND VPWR VPWR sky130_fd_sc_hd__fill_1
XFILLER_0_68_433 VGND VGND VPWR VPWR sky130_fd_sc_hd__decap_8
XFILLER_0_68_477 VPWR VGND VPWR VGND sky130_ef_sc_hd__decap_12
XFILLER_0_50_29 VPWR VGND VPWR VGND sky130_ef_sc_hd__decap_12
XFILLER_0_63_160 VGND VGND VPWR VPWR sky130_fd_sc_hd__fill_1
XFILLER_0_59_27 VGND VGND VPWR VPWR sky130_fd_sc_hd__decap_8
XFILLER_0_75_15 VPWR VGND VPWR VGND sky130_ef_sc_hd__decap_12
X_5990_ net28 u_interface.core_attn_out\[0\] _2512_ VGND VGND VPWR VPWR _2514_ sky130_fd_sc_hd__mux2_1
XFILLER_0_91_69 VPWR VGND VPWR VGND sky130_ef_sc_hd__decap_12
X_4941_ _1509_ _0502_ _0587_ _1209_ VGND VGND VPWR VPWR _1510_ sky130_fd_sc_hd__a22oi_2
X_4872_ _1217_ _1370_ VGND VGND VPWR VPWR _1442_ sky130_fd_sc_hd__nand2_1
XFILLER_0_24_63 VGND VGND VPWR VPWR sky130_fd_sc_hd__decap_3
XFILLER_0_24_85 VPWR VGND VPWR VGND sky130_ef_sc_hd__decap_12
XFILLER_0_59_488 VGND VGND VPWR VPWR sky130_fd_sc_hd__fill_1
X_3823_ _0378_ _0382_ _0376_ VGND VGND VPWR VPWR _0416_ sky130_fd_sc_hd__a21oi_1
XTAP_TAPCELL_ROW_22_409 VGND VPWR sky130_fd_sc_hd__tapvpwrvgnd_1
XFILLER_0_15_503 VGND VGND VPWR VPWR sky130_fd_sc_hd__fill_1
X_3754_ _0344_ _0348_ VGND VGND VPWR VPWR _0349_ sky130_fd_sc_hd__xnor2_1
XFILLER_0_42_322 VGND VGND VPWR VPWR sky130_fd_sc_hd__decap_8
XFILLER_0_61_119 VPWR VGND VPWR VGND sky130_ef_sc_hd__decap_12
X_3685_ _0236_ _0240_ _0280_ VGND VGND VPWR VPWR _0282_ sky130_fd_sc_hd__or3b_1
XTAP_TAPCELL_ROW_30_486 VGND VPWR sky130_fd_sc_hd__tapvpwrvgnd_1
X_5424_ _1982_ _1986_ VGND VGND VPWR VPWR _1987_ sky130_fd_sc_hd__xnor2_1
X_5355_ _1916_ _1917_ net71 VGND VGND VPWR VPWR _1919_ sky130_fd_sc_hd__a21o_1
XFILLER_0_10_230 VPWR VGND VPWR VGND sky130_ef_sc_hd__decap_12
XFILLER_0_57_3 VPWR VGND VPWR VGND sky130_ef_sc_hd__decap_12
X_5286_ _1848_ _1849_ _1765_ _1785_ VGND VGND VPWR VPWR _1851_ sky130_fd_sc_hd__a211o_1
XFILLER_0_49_93 VGND VGND VPWR VPWR sky130_fd_sc_hd__decap_8
X_4306_ _0805_ _0882_ _0883_ VGND VGND VPWR VPWR _0884_ sky130_fd_sc_hd__nand3_2
X_4237_ _0488_ VGND VGND VPWR VPWR _0816_ sky130_fd_sc_hd__clkbuf_4
XFILLER_0_4_62 VGND VGND VPWR VPWR sky130_fd_sc_hd__decap_3
XFILLER_0_69_208 VPWR VGND VPWR VGND sky130_ef_sc_hd__decap_12
XFILLER_0_65_70 VGND VGND VPWR VPWR sky130_fd_sc_hd__decap_3
X_4168_ _0620_ _0674_ VGND VGND VPWR VPWR _0748_ sky130_fd_sc_hd__nand2_1
X_3119_ _2637_ VGND VGND VPWR VPWR _2638_ sky130_fd_sc_hd__inv_2
XTAP_TAPCELL_ROW_38_564 VGND VPWR sky130_fd_sc_hd__tapvpwrvgnd_1
X_4099_ _0612_ _0515_ _0638_ _0680_ VGND VGND VPWR VPWR _0681_ sky130_fd_sc_hd__a31o_1
XFILLER_0_81_80 VGND VGND VPWR VPWR sky130_fd_sc_hd__decap_8
XFILLER_0_92_277 VGND VGND VPWR VPWR sky130_fd_sc_hd__decap_3
XFILLER_0_33_322 VGND VGND VPWR VPWR sky130_fd_sc_hd__fill_2
XFILLER_0_68_241 VGND VGND VPWR VPWR sky130_fd_sc_hd__fill_1
XFILLER_0_68_274 VPWR VGND VPWR VGND sky130_ef_sc_hd__decap_12
XFILLER_0_61_39 VGND VGND VPWR VPWR sky130_fd_sc_hd__decap_8
XTAP_TAPCELL_ROW_72_887 VGND VPWR sky130_fd_sc_hd__tapvpwrvgnd_1
XFILLER_0_83_255 VGND VGND VPWR VPWR sky130_fd_sc_hd__decap_6
XFILLER_0_43_108 VGND VGND VPWR VPWR sky130_fd_sc_hd__decap_4
XFILLER_0_3_216 VGND VGND VPWR VPWR sky130_fd_sc_hd__decap_8
XFILLER_0_24_344 VGND VGND VPWR VPWR sky130_fd_sc_hd__decap_6
XFILLER_0_36_182 VGND VGND VPWR VPWR sky130_fd_sc_hd__fill_2
XFILLER_0_36_193 VGND VGND VPWR VPWR sky130_fd_sc_hd__decap_3
XFILLER_0_12_517 VPWR VGND VPWR VGND sky130_ef_sc_hd__decap_12
XFILLER_0_3_249 VPWR VGND VPWR VGND sky130_ef_sc_hd__decap_12
X_3470_ _2909_ _2911_ _2915_ _2754_ VGND VGND VPWR VPWR _2917_ sky130_fd_sc_hd__a31o_1
XFILLER_0_86_69 VGND VGND VPWR VPWR sky130_fd_sc_hd__decap_4
X_5140_ _1630_ _1701_ VGND VGND VPWR VPWR _1706_ sky130_fd_sc_hd__or2b_4
X_5071_ _1623_ _1621_ VGND VGND VPWR VPWR _1638_ sky130_fd_sc_hd__nand2_2
XFILLER_0_19_63 VGND VGND VPWR VPWR sky130_fd_sc_hd__decap_4
X_4022_ _0573_ _0569_ _0605_ VGND VGND VPWR VPWR _0606_ sky130_fd_sc_hd__a21o_1
X_5973_ _2319_ _2500_ _2501_ _0855_ VGND VGND VPWR VPWR _0167_ sky130_fd_sc_hd__o211a_1
X_4924_ _1441_ _1461_ _1460_ VGND VGND VPWR VPWR _1493_ sky130_fd_sc_hd__o21bai_1
XTAP_TAPCELL_ROW_35_534 VGND VPWR sky130_fd_sc_hd__tapvpwrvgnd_1
XFILLER_0_19_138 VGND VGND VPWR VPWR sky130_fd_sc_hd__decap_4
XFILLER_0_47_436 VPWR VGND VPWR VGND sky130_ef_sc_hd__decap_12
X_4855_ _1367_ _1389_ VGND VGND VPWR VPWR _1425_ sky130_fd_sc_hd__or2_4
X_4786_ _1355_ _1354_ _1342_ VGND VGND VPWR VPWR _1357_ sky130_fd_sc_hd__a21o_1
X_3806_ _0396_ _0397_ _0398_ VGND VGND VPWR VPWR _0399_ sky130_fd_sc_hd__o21a_1
XFILLER_0_51_83 VGND VGND VPWR VPWR sky130_fd_sc_hd__fill_1
X_3737_ _3013_ _2992_ VGND VGND VPWR VPWR _0332_ sky130_fd_sc_hd__nand2_1
XFILLER_0_55_491 VGND VGND VPWR VPWR sky130_fd_sc_hd__decap_4
XFILLER_0_70_450 VGND VGND VPWR VPWR sky130_fd_sc_hd__fill_1
XFILLER_0_42_141 VGND VGND VPWR VPWR sky130_fd_sc_hd__decap_6
X_3668_ net18 VGND VGND VPWR VPWR _0265_ sky130_fd_sc_hd__buf_2
X_3599_ _2990_ _2999_ _3036_ VGND VGND VPWR VPWR _3037_ sky130_fd_sc_hd__or3_1
X_5407_ _1872_ _1969_ VGND VGND VPWR VPWR _1970_ sky130_fd_sc_hd__xnor2_1
X_5338_ _1882_ _1900_ _1901_ VGND VGND VPWR VPWR _1902_ sky130_fd_sc_hd__nand3_1
X_5269_ _1830_ _1831_ _1832_ VGND VGND VPWR VPWR _1834_ sky130_fd_sc_hd__a21o_1
XFILLER_0_38_414 VGND VGND VPWR VPWR sky130_fd_sc_hd__decap_6
XFILLER_0_25_108 VGND VGND VPWR VPWR sky130_fd_sc_hd__decap_4
XFILLER_0_33_130 VGND VGND VPWR VPWR sky130_fd_sc_hd__fill_1
XFILLER_0_0_219 VGND VGND VPWR VPWR sky130_fd_sc_hd__fill_1
XTAP_TAPCELL_ROW_77_935 VGND VPWR sky130_fd_sc_hd__tapvpwrvgnd_1
XFILLER_0_88_314 VGND VGND VPWR VPWR sky130_fd_sc_hd__decap_3
XFILLER_0_88_358 VGND VGND VPWR VPWR sky130_fd_sc_hd__decap_6
XFILLER_0_72_27 VGND VGND VPWR VPWR sky130_fd_sc_hd__fill_1
XTAP_TAPCELL_ROW_32_504 VGND VPWR sky130_fd_sc_hd__tapvpwrvgnd_1
XFILLER_0_56_244 VGND VGND VPWR VPWR sky130_fd_sc_hd__decap_8
X_4640_ _2637_ _0494_ _1212_ VGND VGND VPWR VPWR _1213_ sky130_fd_sc_hd__and3_1
XFILLER_0_4_525 VGND VGND VPWR VPWR sky130_fd_sc_hd__decap_6
XFILLER_0_21_53 VGND VGND VPWR VPWR sky130_fd_sc_hd__decap_3
X_4571_ _2619_ _0594_ VGND VGND VPWR VPWR _1145_ sky130_fd_sc_hd__nand2_1
XTAP_TAPCELL_ROW_40_581 VGND VPWR sky130_fd_sc_hd__tapvpwrvgnd_1
XFILLER_0_52_461 VPWR VGND VPWR VGND sky130_ef_sc_hd__decap_12
X_3522_ net24 _2961_ VGND VGND VPWR VPWR _2962_ sky130_fd_sc_hd__nand2_1
X_6241_ clknet_leaf_13_clk _0154_ VGND VGND VPWR VPWR u_interface.core_attn_out\[16\]
+ sky130_fd_sc_hd__dfxtp_1
X_3453_ net196 _2805_ _2901_ _2902_ VGND VGND VPWR VPWR _0085_ sky130_fd_sc_hd__a22o_1
X_6172_ clknet_leaf_19_clk _0085_ VGND VGND VPWR VPWR u_interface.u_compute_core.mac_accum\[26\]
+ sky130_fd_sc_hd__dfxtp_1
X_5123_ _1592_ _1612_ _1611_ VGND VGND VPWR VPWR _1690_ sky130_fd_sc_hd__a21bo_1
X_3384_ _2840_ _2842_ VGND VGND VPWR VPWR _2844_ sky130_fd_sc_hd__nand2_1
X_5054_ _1620_ _1619_ _1541_ _1543_ VGND VGND VPWR VPWR _1622_ sky130_fd_sc_hd__a211o_1
X_4005_ _0585_ _0588_ VGND VGND VPWR VPWR _0589_ sky130_fd_sc_hd__nor2_1
XFILLER_0_79_358 VGND VGND VPWR VPWR sky130_fd_sc_hd__decap_8
X_5956_ _2485_ _2486_ VGND VGND VPWR VPWR _2487_ sky130_fd_sc_hd__xnor2_1
XFILLER_0_47_200 VGND VGND VPWR VPWR sky130_fd_sc_hd__fill_1
X_5887_ net185 _2304_ _0981_ _2426_ VGND VGND VPWR VPWR _0156_ sky130_fd_sc_hd__o211a_1
XFILLER_0_35_406 VGND VGND VPWR VPWR sky130_fd_sc_hd__fill_1
X_4907_ _0982_ _1476_ VGND VGND VPWR VPWR _1477_ sky130_fd_sc_hd__xnor2_2
XFILLER_0_47_244 VPWR VGND VPWR VGND sky130_ef_sc_hd__decap_12
XFILLER_0_90_501 VPWR VGND VPWR VGND sky130_ef_sc_hd__decap_12
X_4838_ _0571_ _1406_ _1407_ _1408_ _0981_ VGND VGND VPWR VPWR _0125_ sky130_fd_sc_hd__o311a_1
XFILLER_0_62_203 VGND VGND VPWR VPWR sky130_fd_sc_hd__fill_1
XFILLER_0_90_545 VGND VGND VPWR VPWR sky130_fd_sc_hd__fill_2
XFILLER_0_62_225 VGND VGND VPWR VPWR sky130_fd_sc_hd__decap_8
X_4769_ _1321_ VGND VGND VPWR VPWR _1340_ sky130_fd_sc_hd__inv_2
XFILLER_0_30_188 VGND VGND VPWR VPWR sky130_fd_sc_hd__fill_1
XTAP_TAPCELL_ROW_74_905 VGND VPWR sky130_fd_sc_hd__tapvpwrvgnd_1
Xhold76 u_interface.u_compute_core.u_mac.product_reg\[3\] VGND VGND VPWR VPWR net141
+ sky130_fd_sc_hd__dlygate4sd3_1
Xhold98 u_interface.u_compute_core.mac_accum\[31\] VGND VGND VPWR VPWR net163 sky130_fd_sc_hd__dlygate4sd3_1
Xhold87 u_interface.u_compute_core.u_av.product_reg\[6\] VGND VGND VPWR VPWR net152
+ sky130_fd_sc_hd__dlygate4sd3_1
XTAP_TAPCELL_ROW_82_982 VGND VPWR sky130_fd_sc_hd__tapvpwrvgnd_1
XFILLER_0_66_531 VGND VGND VPWR VPWR sky130_fd_sc_hd__fill_1
XFILLER_0_53_214 VGND VGND VPWR VPWR sky130_fd_sc_hd__decap_6
XFILLER_0_1_517 VPWR VGND VPWR VGND sky130_ef_sc_hd__decap_12
XFILLER_0_21_111 VGND VGND VPWR VPWR sky130_fd_sc_hd__fill_1
XFILLER_0_21_155 VPWR VGND VPWR VGND sky130_ef_sc_hd__decap_12
XFILLER_0_67_27 VGND VGND VPWR VPWR sky130_fd_sc_hd__decap_8
XFILLER_0_83_15 VPWR VGND VPWR VGND sky130_ef_sc_hd__decap_12
Xrebuffer19 _1175_ VGND VGND VPWR VPWR net84 sky130_fd_sc_hd__clkbuf_2
XFILLER_0_16_53 VGND VGND VPWR VPWR sky130_fd_sc_hd__fill_2
XFILLER_0_88_166 VPWR VGND VPWR VGND sky130_ef_sc_hd__decap_12
XFILLER_0_88_155 VGND VGND VPWR VPWR sky130_fd_sc_hd__fill_2
XFILLER_0_76_317 VGND VGND VPWR VPWR sky130_fd_sc_hd__decap_3
X_5810_ _2320_ _2358_ _2359_ _2327_ VGND VGND VPWR VPWR _0146_ sky130_fd_sc_hd__o211a_1
XFILLER_0_91_309 VGND VGND VPWR VPWR sky130_fd_sc_hd__decap_8
XFILLER_0_69_391 VGND VGND VPWR VPWR sky130_fd_sc_hd__fill_1
XTAP_TAPCELL_ROW_17_364 VGND VPWR sky130_fd_sc_hd__tapvpwrvgnd_1
X_5741_ _2249_ _2248_ _2298_ _2735_ VGND VGND VPWR VPWR _2300_ sky130_fd_sc_hd__a31o_1
XFILLER_0_84_350 VPWR VGND VPWR VGND sky130_ef_sc_hd__decap_12
XFILLER_0_29_266 VGND VGND VPWR VPWR sky130_fd_sc_hd__fill_1
XFILLER_0_32_74 VGND VGND VPWR VPWR sky130_fd_sc_hd__decap_8
XFILLER_0_72_545 VGND VGND VPWR VPWR sky130_fd_sc_hd__fill_2
XFILLER_0_32_85 VPWR VGND VPWR VGND sky130_ef_sc_hd__decap_12
X_5672_ _1639_ _2231_ VGND VGND VPWR VPWR _2232_ sky130_fd_sc_hd__xor2_1
X_4623_ _1193_ _1194_ _1195_ VGND VGND VPWR VPWR _1196_ sky130_fd_sc_hd__nand3_1
XFILLER_0_4_333 VPWR VGND VPWR VGND sky130_ef_sc_hd__decap_12
X_4554_ _1119_ _1126_ _1127_ VGND VGND VPWR VPWR _1128_ sky130_fd_sc_hd__nand3_1
X_3505_ _2931_ _2935_ _2945_ _2929_ VGND VGND VPWR VPWR _2946_ sky130_fd_sc_hd__a22o_1
XFILLER_0_4_377 VPWR VGND VPWR VGND sky130_ef_sc_hd__decap_12
XFILLER_0_52_291 VPWR VGND VPWR VGND sky130_ef_sc_hd__decap_12
X_4485_ _2625_ _0488_ _0586_ _0927_ VGND VGND VPWR VPWR _1060_ sky130_fd_sc_hd__a22oi_2
X_6224_ clknet_leaf_12_clk _0137_ VGND VGND VPWR VPWR u_interface.u_compute_core.u_av.product_reg\[31\]
+ sky130_fd_sc_hd__dfxtp_2
X_3436_ _2887_ VGND VGND VPWR VPWR _2888_ sky130_fd_sc_hd__inv_2
X_6155_ clknet_leaf_0_clk _0068_ VGND VGND VPWR VPWR u_interface.u_compute_core.mac_accum\[9\]
+ sky130_fd_sc_hd__dfxtp_1
X_3367_ _2826_ _2828_ VGND VGND VPWR VPWR _2829_ sky130_fd_sc_hd__nand2_1
XFILLER_0_57_60 VGND VGND VPWR VPWR sky130_fd_sc_hd__decap_4
X_5106_ _1669_ _1671_ _1672_ VGND VGND VPWR VPWR _1673_ sky130_fd_sc_hd__or3_1
X_6086_ _2578_ VGND VGND VPWR VPWR _0203_ sky130_fd_sc_hd__clkbuf_1
X_5037_ _1602_ _1603_ _1595_ VGND VGND VPWR VPWR _1605_ sky130_fd_sc_hd__o21ai_1
X_3298_ u_interface.u_compute_core.u_mac.product_reg\[5\] u_interface.u_compute_core.mac_accum\[5\]
+ VGND VGND VPWR VPWR _2769_ sky130_fd_sc_hd__or2_1
XFILLER_0_79_111 VGND VGND VPWR VPWR sky130_fd_sc_hd__fill_1
XTAP_TAPCELL_ROW_84_1001 VGND VPWR sky130_fd_sc_hd__tapvpwrvgnd_1
XFILLER_0_79_155 VGND VGND VPWR VPWR sky130_fd_sc_hd__decap_3
XFILLER_0_82_309 VGND VGND VPWR VPWR sky130_fd_sc_hd__decap_4
XFILLER_0_48_531 VGND VGND VPWR VPWR sky130_fd_sc_hd__fill_1
XFILLER_0_75_361 VGND VGND VPWR VPWR sky130_fd_sc_hd__fill_1
XFILLER_0_75_350 VGND VGND VPWR VPWR sky130_fd_sc_hd__fill_1
X_5939_ _2468_ _2471_ VGND VGND VPWR VPWR _2472_ sky130_fd_sc_hd__xnor2_1
XFILLER_0_35_225 VPWR VGND VPWR VGND sky130_ef_sc_hd__decap_12
XFILLER_0_35_247 VPWR VGND VPWR VGND sky130_ef_sc_hd__decap_12
XTAP_TAPCELL_ROW_51_687 VGND VPWR sky130_fd_sc_hd__tapvpwrvgnd_1
Xoutput33 net33 VGND VGND VPWR VPWR m_tdata[14] sky130_fd_sc_hd__buf_2
XFILLER_0_31_497 VGND VGND VPWR VPWR sky130_fd_sc_hd__decap_6
XFILLER_0_9_3 VPWR VGND VPWR VGND sky130_ef_sc_hd__decap_12
Xoutput55 net55 VGND VGND VPWR VPWR m_tdata[5] sky130_fd_sc_hd__buf_2
Xoutput44 net44 VGND VGND VPWR VPWR m_tdata[24] sky130_fd_sc_hd__buf_2
XFILLER_0_58_306 VGND VGND VPWR VPWR sky130_fd_sc_hd__fill_2
XTAP_TAPCELL_ROW_14_334 VGND VPWR sky130_fd_sc_hd__tapvpwrvgnd_1
XFILLER_0_81_320 VPWR VGND VPWR VGND sky130_ef_sc_hd__decap_12
XFILLER_0_54_545 VGND VGND VPWR VPWR sky130_fd_sc_hd__fill_2
XFILLER_0_81_353 VGND VGND VPWR VPWR sky130_fd_sc_hd__fill_2
XFILLER_0_78_15 VPWR VGND VPWR VGND sky130_ef_sc_hd__decap_12
X_4270_ _0736_ _0782_ _0783_ VGND VGND VPWR VPWR _0849_ sky130_fd_sc_hd__nor3_2
X_3221_ _2694_ _2709_ VGND VGND VPWR VPWR _2710_ sky130_fd_sc_hd__and2_1
X_3152_ _2643_ _2662_ VGND VGND VPWR VPWR _0024_ sky130_fd_sc_hd__nor2_1
X_3083_ u_interface.u_compute_core.relu_data\[8\] VGND VGND VPWR VPWR _2610_ sky130_fd_sc_hd__buf_6
XFILLER_0_89_497 VGND VGND VPWR VPWR sky130_fd_sc_hd__decap_6
XFILLER_0_9_425 VGND VGND VPWR VPWR sky130_fd_sc_hd__fill_1
XFILLER_0_64_309 VPWR VGND VPWR VGND sky130_ef_sc_hd__decap_12
XFILLER_0_9_447 VGND VGND VPWR VPWR sky130_fd_sc_hd__fill_1
XFILLER_0_43_84 VPWR VGND VPWR VGND sky130_ef_sc_hd__decap_12
X_3985_ _0545_ _0542_ _0568_ VGND VGND VPWR VPWR _0570_ sky130_fd_sc_hd__or3_1
XFILLER_0_57_361 VGND VGND VPWR VPWR sky130_fd_sc_hd__fill_1
X_5724_ _1490_ _1563_ _1639_ _1935_ VGND VGND VPWR VPWR _2283_ sky130_fd_sc_hd__a2bb2o_1
XFILLER_0_17_225 VPWR VGND VPWR VGND sky130_ef_sc_hd__decap_12
XFILLER_0_72_353 VGND VGND VPWR VPWR sky130_fd_sc_hd__fill_2
X_5655_ _2190_ _2191_ _2214_ VGND VGND VPWR VPWR _2215_ sky130_fd_sc_hd__o21ai_1
XFILLER_0_60_504 VGND VGND VPWR VPWR sky130_fd_sc_hd__fill_2
XFILLER_0_60_515 VGND VGND VPWR VPWR sky130_fd_sc_hd__fill_2
XFILLER_0_87_3 VPWR VGND VPWR VGND sky130_ef_sc_hd__decap_12
XFILLER_0_4_141 VGND VGND VPWR VPWR sky130_fd_sc_hd__fill_1
X_4606_ _1178_ _1116_ _1179_ VGND VGND VPWR VPWR _1180_ sky130_fd_sc_hd__and3_1
X_5586_ _2145_ _2146_ VGND VGND VPWR VPWR _2147_ sky130_fd_sc_hd__or2_1
X_4537_ _1109_ _1111_ VGND VGND VPWR VPWR _1112_ sky130_fd_sc_hd__or2_1
X_4468_ _1030_ _1031_ VGND VGND VPWR VPWR _1043_ sky130_fd_sc_hd__and2b_1
XFILLER_0_0_391 VGND VGND VPWR VPWR sky130_fd_sc_hd__fill_1
X_6207_ clknet_leaf_10_clk _0120_ VGND VGND VPWR VPWR u_interface.u_compute_core.u_av.product_reg\[14\]
+ sky130_fd_sc_hd__dfxtp_1
X_3419_ _2871_ _2872_ VGND VGND VPWR VPWR _2873_ sky130_fd_sc_hd__nor2_1
X_6138_ clknet_leaf_19_clk _0051_ VGND VGND VPWR VPWR u_interface.u_compute_core.scaled_data\[22\]
+ sky130_fd_sc_hd__dfxtp_1
X_4399_ _0972_ _0974_ _0973_ VGND VGND VPWR VPWR _0976_ sky130_fd_sc_hd__and3_1
X_6069_ _2567_ VGND VGND VPWR VPWR _0197_ sky130_fd_sc_hd__clkbuf_1
XTAP_TAPCELL_ROW_56_735 VGND VPWR sky130_fd_sc_hd__tapvpwrvgnd_1
XFILLER_0_48_372 VGND VGND VPWR VPWR sky130_fd_sc_hd__fill_1
XTAP_TAPCELL_ROW_11_304 VGND VPWR sky130_fd_sc_hd__tapvpwrvgnd_1
XFILLER_0_36_545 VGND VGND VPWR VPWR sky130_fd_sc_hd__fill_2
XFILLER_0_48_29 VGND VGND VPWR VPWR sky130_fd_sc_hd__decap_8
XFILLER_0_86_456 VGND VGND VPWR VPWR sky130_fd_sc_hd__decap_4
XFILLER_0_86_445 VGND VGND VPWR VPWR sky130_fd_sc_hd__decap_3
XFILLER_0_80_27 VGND VGND VPWR VPWR sky130_fd_sc_hd__fill_1
XPHY_EDGE_ROW_17_Left_110 VGND VGND VPWR VPWR sky130_fd_sc_hd__decap_3
XFILLER_0_46_309 VPWR VGND VPWR VGND sky130_ef_sc_hd__decap_12
XFILLER_0_73_139 VGND VGND VPWR VPWR sky130_fd_sc_hd__decap_4
X_3770_ _0362_ _0363_ VGND VGND VPWR VPWR _0364_ sky130_fd_sc_hd__nor2_1
XFILLER_0_6_417 VGND VGND VPWR VPWR sky130_fd_sc_hd__decap_3
XFILLER_0_27_534 VGND VGND VPWR VPWR sky130_fd_sc_hd__decap_8
X_5440_ _1997_ _2002_ VGND VGND VPWR VPWR _2003_ sky130_fd_sc_hd__xor2_1
XFILLER_0_89_69 VPWR VGND VPWR VGND sky130_ef_sc_hd__decap_12
X_5371_ _1689_ VGND VGND VPWR VPWR _1935_ sky130_fd_sc_hd__clkbuf_4
XFILLER_0_1_144 VPWR VGND VPWR VGND sky130_ef_sc_hd__decap_12
XFILLER_0_22_283 VGND VGND VPWR VPWR sky130_fd_sc_hd__decap_8
X_4322_ _0894_ _0895_ _0898_ VGND VGND VPWR VPWR _0900_ sky130_fd_sc_hd__a21oi_1
XFILLER_0_1_199 VPWR VGND VPWR VGND sky130_ef_sc_hd__decap_12
X_4253_ _0767_ _0831_ _0830_ VGND VGND VPWR VPWR _0832_ sky130_fd_sc_hd__or3_4
XFILLER_0_38_40 VGND VGND VPWR VPWR sky130_fd_sc_hd__fill_2
X_3204_ _2698_ VGND VGND VPWR VPWR _0040_ sky130_fd_sc_hd__clkbuf_1
X_4184_ _0761_ _0762_ _0757_ VGND VGND VPWR VPWR _0764_ sky130_fd_sc_hd__a21o_1
X_3135_ u_interface.u_compute_core.relu_data\[20\] VGND VGND VPWR VPWR _2650_ sky130_fd_sc_hd__buf_2
X_3066_ _2582_ _2597_ VGND VGND VPWR VPWR _0003_ sky130_fd_sc_hd__nor2_1
XFILLER_0_89_272 VGND VGND VPWR VPWR sky130_fd_sc_hd__decap_8
XTAP_TAPCELL_ROW_53_705 VGND VPWR sky130_fd_sc_hd__tapvpwrvgnd_1
XFILLER_0_49_125 VGND VGND VPWR VPWR sky130_fd_sc_hd__decap_4
XFILLER_0_49_169 VGND VGND VPWR VPWR sky130_fd_sc_hd__decap_3
XFILLER_0_9_255 VPWR VGND VPWR VGND sky130_ef_sc_hd__decap_12
XFILLER_0_18_545 VGND VGND VPWR VPWR sky130_fd_sc_hd__fill_2
X_3968_ _0551_ _0552_ VGND VGND VPWR VPWR _0553_ sky130_fd_sc_hd__xnor2_1
XFILLER_0_45_353 VGND VGND VPWR VPWR sky130_fd_sc_hd__decap_8
X_5707_ _2264_ _2265_ VGND VGND VPWR VPWR _2266_ sky130_fd_sc_hd__xor2_1
XTAP_TAPCELL_ROW_61_782 VGND VPWR sky130_fd_sc_hd__tapvpwrvgnd_1
X_3899_ _2580_ VGND VGND VPWR VPWR _0486_ sky130_fd_sc_hd__buf_2
XFILLER_0_45_375 VGND VGND VPWR VPWR sky130_fd_sc_hd__decap_4
XFILLER_0_5_461 VPWR VGND VPWR VGND sky130_ef_sc_hd__decap_12
X_5638_ _2131_ _2134_ _2132_ VGND VGND VPWR VPWR _2198_ sky130_fd_sc_hd__o21ba_1
XFILLER_0_60_356 VGND VGND VPWR VPWR sky130_fd_sc_hd__decap_8
X_5569_ _2050_ _2052_ VGND VGND VPWR VPWR _2130_ sky130_fd_sc_hd__or2_1
XFILLER_0_60_389 VGND VGND VPWR VPWR sky130_fd_sc_hd__decap_3
Xhold140 u_interface.u_compute_core.mac_accum\[11\] VGND VGND VPWR VPWR net205 sky130_fd_sc_hd__dlygate4sd3_1
Xhold151 u_interface.u_compute_core.u_av.product_reg\[21\] VGND VGND VPWR VPWR net216
+ sky130_fd_sc_hd__dlygate4sd3_1
XFILLER_0_68_412 VGND VGND VPWR VPWR sky130_fd_sc_hd__decap_4
XFILLER_0_68_489 VGND VGND VPWR VPWR sky130_fd_sc_hd__fill_2
XFILLER_0_63_172 VGND VGND VPWR VPWR sky130_fd_sc_hd__decap_8
XFILLER_0_75_27 VPWR VGND VPWR VGND sky130_ef_sc_hd__decap_12
XFILLER_0_91_15 VPWR VGND VPWR VGND sky130_ef_sc_hd__decap_12
X_4940_ u_interface.u_compute_core.relu_data\[21\] VGND VGND VPWR VPWR _1509_ sky130_fd_sc_hd__clkbuf_4
X_4871_ _1440_ VGND VGND VPWR VPWR _1441_ sky130_fd_sc_hd__inv_2
XFILLER_0_86_275 VGND VGND VPWR VPWR sky130_fd_sc_hd__fill_2
XFILLER_0_74_426 VGND VGND VPWR VPWR sky130_fd_sc_hd__fill_2
X_3822_ _0408_ _0414_ VGND VGND VPWR VPWR _0415_ sky130_fd_sc_hd__xnor2_1
XFILLER_0_24_97 VGND VGND VPWR VPWR sky130_fd_sc_hd__fill_2
XFILLER_0_74_459 VGND VGND VPWR VPWR sky130_fd_sc_hd__decap_8
XFILLER_0_6_225 VPWR VGND VPWR VGND sky130_ef_sc_hd__decap_12
XFILLER_0_6_214 VGND VGND VPWR VPWR sky130_fd_sc_hd__fill_1
XFILLER_0_82_470 VGND VGND VPWR VPWR sky130_fd_sc_hd__decap_6
X_3753_ _0346_ _0347_ VGND VGND VPWR VPWR _0348_ sky130_fd_sc_hd__nor2_1
XFILLER_0_42_301 VGND VGND VPWR VPWR sky130_fd_sc_hd__decap_3
X_3684_ _0236_ _0240_ _0280_ VGND VGND VPWR VPWR _0281_ sky130_fd_sc_hd__o21ba_1
XTAP_TAPCELL_ROW_30_487 VGND VPWR sky130_fd_sc_hd__tapvpwrvgnd_1
XFILLER_0_40_85 VGND VGND VPWR VPWR sky130_fd_sc_hd__decap_4
XFILLER_0_54_194 VGND VGND VPWR VPWR sky130_fd_sc_hd__fill_2
X_5423_ _1806_ _1985_ VGND VGND VPWR VPWR _1986_ sky130_fd_sc_hd__xnor2_1
XFILLER_0_30_518 VPWR VGND VPWR VGND sky130_ef_sc_hd__decap_12
X_5354_ net71 _1916_ _1917_ VGND VGND VPWR VPWR _1918_ sky130_fd_sc_hd__nand3_1
XFILLER_0_2_475 VGND VGND VPWR VPWR sky130_fd_sc_hd__fill_1
XFILLER_0_10_253 VPWR VGND VPWR VGND sky130_ef_sc_hd__decap_12
XFILLER_0_10_242 VGND VGND VPWR VPWR sky130_fd_sc_hd__decap_8
X_4305_ _0880_ _0881_ _0874_ VGND VGND VPWR VPWR _0883_ sky130_fd_sc_hd__a21o_1
X_5285_ _1765_ _1785_ _1848_ _1849_ VGND VGND VPWR VPWR _1850_ sky130_fd_sc_hd__o211ai_1
XFILLER_0_4_41 VGND VGND VPWR VPWR sky130_fd_sc_hd__decap_8
X_4236_ _0759_ _0761_ VGND VGND VPWR VPWR _0815_ sky130_fd_sc_hd__nand2_1
XFILLER_0_4_85 VGND VGND VPWR VPWR sky130_fd_sc_hd__decap_8
X_4167_ _0745_ _0746_ VGND VGND VPWR VPWR _0747_ sky130_fd_sc_hd__or2_1
X_3118_ u_interface.u_compute_core.relu_data\[16\] VGND VGND VPWR VPWR _2637_ sky130_fd_sc_hd__buf_2
XTAP_TAPCELL_ROW_66_830 VGND VPWR sky130_fd_sc_hd__tapvpwrvgnd_1
X_4098_ _0600_ _0637_ VGND VGND VPWR VPWR _0680_ sky130_fd_sc_hd__nor2_1
XTAP_TAPCELL_ROW_38_565 VGND VPWR sky130_fd_sc_hd__tapvpwrvgnd_1
X_3049_ _2583_ VGND VGND VPWR VPWR _2584_ sky130_fd_sc_hd__clkbuf_2
XFILLER_0_77_286 VGND VGND VPWR VPWR sky130_fd_sc_hd__decap_6
XFILLER_0_18_331 VGND VGND VPWR VPWR sky130_fd_sc_hd__fill_1
XFILLER_0_60_175 VPWR VGND VPWR VGND sky130_ef_sc_hd__decap_12
XFILLER_0_60_197 VPWR VGND VPWR VGND sky130_ef_sc_hd__decap_12
XFILLER_0_83_201 VPWR VGND VPWR VGND sky130_ef_sc_hd__decap_12
XTAP_TAPCELL_ROW_72_888 VGND VPWR sky130_fd_sc_hd__tapvpwrvgnd_1
XFILLER_0_68_286 VGND VGND VPWR VPWR sky130_fd_sc_hd__fill_1
XFILLER_0_28_139 VGND VGND VPWR VPWR sky130_fd_sc_hd__fill_1
XFILLER_0_24_301 VGND VGND VPWR VPWR sky130_fd_sc_hd__decap_6
XFILLER_0_10_11 VGND VGND VPWR VPWR sky130_fd_sc_hd__fill_1
XFILLER_0_51_120 VGND VGND VPWR VPWR sky130_fd_sc_hd__decap_8
XFILLER_0_12_529 VGND VGND VPWR VPWR sky130_fd_sc_hd__decap_3
XFILLER_0_12_507 VGND VGND VPWR VPWR sky130_fd_sc_hd__fill_1
XFILLER_0_51_175 VPWR VGND VPWR VGND sky130_ef_sc_hd__decap_12
XFILLER_0_86_15 VPWR VGND VPWR VGND sky130_ef_sc_hd__decap_12
XFILLER_0_19_53 VGND VGND VPWR VPWR sky130_fd_sc_hd__decap_3
X_5070_ _1627_ _1042_ _1636_ VGND VGND VPWR VPWR _1637_ sky130_fd_sc_hd__a21o_1
X_4021_ _0576_ _0604_ VGND VGND VPWR VPWR _0605_ sky130_fd_sc_hd__xor2_1
XFILLER_0_35_52 VGND VGND VPWR VPWR sky130_fd_sc_hd__decap_4
XTAP_TAPCELL_ROW_63_800 VGND VPWR sky130_fd_sc_hd__tapvpwrvgnd_1
X_5972_ u_interface.core_attn_out\[29\] _2308_ VGND VGND VPWR VPWR _2501_ sky130_fd_sc_hd__or2_1
XFILLER_0_35_63 VGND VGND VPWR VPWR sky130_fd_sc_hd__fill_2
X_4923_ _1490_ _1421_ _1491_ VGND VGND VPWR VPWR _1492_ sky130_fd_sc_hd__o21ai_2
XTAP_TAPCELL_ROW_35_535 VGND VPWR sky130_fd_sc_hd__tapvpwrvgnd_1
XFILLER_0_59_264 VGND VGND VPWR VPWR sky130_fd_sc_hd__decap_3
X_4854_ _1410_ _1423_ VGND VGND VPWR VPWR _1424_ sky130_fd_sc_hd__xnor2_1
XFILLER_0_51_51 VGND VGND VPWR VPWR sky130_fd_sc_hd__fill_2
X_4785_ _1342_ _1354_ _1355_ VGND VGND VPWR VPWR _1356_ sky130_fd_sc_hd__nand3_2
X_3805_ _3013_ _0265_ VGND VGND VPWR VPWR _0398_ sky130_fd_sc_hd__nand2_1
XFILLER_0_62_418 VGND VGND VPWR VPWR sky130_fd_sc_hd__fill_2
X_3736_ _0329_ _0330_ VGND VGND VPWR VPWR _0331_ sky130_fd_sc_hd__nor2_1
XFILLER_0_70_495 VGND VGND VPWR VPWR sky130_fd_sc_hd__decap_8
X_3667_ _0262_ _0263_ VGND VGND VPWR VPWR _0264_ sky130_fd_sc_hd__or2_1
XFILLER_0_30_337 VGND VGND VPWR VPWR sky130_fd_sc_hd__fill_1
XFILLER_0_42_197 VGND VGND VPWR VPWR sky130_fd_sc_hd__decap_6
X_3598_ _3034_ _3035_ VGND VGND VPWR VPWR _3036_ sky130_fd_sc_hd__or2_1
X_5406_ _1967_ _1968_ VGND VGND VPWR VPWR _1969_ sky130_fd_sc_hd__xnor2_1
X_5337_ _1898_ _1899_ _1883_ VGND VGND VPWR VPWR _1901_ sky130_fd_sc_hd__a21o_1
X_5268_ _1830_ _1831_ _1832_ VGND VGND VPWR VPWR _1833_ sky130_fd_sc_hd__nand3_1
X_4219_ _2611_ _2615_ _0499_ _0489_ VGND VGND VPWR VPWR _0798_ sky130_fd_sc_hd__and4_1
X_5199_ _1719_ _1720_ _1763_ _1764_ VGND VGND VPWR VPWR _1765_ sky130_fd_sc_hd__o211a_1
XFILLER_0_38_404 VGND VGND VPWR VPWR sky130_fd_sc_hd__decap_3
XFILLER_0_80_215 VGND VGND VPWR VPWR sky130_fd_sc_hd__fill_2
XFILLER_0_18_172 VGND VGND VPWR VPWR sky130_fd_sc_hd__fill_2
XFILLER_0_33_164 VGND VGND VPWR VPWR sky130_fd_sc_hd__decap_4
XFILLER_0_56_29 VPWR VGND VPWR VGND sky130_ef_sc_hd__decap_12
XTAP_TAPCELL_ROW_6_260 VGND VPWR sky130_fd_sc_hd__tapvpwrvgnd_1
XFILLER_0_69_540 VGND VGND VPWR VPWR sky130_fd_sc_hd__decap_6
XTAP_TAPCELL_ROW_32_505 VGND VPWR sky130_fd_sc_hd__tapvpwrvgnd_1
XFILLER_0_56_278 VPWR VGND VPWR VGND sky130_ef_sc_hd__decap_12
X_4570_ _1058_ _1060_ _1059_ VGND VGND VPWR VPWR _1144_ sky130_fd_sc_hd__o21bai_1
X_3521_ net15 VGND VGND VPWR VPWR _2961_ sky130_fd_sc_hd__buf_2
XTAP_TAPCELL_ROW_40_582 VGND VPWR sky130_fd_sc_hd__tapvpwrvgnd_1
XFILLER_0_12_304 VGND VGND VPWR VPWR sky130_fd_sc_hd__fill_1
XFILLER_0_24_197 VGND VGND VPWR VPWR sky130_fd_sc_hd__decap_4
XFILLER_0_52_473 VGND VGND VPWR VPWR sky130_fd_sc_hd__decap_3
X_6240_ clknet_leaf_18_clk _0153_ VGND VGND VPWR VPWR u_interface.core_attn_out\[15\]
+ sky130_fd_sc_hd__dfxtp_1
X_3452_ _2900_ _2895_ _2896_ _2740_ VGND VGND VPWR VPWR _2902_ sky130_fd_sc_hd__o31a_1
X_6171_ clknet_leaf_19_clk _0084_ VGND VGND VPWR VPWR u_interface.u_compute_core.mac_accum\[25\]
+ sky130_fd_sc_hd__dfxtp_1
X_3383_ _2840_ _2842_ VGND VGND VPWR VPWR _2843_ sky130_fd_sc_hd__or2_1
X_5122_ _1688_ VGND VGND VPWR VPWR _1689_ sky130_fd_sc_hd__clkbuf_4
XFILLER_0_20_381 VGND VGND VPWR VPWR sky130_fd_sc_hd__fill_1
X_5053_ _1541_ _1543_ _1619_ _1620_ VGND VGND VPWR VPWR _1621_ sky130_fd_sc_hd__o211ai_2
X_4004_ _2595_ _0489_ _0587_ u_interface.u_compute_core.relu_data\[2\] VGND VGND VPWR
+ VPWR _0588_ sky130_fd_sc_hd__a22oi_1
XPHY_EDGE_ROW_9_Left_102 VGND VGND VPWR VPWR sky130_fd_sc_hd__decap_3
XTAP_TAPCELL_ROW_48_660 VGND VPWR sky130_fd_sc_hd__tapvpwrvgnd_1
XFILLER_0_75_510 VGND VGND VPWR VPWR sky130_fd_sc_hd__fill_2
X_5955_ _2476_ _2480_ VGND VGND VPWR VPWR _2486_ sky130_fd_sc_hd__or2_1
X_4906_ _1475_ _1474_ VGND VGND VPWR VPWR _1476_ sky130_fd_sc_hd__nor2_4
X_5886_ _2424_ _2425_ _2319_ VGND VGND VPWR VPWR _2426_ sky130_fd_sc_hd__a21o_1
XFILLER_0_47_256 VGND VGND VPWR VPWR sky130_fd_sc_hd__fill_1
XFILLER_0_90_513 VPWR VGND VPWR VGND sky130_ef_sc_hd__decap_12
X_4837_ u_interface.u_compute_core.relu_valid u_interface.u_compute_core.u_av.product_reg\[19\]
+ VGND VGND VPWR VPWR _1408_ sky130_fd_sc_hd__or2_1
XFILLER_0_7_353 VGND VGND VPWR VPWR sky130_fd_sc_hd__decap_4
X_4768_ _1330_ _1334_ VGND VGND VPWR VPWR _1339_ sky130_fd_sc_hd__nand2_1
X_4699_ _1270_ _1269_ _1268_ VGND VGND VPWR VPWR _1271_ sky130_fd_sc_hd__or3_4
XFILLER_0_15_164 VGND VGND VPWR VPWR sky130_fd_sc_hd__decap_4
X_3719_ _0262_ _0273_ _0314_ VGND VGND VPWR VPWR _0315_ sky130_fd_sc_hd__o21ai_1
XTAP_TAPCELL_ROW_74_906 VGND VPWR sky130_fd_sc_hd__tapvpwrvgnd_1
XTAP_TAPCELL_ROW_3_230 VGND VPWR sky130_fd_sc_hd__tapvpwrvgnd_1
Xhold77 u_interface.u_compute_core.u_mac.product_reg\[6\] VGND VGND VPWR VPWR net142
+ sky130_fd_sc_hd__dlygate4sd3_1
Xhold99 u_interface.u_compute_core.u_mac.product_reg\[5\] VGND VGND VPWR VPWR net164
+ sky130_fd_sc_hd__dlygate4sd3_1
Xhold88 u_interface.core_attn_out\[20\] VGND VGND VPWR VPWR net153 sky130_fd_sc_hd__dlygate4sd3_1
XFILLER_0_66_510 VGND VGND VPWR VPWR sky130_fd_sc_hd__decap_4
XFILLER_0_38_201 VGND VGND VPWR VPWR sky130_fd_sc_hd__fill_1
XTAP_TAPCELL_ROW_82_983 VGND VPWR sky130_fd_sc_hd__tapvpwrvgnd_1
XFILLER_0_53_248 VPWR VGND VPWR VGND sky130_ef_sc_hd__decap_12
XFILLER_0_61_281 VGND VGND VPWR VPWR sky130_fd_sc_hd__decap_6
XFILLER_0_1_529 VPWR VGND VPWR VGND sky130_ef_sc_hd__decap_12
XFILLER_0_21_167 VGND VGND VPWR VPWR sky130_fd_sc_hd__fill_1
XFILLER_0_83_27 VPWR VGND VPWR VGND sky130_ef_sc_hd__decap_12
XTAP_TAPCELL_ROW_45_630 VGND VPWR sky130_fd_sc_hd__tapvpwrvgnd_1
XFILLER_0_88_178 VPWR VGND VPWR VGND sky130_ef_sc_hd__decap_12
XFILLER_0_29_201 VGND VGND VPWR VPWR sky130_fd_sc_hd__fill_1
XTAP_TAPCELL_ROW_17_365 VGND VPWR sky130_fd_sc_hd__tapvpwrvgnd_1
X_5740_ _2248_ _2249_ _2298_ VGND VGND VPWR VPWR _2299_ sky130_fd_sc_hd__a21oi_1
XFILLER_0_84_362 VGND VGND VPWR VPWR sky130_fd_sc_hd__fill_2
XFILLER_0_8_139 VGND VGND VPWR VPWR sky130_fd_sc_hd__fill_1
XFILLER_0_32_53 VGND VGND VPWR VPWR sky130_fd_sc_hd__decap_6
XFILLER_0_84_395 VPWR VGND VPWR VGND sky130_ef_sc_hd__decap_12
XFILLER_0_32_97 VPWR VGND VPWR VGND sky130_ef_sc_hd__decap_12
X_5671_ _2229_ _2230_ VGND VGND VPWR VPWR _2231_ sky130_fd_sc_hd__nand2_1
X_4622_ _1143_ _1151_ _1150_ VGND VGND VPWR VPWR _1195_ sky130_fd_sc_hd__a21o_1
XFILLER_0_4_301 VGND VGND VPWR VPWR sky130_fd_sc_hd__decap_6
X_4553_ _1123_ _1124_ _1125_ VGND VGND VPWR VPWR _1127_ sky130_fd_sc_hd__a21o_1
XFILLER_0_4_345 VPWR VGND VPWR VGND sky130_ef_sc_hd__decap_12
XFILLER_0_40_421 VGND VGND VPWR VPWR sky130_fd_sc_hd__fill_2
X_4484_ u_interface.u_compute_core.relu_data\[12\] _0927_ net20 net21 VGND VGND VPWR
+ VPWR _1059_ sky130_fd_sc_hd__and4_1
XFILLER_0_4_389 VPWR VGND VPWR VGND sky130_ef_sc_hd__decap_12
X_3504_ net5 VGND VGND VPWR VPWR _2945_ sky130_fd_sc_hd__buf_2
XFILLER_0_12_156 VGND VGND VPWR VPWR sky130_fd_sc_hd__fill_1
X_3435_ _2863_ _2883_ _2884_ _2885_ _2886_ VGND VGND VPWR VPWR _2887_ sky130_fd_sc_hd__o311a_1
X_6223_ clknet_leaf_12_clk _0136_ VGND VGND VPWR VPWR u_interface.u_compute_core.u_av.product_reg\[30\]
+ sky130_fd_sc_hd__dfxtp_1
X_6154_ clknet_leaf_0_clk _0067_ VGND VGND VPWR VPWR u_interface.u_compute_core.mac_accum\[8\]
+ sky130_fd_sc_hd__dfxtp_1
X_3366_ _2818_ _2823_ _2820_ VGND VGND VPWR VPWR _2828_ sky130_fd_sc_hd__a21o_1
X_5105_ net118 _1600_ _1670_ VGND VGND VPWR VPWR _1672_ sky130_fd_sc_hd__a21oi_1
X_6085_ _2670_ _2577_ VGND VGND VPWR VPWR _2578_ sky130_fd_sc_hd__and2_1
X_3297_ _2763_ _2766_ VGND VGND VPWR VPWR _2768_ sky130_fd_sc_hd__and2_1
X_5036_ _1595_ _1602_ _1603_ VGND VGND VPWR VPWR _1604_ sky130_fd_sc_hd__or3_4
XFILLER_0_79_123 VGND VGND VPWR VPWR sky130_fd_sc_hd__decap_6
XTAP_TAPCELL_ROW_0_200 VGND VPWR sky130_fd_sc_hd__tapvpwrvgnd_1
XTAP_TAPCELL_ROW_84_1002 VGND VPWR sky130_fd_sc_hd__tapvpwrvgnd_1
XFILLER_0_67_318 VGND VGND VPWR VPWR sky130_fd_sc_hd__decap_4
X_5938_ _2469_ _2470_ VGND VGND VPWR VPWR _2471_ sky130_fd_sc_hd__nor2_1
X_5869_ _2408_ _2410_ VGND VGND VPWR VPWR _2411_ sky130_fd_sc_hd__or2_1
XFILLER_0_35_237 VGND VGND VPWR VPWR sky130_fd_sc_hd__decap_6
XTAP_TAPCELL_ROW_51_688 VGND VPWR sky130_fd_sc_hd__tapvpwrvgnd_1
XFILLER_0_35_259 VPWR VGND VPWR VGND sky130_ef_sc_hd__decap_12
XFILLER_0_90_398 VGND VGND VPWR VPWR sky130_fd_sc_hd__fill_2
XFILLER_0_31_432 VGND VGND VPWR VPWR sky130_fd_sc_hd__decap_3
XFILLER_0_31_443 VGND VGND VPWR VPWR sky130_fd_sc_hd__decap_4
XFILLER_0_43_281 VPWR VGND VPWR VGND sky130_ef_sc_hd__decap_12
Xoutput34 net34 VGND VGND VPWR VPWR m_tdata[15] sky130_fd_sc_hd__buf_2
Xoutput56 net56 VGND VGND VPWR VPWR m_tdata[6] sky130_fd_sc_hd__buf_2
Xoutput45 net45 VGND VGND VPWR VPWR m_tdata[25] sky130_fd_sc_hd__buf_2
XFILLER_0_85_126 VGND VGND VPWR VPWR sky130_fd_sc_hd__decap_6
XTAP_TAPCELL_ROW_42_600 VGND VPWR sky130_fd_sc_hd__tapvpwrvgnd_1
XTAP_TAPCELL_ROW_14_335 VGND VPWR sky130_fd_sc_hd__tapvpwrvgnd_1
XFILLER_0_81_332 VGND VGND VPWR VPWR sky130_fd_sc_hd__decap_4
XFILLER_0_66_384 VGND VGND VPWR VPWR sky130_fd_sc_hd__decap_4
XFILLER_0_78_49 VGND VGND VPWR VPWR sky130_fd_sc_hd__decap_3
XFILLER_0_78_27 VGND VGND VPWR VPWR sky130_fd_sc_hd__fill_1
XFILLER_0_1_337 VPWR VGND VPWR VGND sky130_ef_sc_hd__decap_12
XFILLER_0_22_498 VGND VGND VPWR VPWR sky130_fd_sc_hd__fill_1
X_3220_ u_interface.u_compute_core.scaled_data\[17\] u_interface.u_compute_core.mac_accum\[20\]
+ _2691_ VGND VGND VPWR VPWR _2709_ sky130_fd_sc_hd__mux2_1
X_3151_ u_interface.u_compute_core.scaled_data\[24\] _2583_ _2661_ _2586_ VGND VGND
+ VPWR VPWR _2662_ sky130_fd_sc_hd__o2bb2a_1
XFILLER_0_27_75 VGND VGND VPWR VPWR sky130_fd_sc_hd__fill_1
XFILLER_0_27_86 VGND VGND VPWR VPWR sky130_fd_sc_hd__decap_4
X_3082_ _2581_ VGND VGND VPWR VPWR _2609_ sky130_fd_sc_hd__clkbuf_4
XFILLER_0_17_204 VGND VGND VPWR VPWR sky130_fd_sc_hd__fill_1
XFILLER_0_43_96 VPWR VGND VPWR VGND sky130_ef_sc_hd__decap_12
X_3984_ _0545_ _0542_ _0568_ VGND VGND VPWR VPWR _0569_ sky130_fd_sc_hd__o21ai_1
XFILLER_0_45_502 VGND VGND VPWR VPWR sky130_fd_sc_hd__fill_2
XFILLER_0_72_321 VGND VGND VPWR VPWR sky130_fd_sc_hd__decap_8
XFILLER_0_17_237 VGND VGND VPWR VPWR sky130_fd_sc_hd__fill_1
X_5723_ _2281_ _2221_ _2219_ VGND VGND VPWR VPWR _2282_ sky130_fd_sc_hd__a21oi_1
X_5654_ _2209_ _2213_ VGND VGND VPWR VPWR _2214_ sky130_fd_sc_hd__xor2_1
X_4605_ net99 _1176_ _0918_ VGND VGND VPWR VPWR _1179_ sky130_fd_sc_hd__o21ai_1
XFILLER_0_60_527 VGND VGND VPWR VPWR sky130_fd_sc_hd__decap_4
XFILLER_0_4_175 VGND VGND VPWR VPWR sky130_fd_sc_hd__decap_4
X_5585_ _2068_ _2144_ _1981_ VGND VGND VPWR VPWR _2146_ sky130_fd_sc_hd__a21oi_1
XFILLER_0_7_52 VGND VGND VPWR VPWR sky130_fd_sc_hd__fill_1
XFILLER_0_4_197 VGND VGND VPWR VPWR sky130_fd_sc_hd__decap_4
XFILLER_0_40_251 VGND VGND VPWR VPWR sky130_fd_sc_hd__fill_1
X_4536_ _1110_ VGND VGND VPWR VPWR _1111_ sky130_fd_sc_hd__inv_2
XFILLER_0_7_96 VGND VGND VPWR VPWR sky130_fd_sc_hd__decap_8
X_4467_ _0904_ VGND VGND VPWR VPWR _1042_ sky130_fd_sc_hd__clkbuf_4
XTAP_TAPCELL_ROW_90_1050 VGND VPWR sky130_fd_sc_hd__tapvpwrvgnd_1
XFILLER_0_68_82 VGND VGND VPWR VPWR sky130_fd_sc_hd__fill_2
X_6206_ clknet_leaf_10_clk _0119_ VGND VGND VPWR VPWR u_interface.u_compute_core.u_av.product_reg\[13\]
+ sky130_fd_sc_hd__dfxtp_1
X_3418_ u_interface.u_compute_core.u_mac.product_reg\[15\] u_interface.u_compute_core.mac_accum\[22\]
+ VGND VGND VPWR VPWR _2872_ sky130_fd_sc_hd__and2_1
X_4398_ _0972_ _0973_ _0974_ VGND VGND VPWR VPWR _0975_ sky130_fd_sc_hd__a21oi_1
X_3349_ u_interface.u_compute_core.u_mac.product_reg\[12\] u_interface.u_compute_core.mac_accum\[12\]
+ VGND VGND VPWR VPWR _2813_ sky130_fd_sc_hd__or2_1
X_6137_ clknet_leaf_19_clk _0050_ VGND VGND VPWR VPWR u_interface.u_compute_core.scaled_data\[21\]
+ sky130_fd_sc_hd__dfxtp_1
X_6068_ _2670_ _2566_ VGND VGND VPWR VPWR _2567_ sky130_fd_sc_hd__and2_1
X_5019_ _1581_ _1586_ VGND VGND VPWR VPWR _1587_ sky130_fd_sc_hd__xor2_1
XTAP_TAPCELL_ROW_56_736 VGND VPWR sky130_fd_sc_hd__tapvpwrvgnd_1
XFILLER_0_48_351 VPWR VGND VPWR VGND sky130_ef_sc_hd__decap_12
XFILLER_0_36_524 VGND VGND VPWR VPWR sky130_fd_sc_hd__decap_8
XTAP_TAPCELL_ROW_11_305 VGND VPWR sky130_fd_sc_hd__tapvpwrvgnd_1
XFILLER_0_90_162 VGND VGND VPWR VPWR sky130_fd_sc_hd__decap_3
XFILLER_0_90_195 VGND VGND VPWR VPWR sky130_fd_sc_hd__fill_1
XFILLER_0_64_29 VPWR VGND VPWR VGND sky130_ef_sc_hd__decap_12
XFILLER_0_86_402 VPWR VGND VPWR VGND sky130_ef_sc_hd__decap_12
XFILLER_0_58_115 VGND VGND VPWR VPWR sky130_fd_sc_hd__decap_6
XTAP_TAPCELL_ROW_27_460 VGND VPWR sky130_fd_sc_hd__tapvpwrvgnd_1
XFILLER_0_13_55 VGND VGND VPWR VPWR sky130_fd_sc_hd__fill_1
XFILLER_0_89_15 VPWR VGND VPWR VGND sky130_ef_sc_hd__decap_12
XFILLER_0_81_151 VPWR VGND VPWR VGND sky130_ef_sc_hd__decap_12
X_5370_ _1931_ _1932_ net88 _1868_ VGND VGND VPWR VPWR _1934_ sky130_fd_sc_hd__a211oi_1
XFILLER_0_1_134 VGND VGND VPWR VPWR sky130_fd_sc_hd__fill_1
XFILLER_0_1_156 VPWR VGND VPWR VGND sky130_ef_sc_hd__decap_12
X_4321_ _0898_ _0894_ _0895_ VGND VGND VPWR VPWR _0899_ sky130_fd_sc_hd__and3_1
X_4252_ _0828_ _0829_ _0814_ VGND VGND VPWR VPWR _0831_ sky130_fd_sc_hd__a21oi_1
X_3203_ _2694_ _2697_ VGND VGND VPWR VPWR _2698_ sky130_fd_sc_hd__and2_1
XFILLER_0_38_85 VPWR VGND VPWR VGND sky130_ef_sc_hd__decap_12
X_4183_ _0757_ _0761_ _0762_ VGND VGND VPWR VPWR _0763_ sky130_fd_sc_hd__nand3_1
X_3134_ _2643_ _2649_ VGND VGND VPWR VPWR _0019_ sky130_fd_sc_hd__nor2_1
X_3065_ u_interface.u_compute_core.scaled_data\[3\] _2584_ _2596_ _2587_ VGND VGND
+ VPWR VPWR _2597_ sky130_fd_sc_hd__o2bb2a_1
XTAP_TAPCELL_ROW_53_706 VGND VPWR sky130_fd_sc_hd__tapvpwrvgnd_1
XFILLER_0_89_295 VGND VGND VPWR VPWR sky130_fd_sc_hd__decap_6
XFILLER_0_49_148 VGND VGND VPWR VPWR sky130_fd_sc_hd__decap_6
XFILLER_0_92_405 VPWR VGND VPWR VGND sky130_ef_sc_hd__decap_12
XFILLER_0_92_449 VPWR VGND VPWR VGND sky130_ef_sc_hd__decap_12
XFILLER_0_9_267 VPWR VGND VPWR VGND sky130_ef_sc_hd__decap_12
X_3967_ _2589_ _0535_ VGND VGND VPWR VPWR _0552_ sky130_fd_sc_hd__nand2_1
XFILLER_0_45_332 VGND VGND VPWR VPWR sky130_fd_sc_hd__decap_4
X_5706_ u_interface.u_compute_core.relu_data\[26\] _0559_ VGND VGND VPWR VPWR _2265_
+ sky130_fd_sc_hd__nand2_1
XTAP_TAPCELL_ROW_61_783 VGND VPWR sky130_fd_sc_hd__tapvpwrvgnd_1
X_3898_ u_interface.u_compute_core.relu_valid VGND VGND VPWR VPWR _0485_ sky130_fd_sc_hd__clkbuf_4
XFILLER_0_5_473 VPWR VGND VPWR VGND sky130_ef_sc_hd__decap_12
X_5637_ _2195_ _2196_ VGND VGND VPWR VPWR _2197_ sky130_fd_sc_hd__xnor2_1
X_5568_ _2127_ _2128_ VGND VGND VPWR VPWR _2129_ sky130_fd_sc_hd__xnor2_1
X_4519_ _1091_ _1092_ _1075_ VGND VGND VPWR VPWR _1094_ sky130_fd_sc_hd__a21o_1
Xhold141 u_interface.core_attn_out\[0\] VGND VGND VPWR VPWR net206 sky130_fd_sc_hd__dlygate4sd3_1
Xhold130 u_interface.u_compute_core.mac_accum\[5\] VGND VGND VPWR VPWR net195 sky130_fd_sc_hd__dlygate4sd3_1
Xhold152 u_interface.u_compute_core.u_av.product_reg\[24\] VGND VGND VPWR VPWR net217
+ sky130_fd_sc_hd__dlygate4sd3_1
X_5499_ _1981_ _1987_ _2060_ VGND VGND VPWR VPWR _2061_ sky130_fd_sc_hd__a21o_1
XFILLER_0_83_449 VGND VGND VPWR VPWR sky130_fd_sc_hd__decap_4
XTAP_TAPCELL_ROW_24_430 VGND VPWR sky130_fd_sc_hd__tapvpwrvgnd_1
Xclkbuf_leaf_21_clk clknet_1_1__leaf_clk VGND VGND VPWR VPWR clknet_leaf_21_clk sky130_fd_sc_hd__clkbuf_8
XFILLER_0_36_365 VGND VGND VPWR VPWR sky130_fd_sc_hd__decap_4
XFILLER_0_75_39 VGND VGND VPWR VPWR sky130_fd_sc_hd__fill_1
XFILLER_0_91_27 VPWR VGND VPWR VGND sky130_ef_sc_hd__decap_12
XFILLER_0_59_435 VPWR VGND VPWR VGND sky130_ef_sc_hd__decap_12
X_4870_ _1383_ _1385_ VGND VGND VPWR VPWR _1440_ sky130_fd_sc_hd__nand2_1
XFILLER_0_59_457 VPWR VGND VPWR VGND sky130_ef_sc_hd__decap_12
X_3821_ _0413_ VGND VGND VPWR VPWR _0414_ sky130_fd_sc_hd__clkbuf_2
XFILLER_0_46_129 VGND VGND VPWR VPWR sky130_fd_sc_hd__fill_1
XFILLER_0_15_505 VPWR VGND VPWR VGND sky130_ef_sc_hd__decap_12
X_3752_ _0269_ _0345_ VGND VGND VPWR VPWR _0347_ sky130_fd_sc_hd__and2_1
XFILLER_0_6_237 VPWR VGND VPWR VGND sky130_ef_sc_hd__decap_12
Xclkbuf_leaf_12_clk clknet_1_1__leaf_clk VGND VGND VPWR VPWR clknet_leaf_12_clk sky130_fd_sc_hd__clkbuf_8
X_3683_ _0278_ _0279_ VGND VGND VPWR VPWR _0280_ sky130_fd_sc_hd__xor2_1
XTAP_TAPCELL_ROW_30_488 VGND VPWR sky130_fd_sc_hd__tapvpwrvgnd_1
X_5422_ _1983_ _1984_ VGND VGND VPWR VPWR _1985_ sky130_fd_sc_hd__nor2_1
XFILLER_0_2_421 VPWR VGND VPWR VGND sky130_ef_sc_hd__decap_12
X_5353_ _1913_ _1914_ _1915_ VGND VGND VPWR VPWR _1917_ sky130_fd_sc_hd__a21o_1
XFILLER_0_49_51 VGND VGND VPWR VPWR sky130_fd_sc_hd__decap_4
X_4304_ _0874_ _0880_ _0881_ VGND VGND VPWR VPWR _0882_ sky130_fd_sc_hd__nand3_1
X_5284_ _1843_ _1844_ _1847_ VGND VGND VPWR VPWR _1849_ sky130_fd_sc_hd__o21ai_1
XFILLER_0_10_265 VGND VGND VPWR VPWR sky130_fd_sc_hd__decap_8
X_4235_ _0763_ _0765_ VGND VGND VPWR VPWR _0814_ sky130_fd_sc_hd__nand2_1
X_4166_ _2619_ _0515_ _0744_ VGND VGND VPWR VPWR _0746_ sky130_fd_sc_hd__a21oi_1
X_3117_ _2609_ _2636_ VGND VGND VPWR VPWR _0015_ sky130_fd_sc_hd__nor2_1
XTAP_TAPCELL_ROW_66_831 VGND VPWR sky130_fd_sc_hd__tapvpwrvgnd_1
X_4097_ _0678_ _0654_ VGND VGND VPWR VPWR _0679_ sky130_fd_sc_hd__xor2_1
XFILLER_0_77_232 VGND VGND VPWR VPWR sky130_fd_sc_hd__decap_3
X_3048_ u_interface.u_compute_core.scaled_data\[28\] u_interface.u_compute_core.scaled_valid
+ VGND VGND VPWR VPWR _2583_ sky130_fd_sc_hd__nor2b_2
XFILLER_0_77_265 VGND VGND VPWR VPWR sky130_fd_sc_hd__fill_1
XFILLER_0_65_405 VGND VGND VPWR VPWR sky130_fd_sc_hd__decap_8
XFILLER_0_65_449 VPWR VGND VPWR VGND sky130_ef_sc_hd__decap_12
XFILLER_0_65_438 VGND VGND VPWR VPWR sky130_fd_sc_hd__decap_8
XFILLER_0_92_235 VPWR VGND VPWR VGND sky130_ef_sc_hd__decap_12
X_4999_ _1518_ _1536_ _1535_ VGND VGND VPWR VPWR _1567_ sky130_fd_sc_hd__a21boi_1
XTAP_TAPCELL_ROW_21_400 VGND VPWR sky130_fd_sc_hd__tapvpwrvgnd_1
XFILLER_0_80_419 VGND VGND VPWR VPWR sky130_fd_sc_hd__fill_1
XFILLER_0_18_365 VPWR VGND VPWR VGND sky130_ef_sc_hd__decap_12
XFILLER_0_33_335 VGND VGND VPWR VPWR sky130_fd_sc_hd__fill_1
XPHY_EDGE_ROW_36_Left_129 VGND VGND VPWR VPWR sky130_fd_sc_hd__decap_3
XFILLER_0_60_121 VPWR VGND VPWR VGND sky130_ef_sc_hd__decap_12
XFILLER_0_5_281 VPWR VGND VPWR VGND sky130_ef_sc_hd__decap_12
XFILLER_0_60_187 VGND VGND VPWR VPWR sky130_fd_sc_hd__decap_8
XFILLER_0_41_390 VGND VGND VPWR VPWR sky130_fd_sc_hd__fill_2
XPHY_EDGE_ROW_45_Left_138 VGND VGND VPWR VPWR sky130_fd_sc_hd__decap_3
XFILLER_0_68_210 VGND VGND VPWR VPWR sky130_fd_sc_hd__decap_4
XFILLER_0_83_213 VGND VGND VPWR VPWR sky130_fd_sc_hd__decap_8
XPHY_EDGE_ROW_54_Left_147 VGND VGND VPWR VPWR sky130_fd_sc_hd__decap_3
XFILLER_0_24_379 VGND VGND VPWR VPWR sky130_fd_sc_hd__fill_1
XFILLER_0_51_187 VGND VGND VPWR VPWR sky130_fd_sc_hd__fill_1
XFILLER_0_86_27 VGND VGND VPWR VPWR sky130_fd_sc_hd__fill_1
XFILLER_0_20_541 VGND VGND VPWR VPWR sky130_fd_sc_hd__fill_2
XFILLER_0_19_32 VPWR VGND VPWR VGND sky130_ef_sc_hd__decap_12
XPHY_EDGE_ROW_63_Left_156 VGND VGND VPWR VPWR sky130_fd_sc_hd__decap_3
Xclkbuf_leaf_1_clk clknet_1_0__leaf_clk VGND VGND VPWR VPWR clknet_leaf_1_clk sky130_fd_sc_hd__clkbuf_8
X_4020_ _0602_ _0603_ VGND VGND VPWR VPWR _0604_ sky130_fd_sc_hd__xnor2_1
XTAP_TAPCELL_ROW_63_801 VGND VPWR sky130_fd_sc_hd__tapvpwrvgnd_1
X_5971_ _2496_ _2499_ VGND VGND VPWR VPWR _2500_ sky130_fd_sc_hd__xnor2_1
X_4922_ _1414_ _1420_ VGND VGND VPWR VPWR _1491_ sky130_fd_sc_hd__or2_1
XFILLER_0_87_541 VGND VGND VPWR VPWR sky130_fd_sc_hd__decap_6
XTAP_TAPCELL_ROW_35_536 VGND VPWR sky130_fd_sc_hd__tapvpwrvgnd_1
XFILLER_0_59_276 VGND VGND VPWR VPWR sky130_fd_sc_hd__decap_4
X_4853_ _1413_ _1422_ VGND VGND VPWR VPWR _1423_ sky130_fd_sc_hd__xnor2_1
XFILLER_0_74_257 VGND VGND VPWR VPWR sky130_fd_sc_hd__decap_6
XPHY_EDGE_ROW_72_Left_165 VGND VGND VPWR VPWR sky130_fd_sc_hd__decap_3
XFILLER_0_47_449 VPWR VGND VPWR VGND sky130_ef_sc_hd__decap_12
X_4784_ _1352_ _1353_ _1302_ VGND VGND VPWR VPWR _1355_ sky130_fd_sc_hd__a21o_1
X_3804_ _2992_ _3014_ _0300_ net9 VGND VGND VPWR VPWR _0397_ sky130_fd_sc_hd__and4b_1
XFILLER_0_62_408 VGND VGND VPWR VPWR sky130_fd_sc_hd__decap_3
XFILLER_0_15_335 VGND VGND VPWR VPWR sky130_fd_sc_hd__fill_1
X_3735_ _2961_ _3014_ _0328_ VGND VGND VPWR VPWR _0330_ sky130_fd_sc_hd__and3_1
XFILLER_0_70_463 VPWR VGND VPWR VGND sky130_ef_sc_hd__decap_12
X_3666_ _0261_ _0248_ VGND VGND VPWR VPWR _0263_ sky130_fd_sc_hd__and2b_1
XFILLER_0_2_240 VPWR VGND VPWR VGND sky130_ef_sc_hd__decap_12
X_5405_ u_interface.u_compute_core.relu_data\[22\] _0559_ VGND VGND VPWR VPWR _1968_
+ sky130_fd_sc_hd__nand2_1
X_3597_ _3024_ _3033_ VGND VGND VPWR VPWR _3035_ sky130_fd_sc_hd__and2_1
XFILLER_0_62_3 VPWR VGND VPWR VGND sky130_ef_sc_hd__decap_12
XPHY_EDGE_ROW_81_Left_174 VGND VGND VPWR VPWR sky130_fd_sc_hd__decap_3
X_5336_ _1883_ _1898_ _1899_ VGND VGND VPWR VPWR _1900_ sky130_fd_sc_hd__nand3_1
X_5267_ _1669_ _1751_ _1750_ VGND VGND VPWR VPWR _1832_ sky130_fd_sc_hd__o21bai_1
X_4218_ _0612_ _0535_ VGND VGND VPWR VPWR _0797_ sky130_fd_sc_hd__nand2_1
X_5198_ _1761_ _1762_ _1746_ VGND VGND VPWR VPWR _1764_ sky130_fd_sc_hd__a21o_1
XTAP_TAPCELL_ROW_87_1022 VGND VPWR sky130_fd_sc_hd__tapvpwrvgnd_1
X_4149_ _0693_ _0729_ VGND VGND VPWR VPWR _0730_ sky130_fd_sc_hd__xor2_2
XFILLER_0_92_81 VGND VGND VPWR VPWR sky130_fd_sc_hd__decap_3
XPHY_EDGE_ROW_90_Left_183 VGND VGND VPWR VPWR sky130_fd_sc_hd__decap_3
XFILLER_0_38_438 VPWR VGND VPWR VGND sky130_ef_sc_hd__decap_12
XFILLER_0_80_205 VGND VGND VPWR VPWR sky130_fd_sc_hd__fill_1
XFILLER_0_65_279 VGND VGND VPWR VPWR sky130_fd_sc_hd__fill_1
XFILLER_0_33_121 VGND VGND VPWR VPWR sky130_fd_sc_hd__fill_1
Xclkload0 clknet_1_0__leaf_clk VGND VGND VPWR VPWR clkload0/X sky130_fd_sc_hd__clkbuf_8
XFILLER_0_61_441 VGND VGND VPWR VPWR sky130_fd_sc_hd__decap_6
XTAP_TAPCELL_ROW_6_261 VGND VPWR sky130_fd_sc_hd__tapvpwrvgnd_1
XPHY_EDGE_ROW_3_Left_96 VGND VGND VPWR VPWR sky130_fd_sc_hd__decap_3
XFILLER_0_72_29 VGND VGND VPWR VPWR sky130_fd_sc_hd__decap_4
XFILLER_0_56_213 VGND VGND VPWR VPWR sky130_fd_sc_hd__decap_4
XFILLER_0_84_533 VPWR VGND VPWR VGND sky130_ef_sc_hd__decap_12
XTAP_TAPCELL_ROW_32_506 VGND VPWR sky130_fd_sc_hd__tapvpwrvgnd_1
XFILLER_0_56_235 VGND VGND VPWR VPWR sky130_fd_sc_hd__fill_2
XFILLER_0_44_419 VGND VGND VPWR VPWR sky130_fd_sc_hd__fill_1
XFILLER_0_21_44 VGND VGND VPWR VPWR sky130_fd_sc_hd__decap_3
X_3520_ _2930_ _2949_ VGND VGND VPWR VPWR _2960_ sky130_fd_sc_hd__nand2_1
XTAP_TAPCELL_ROW_40_583 VGND VPWR sky130_fd_sc_hd__tapvpwrvgnd_1
X_3451_ _2895_ _2896_ _2900_ VGND VGND VPWR VPWR _2901_ sky130_fd_sc_hd__o21ai_1
X_6170_ clknet_leaf_2_clk _0083_ VGND VGND VPWR VPWR u_interface.u_compute_core.mac_accum\[24\]
+ sky130_fd_sc_hd__dfxtp_1
X_3382_ _2824_ _2827_ _2831_ _2841_ VGND VGND VPWR VPWR _2842_ sky130_fd_sc_hd__a31o_1
X_5121_ _1490_ _1497_ _1563_ VGND VGND VPWR VPWR _1688_ sky130_fd_sc_hd__o21a_1
X_5052_ _1617_ _1618_ _1569_ VGND VGND VPWR VPWR _1620_ sky130_fd_sc_hd__o21ai_1
XFILLER_0_79_305 VPWR VGND VPWR VGND sky130_ef_sc_hd__decap_12
XFILLER_0_46_85 VPWR VGND VPWR VGND sky130_ef_sc_hd__decap_12
X_4003_ _0586_ VGND VGND VPWR VPWR _0587_ sky130_fd_sc_hd__clkbuf_4
XFILLER_0_87_371 VPWR VGND VPWR VGND sky130_ef_sc_hd__decap_12
X_5954_ _2483_ _2484_ VGND VGND VPWR VPWR _2485_ sky130_fd_sc_hd__nand2_1
XFILLER_0_87_393 VPWR VGND VPWR VGND sky130_ef_sc_hd__decap_12
X_4905_ _1473_ _1472_ net87 net133 VGND VGND VPWR VPWR _1475_ sky130_fd_sc_hd__a211oi_4
X_5885_ _2415_ _2423_ _2422_ VGND VGND VPWR VPWR _2425_ sky130_fd_sc_hd__a21bo_1
X_4836_ _1338_ _1339_ _1403_ _1405_ VGND VGND VPWR VPWR _1407_ sky130_fd_sc_hd__and4_1
XFILLER_0_90_525 VGND VGND VPWR VPWR sky130_fd_sc_hd__decap_6
XFILLER_0_28_493 VPWR VGND VPWR VGND sky130_ef_sc_hd__decap_12
XFILLER_0_15_132 VGND VGND VPWR VPWR sky130_fd_sc_hd__decap_3
X_4767_ _1328_ _1329_ VGND VGND VPWR VPWR _1338_ sky130_fd_sc_hd__nand2_1
XFILLER_0_43_463 VPWR VGND VPWR VGND sky130_ef_sc_hd__decap_12
X_4698_ _1189_ _1197_ _1196_ VGND VGND VPWR VPWR _1270_ sky130_fd_sc_hd__a21boi_1
X_3718_ _0309_ _0313_ VGND VGND VPWR VPWR _0314_ sky130_fd_sc_hd__xnor2_1
XFILLER_0_30_102 VGND VGND VPWR VPWR sky130_fd_sc_hd__fill_1
X_3649_ _2890_ _0245_ _0246_ _2745_ net156 VGND VGND VPWR VPWR _0098_ sky130_fd_sc_hd__a32o_1
XFILLER_0_30_157 VGND VGND VPWR VPWR sky130_fd_sc_hd__fill_1
X_5319_ _1813_ _1815_ VGND VGND VPWR VPWR _1883_ sky130_fd_sc_hd__nand2_1
XTAP_TAPCELL_ROW_74_907 VGND VPWR sky130_fd_sc_hd__tapvpwrvgnd_1
XTAP_TAPCELL_ROW_3_231 VGND VPWR sky130_fd_sc_hd__tapvpwrvgnd_1
Xhold78 u_interface.u_compute_core.u_mac.product_reg\[10\] VGND VGND VPWR VPWR net143
+ sky130_fd_sc_hd__dlygate4sd3_1
Xhold89 u_interface.u_compute_core.u_av.product_reg\[22\] VGND VGND VPWR VPWR net154
+ sky130_fd_sc_hd__dlygate4sd3_1
XFILLER_0_85_319 VGND VGND VPWR VPWR sky130_fd_sc_hd__decap_4
XFILLER_0_66_500 VGND VGND VPWR VPWR sky130_fd_sc_hd__fill_2
XFILLER_0_78_393 VGND VGND VPWR VPWR sky130_fd_sc_hd__decap_3
XFILLER_0_66_533 VPWR VGND VPWR VGND sky130_ef_sc_hd__decap_12
XFILLER_0_81_503 VGND VGND VPWR VPWR sky130_fd_sc_hd__fill_1
XFILLER_0_34_463 VGND VGND VPWR VPWR sky130_fd_sc_hd__fill_1
XFILLER_0_21_113 VGND VGND VPWR VPWR sky130_fd_sc_hd__decap_8
XFILLER_0_83_39 VGND VGND VPWR VPWR sky130_fd_sc_hd__fill_1
XFILLER_0_88_102 VGND VGND VPWR VPWR sky130_fd_sc_hd__fill_1
XFILLER_0_16_22 VGND VGND VPWR VPWR sky130_fd_sc_hd__decap_6
XFILLER_0_88_135 VGND VGND VPWR VPWR sky130_fd_sc_hd__decap_4
XTAP_TAPCELL_ROW_45_631 VGND VPWR sky130_fd_sc_hd__tapvpwrvgnd_1
XFILLER_0_29_235 VGND VGND VPWR VPWR sky130_fd_sc_hd__fill_1
XFILLER_0_29_279 VGND VGND VPWR VPWR sky130_fd_sc_hd__fill_1
XFILLER_0_44_205 VGND VGND VPWR VPWR sky130_fd_sc_hd__decap_3
X_5670_ _2162_ _2157_ VGND VGND VPWR VPWR _2230_ sky130_fd_sc_hd__or2b_1
X_4621_ _1010_ _1191_ _1192_ VGND VGND VPWR VPWR _1194_ sky130_fd_sc_hd__nand3_2
XFILLER_0_44_238 VGND VGND VPWR VPWR sky130_fd_sc_hd__decap_6
X_4552_ _1123_ _1124_ _1125_ VGND VGND VPWR VPWR _1126_ sky130_fd_sc_hd__nand3_1
XFILLER_0_12_102 VGND VGND VPWR VPWR sky130_fd_sc_hd__fill_1
XFILLER_0_4_357 VGND VGND VPWR VPWR sky130_fd_sc_hd__decap_6
XFILLER_0_52_260 VGND VGND VPWR VPWR sky130_fd_sc_hd__decap_6
X_4483_ _2619_ _0556_ VGND VGND VPWR VPWR _1058_ sky130_fd_sc_hd__nand2_1
XFILLER_0_12_113 VGND VGND VPWR VPWR sky130_fd_sc_hd__fill_1
X_3503_ _2928_ _2929_ _2932_ _2938_ VGND VGND VPWR VPWR _2944_ sky130_fd_sc_hd__and4_1
X_3434_ _2833_ u_interface.u_compute_core.mac_accum\[24\] VGND VGND VPWR VPWR _2886_
+ sky130_fd_sc_hd__nand2_1
X_6222_ clknet_leaf_12_clk _0135_ VGND VGND VPWR VPWR u_interface.u_compute_core.u_av.product_reg\[29\]
+ sky130_fd_sc_hd__dfxtp_1
X_6153_ clknet_leaf_2_clk _0066_ VGND VGND VPWR VPWR u_interface.u_compute_core.mac_accum\[7\]
+ sky130_fd_sc_hd__dfxtp_1
X_3365_ _2818_ _2823_ _2820_ _2826_ VGND VGND VPWR VPWR _2827_ sky130_fd_sc_hd__a211o_1
X_5104_ _1599_ _1600_ _1670_ VGND VGND VPWR VPWR _1671_ sky130_fd_sc_hd__and3_1
X_6084_ net52 u_interface.core_attn_out\[31\] u_interface.core_valid_out VGND VGND
+ VPWR VPWR _2577_ sky130_fd_sc_hd__mux2_1
X_3296_ _2741_ _2766_ _2767_ _2746_ net159 VGND VGND VPWR VPWR _0063_ sky130_fd_sc_hd__a32o_1
XFILLER_0_57_95 VGND VGND VPWR VPWR sky130_fd_sc_hd__fill_1
X_5035_ _1599_ _1600_ _1601_ VGND VGND VPWR VPWR _1603_ sky130_fd_sc_hd__a21oi_1
XTAP_TAPCELL_ROW_0_201 VGND VPWR sky130_fd_sc_hd__tapvpwrvgnd_1
XFILLER_0_25_3 VPWR VGND VPWR VGND sky130_ef_sc_hd__decap_12
X_5937_ u_interface.core_attn_out\[25\] u_interface.u_compute_core.u_av.product_reg\[28\]
+ VGND VGND VPWR VPWR _2470_ sky130_fd_sc_hd__and2_1
XFILLER_0_48_533 VPWR VGND VPWR VGND sky130_ef_sc_hd__decap_12
XFILLER_0_63_503 VGND VGND VPWR VPWR sky130_fd_sc_hd__fill_1
X_5868_ _2401_ _2409_ VGND VGND VPWR VPWR _2410_ sky130_fd_sc_hd__or2_1
X_4819_ _1367_ _1389_ VGND VGND VPWR VPWR _1390_ sky130_fd_sc_hd__xnor2_1
X_5799_ _2336_ _2343_ _2344_ _2341_ VGND VGND VPWR VPWR _2350_ sky130_fd_sc_hd__o31ai_2
XFILLER_0_7_184 VPWR VGND VPWR VGND sky130_ef_sc_hd__decap_12
XFILLER_0_7_151 VGND VGND VPWR VPWR sky130_fd_sc_hd__fill_1
XFILLER_0_16_441 VGND VGND VPWR VPWR sky130_fd_sc_hd__fill_2
XFILLER_0_43_271 VGND VGND VPWR VPWR sky130_fd_sc_hd__decap_8
XFILLER_0_43_293 VGND VGND VPWR VPWR sky130_fd_sc_hd__decap_8
XFILLER_0_31_477 VPWR VGND VPWR VGND sky130_ef_sc_hd__decap_12
Xoutput57 net57 VGND VGND VPWR VPWR m_tdata[7] sky130_fd_sc_hd__buf_2
Xoutput46 net46 VGND VGND VPWR VPWR m_tdata[26] sky130_fd_sc_hd__buf_2
Xoutput35 net35 VGND VGND VPWR VPWR m_tdata[16] sky130_fd_sc_hd__buf_2
XTAP_TAPCELL_ROW_59_756 VGND VPWR sky130_fd_sc_hd__tapvpwrvgnd_1
XPHY_EDGE_ROW_19_Right_19 VGND VGND VPWR VPWR sky130_fd_sc_hd__decap_3
XTAP_TAPCELL_ROW_42_601 VGND VPWR sky130_fd_sc_hd__tapvpwrvgnd_1
XFILLER_0_66_363 VGND VGND VPWR VPWR sky130_fd_sc_hd__fill_1
XTAP_TAPCELL_ROW_14_336 VGND VPWR sky130_fd_sc_hd__tapvpwrvgnd_1
XFILLER_0_54_514 VGND VGND VPWR VPWR sky130_fd_sc_hd__fill_1
XFILLER_0_1_305 VPWR VGND VPWR VGND sky130_ef_sc_hd__decap_12
XFILLER_0_1_349 VPWR VGND VPWR VGND sky130_ef_sc_hd__decap_12
XPHY_EDGE_ROW_28_Right_28 VGND VGND VPWR VPWR sky130_fd_sc_hd__decap_3
X_3150_ _2660_ VGND VGND VPWR VPWR _2661_ sky130_fd_sc_hd__inv_2
X_3081_ _2582_ _2608_ VGND VGND VPWR VPWR _0007_ sky130_fd_sc_hd__nor2_1
XFILLER_0_89_411 VGND VGND VPWR VPWR sky130_fd_sc_hd__decap_3
XFILLER_0_27_98 VGND VGND VPWR VPWR sky130_fd_sc_hd__decap_3
XPHY_EDGE_ROW_37_Right_37 VGND VGND VPWR VPWR sky130_fd_sc_hd__decap_3
XFILLER_0_69_190 VPWR VGND VPWR VGND sky130_ef_sc_hd__decap_12
XFILLER_0_43_64 VGND VGND VPWR VPWR sky130_fd_sc_hd__decap_3
XFILLER_0_9_449 VGND VGND VPWR VPWR sky130_fd_sc_hd__decap_8
X_3983_ _0566_ _0567_ VGND VGND VPWR VPWR _0568_ sky130_fd_sc_hd__xnor2_1
X_5722_ _2217_ VGND VGND VPWR VPWR _2281_ sky130_fd_sc_hd__inv_2
XFILLER_0_57_341 VPWR VGND VPWR VGND sky130_ef_sc_hd__decap_12
XFILLER_0_84_160 VGND VGND VPWR VPWR sky130_fd_sc_hd__decap_3
X_5653_ _2210_ _2212_ VGND VGND VPWR VPWR _2213_ sky130_fd_sc_hd__xnor2_1
XFILLER_0_25_260 VGND VGND VPWR VPWR sky130_fd_sc_hd__decap_8
X_4604_ _0917_ _1176_ _1177_ VGND VGND VPWR VPWR _1178_ sky130_fd_sc_hd__or3_4
XPHY_EDGE_ROW_46_Right_46 VGND VGND VPWR VPWR sky130_fd_sc_hd__decap_3
X_5584_ _1981_ _2068_ _2144_ VGND VGND VPWR VPWR _2145_ sky130_fd_sc_hd__and3_1
XFILLER_0_13_444 VGND VGND VPWR VPWR sky130_fd_sc_hd__decap_4
XFILLER_0_13_422 VGND VGND VPWR VPWR sky130_fd_sc_hd__fill_1
X_4535_ _1107_ _1108_ _1044_ VGND VGND VPWR VPWR _1110_ sky130_fd_sc_hd__a21o_1
XFILLER_0_40_230 VPWR VGND VPWR VGND sky130_ef_sc_hd__decap_12
XFILLER_0_7_64 VGND VGND VPWR VPWR sky130_fd_sc_hd__decap_6
X_4466_ _2736_ _1040_ _1041_ net61 VGND VGND VPWR VPWR _0120_ sky130_fd_sc_hd__o211a_1
XFILLER_0_0_371 VGND VGND VPWR VPWR sky130_fd_sc_hd__decap_3
X_6205_ clknet_leaf_18_clk _0118_ VGND VGND VPWR VPWR u_interface.u_compute_core.u_av.product_reg\[12\]
+ sky130_fd_sc_hd__dfxtp_1
X_3417_ u_interface.u_compute_core.u_mac.product_reg\[15\] u_interface.u_compute_core.mac_accum\[22\]
+ VGND VGND VPWR VPWR _2871_ sky130_fd_sc_hd__nor2_1
X_4397_ _0902_ _0906_ VGND VGND VPWR VPWR _0974_ sky130_fd_sc_hd__nand2_1
XTAP_TAPCELL_ROW_90_1051 VGND VPWR sky130_fd_sc_hd__tapvpwrvgnd_1
XFILLER_0_0_393 VGND VGND VPWR VPWR sky130_fd_sc_hd__decap_8
X_3348_ u_interface.u_compute_core.u_mac.product_reg\[12\] u_interface.u_compute_core.mac_accum\[12\]
+ VGND VGND VPWR VPWR _2812_ sky130_fd_sc_hd__nand2_1
X_6136_ clknet_leaf_19_clk _0049_ VGND VGND VPWR VPWR u_interface.u_compute_core.scaled_data\[20\]
+ sky130_fd_sc_hd__dfxtp_1
XFILLER_0_84_82 VGND VGND VPWR VPWR sky130_fd_sc_hd__fill_2
XFILLER_0_84_71 VGND VGND VPWR VPWR sky130_fd_sc_hd__fill_2
X_6067_ net45 u_interface.core_attn_out\[25\] u_interface.core_valid_out VGND VGND
+ VPWR VPWR _2566_ sky130_fd_sc_hd__mux2_1
X_3279_ _2579_ net27 VGND VGND VPWR VPWR _2753_ sky130_fd_sc_hd__nand2_1
XPHY_EDGE_ROW_55_Right_55 VGND VGND VPWR VPWR sky130_fd_sc_hd__decap_3
X_5018_ _1584_ _1585_ VGND VGND VPWR VPWR _1586_ sky130_fd_sc_hd__xnor2_1
XFILLER_0_48_363 VGND VGND VPWR VPWR sky130_fd_sc_hd__fill_1
XFILLER_0_63_311 VGND VGND VPWR VPWR sky130_fd_sc_hd__fill_2
XPHY_EDGE_ROW_64_Right_64 VGND VGND VPWR VPWR sky130_fd_sc_hd__decap_3
XTAP_TAPCELL_ROW_11_306 VGND VPWR sky130_fd_sc_hd__tapvpwrvgnd_1
XFILLER_0_63_388 VGND VGND VPWR VPWR sky130_fd_sc_hd__decap_4
XFILLER_0_23_208 VPWR VGND VPWR VGND sky130_ef_sc_hd__decap_12
XFILLER_0_31_252 VPWR VGND VPWR VGND sky130_ef_sc_hd__decap_12
XPHY_EDGE_ROW_73_Right_73 VGND VGND VPWR VPWR sky130_fd_sc_hd__decap_3
XFILLER_0_86_414 VGND VGND VPWR VPWR sky130_fd_sc_hd__decap_6
XFILLER_0_80_29 VPWR VGND VPWR VGND sky130_ef_sc_hd__decap_12
XPHY_EDGE_ROW_82_Right_82 VGND VGND VPWR VPWR sky130_fd_sc_hd__decap_3
XFILLER_0_66_171 VGND VGND VPWR VPWR sky130_fd_sc_hd__decap_4
XFILLER_0_39_396 VGND VGND VPWR VPWR sky130_fd_sc_hd__decap_8
XFILLER_0_89_27 VPWR VGND VPWR VGND sky130_ef_sc_hd__decap_12
XFILLER_0_81_163 VGND VGND VPWR VPWR sky130_fd_sc_hd__decap_4
XFILLER_0_1_113 VPWR VGND VPWR VGND sky130_ef_sc_hd__decap_12
XFILLER_0_1_102 VGND VGND VPWR VPWR sky130_fd_sc_hd__decap_3
X_4320_ _0807_ _0837_ _0838_ VGND VGND VPWR VPWR _0898_ sky130_fd_sc_hd__nor3_1
XFILLER_0_10_469 VGND VGND VPWR VPWR sky130_fd_sc_hd__decap_6
X_4251_ _0829_ _0828_ _0814_ VGND VGND VPWR VPWR _0830_ sky130_fd_sc_hd__and3_1
XPHY_EDGE_ROW_91_Right_91 VGND VGND VPWR VPWR sky130_fd_sc_hd__decap_3
X_3202_ u_interface.u_compute_core.scaled_data\[11\] u_interface.u_compute_core.mac_accum\[14\]
+ _2691_ VGND VGND VPWR VPWR _2697_ sky130_fd_sc_hd__mux2_1
XFILLER_0_38_97 VPWR VGND VPWR VGND sky130_ef_sc_hd__decap_12
X_4182_ _0759_ _0760_ _0758_ VGND VGND VPWR VPWR _0762_ sky130_fd_sc_hd__a21bo_1
X_3133_ u_interface.u_compute_core.scaled_data\[19\] _2618_ _2648_ _2586_ VGND VGND
+ VPWR VPWR _2649_ sky130_fd_sc_hd__o2bb2a_1
XFILLER_0_54_41 VPWR VGND VPWR VGND sky130_ef_sc_hd__decap_12
X_3064_ _2595_ VGND VGND VPWR VPWR _2596_ sky130_fd_sc_hd__inv_2
XFILLER_0_54_74 VGND VGND VPWR VPWR sky130_fd_sc_hd__fill_1
XFILLER_0_77_447 VGND VGND VPWR VPWR sky130_fd_sc_hd__fill_1
XTAP_TAPCELL_ROW_53_707 VGND VPWR sky130_fd_sc_hd__tapvpwrvgnd_1
XFILLER_0_54_85 VGND VGND VPWR VPWR sky130_fd_sc_hd__fill_2
XFILLER_0_92_417 VGND VGND VPWR VPWR sky130_fd_sc_hd__decap_3
X_3966_ _0549_ _0550_ VGND VGND VPWR VPWR _0551_ sky130_fd_sc_hd__nor2_1
XFILLER_0_70_73 VGND VGND VPWR VPWR sky130_fd_sc_hd__decap_8
XFILLER_0_9_279 VGND VGND VPWR VPWR sky130_fd_sc_hd__fill_1
X_5705_ u_interface.u_compute_core.relu_data\[27\] _0536_ VGND VGND VPWR VPWR _2264_
+ sky130_fd_sc_hd__nand2_1
XFILLER_0_92_3 VPWR VGND VPWR VGND sky130_ef_sc_hd__decap_12
X_3897_ _0484_ VGND VGND VPWR VPWR _0108_ sky130_fd_sc_hd__clkbuf_1
XFILLER_0_45_366 VGND VGND VPWR VPWR sky130_fd_sc_hd__decap_4
X_5636_ u_interface.u_compute_core.relu_data\[25\] _0559_ VGND VGND VPWR VPWR _2196_
+ sky130_fd_sc_hd__nand2_1
XFILLER_0_5_441 VGND VGND VPWR VPWR sky130_fd_sc_hd__decap_6
XFILLER_0_13_230 VPWR VGND VPWR VGND sky130_ef_sc_hd__decap_12
XFILLER_0_5_485 VPWR VGND VPWR VGND sky130_ef_sc_hd__decap_12
X_5567_ u_interface.u_compute_core.relu_data\[25\] _0536_ VGND VGND VPWR VPWR _2128_
+ sky130_fd_sc_hd__nand2_1
X_4518_ _1075_ _1091_ _1092_ VGND VGND VPWR VPWR _1093_ sky130_fd_sc_hd__nand3_2
Xhold142 u_interface.core_attn_out\[11\] VGND VGND VPWR VPWR net207 sky130_fd_sc_hd__dlygate4sd3_1
Xhold120 u_interface.core_attn_out\[18\] VGND VGND VPWR VPWR net185 sky130_fd_sc_hd__dlygate4sd3_1
Xhold131 u_interface.u_compute_core.mac_accum\[26\] VGND VGND VPWR VPWR net196 sky130_fd_sc_hd__dlygate4sd3_1
Xhold153 u_interface.u_compute_core.u_av.product_reg\[23\] VGND VGND VPWR VPWR net218
+ sky130_fd_sc_hd__dlygate4sd3_1
X_5498_ _1982_ _1986_ VGND VGND VPWR VPWR _2060_ sky130_fd_sc_hd__and2b_1
X_4449_ _1024_ _1023_ _1007_ VGND VGND VPWR VPWR _1025_ sky130_fd_sc_hd__and3_1
XTAP_TAPCELL_ROW_69_851 VGND VPWR sky130_fd_sc_hd__tapvpwrvgnd_1
X_6119_ clknet_leaf_3_clk _0032_ VGND VGND VPWR VPWR u_interface.u_compute_core.scaled_data\[3\]
+ sky130_fd_sc_hd__dfxtp_1
XFILLER_0_83_406 VPWR VGND VPWR VGND sky130_ef_sc_hd__decap_12
XFILLER_0_83_428 VPWR VGND VPWR VGND sky130_ef_sc_hd__decap_12
XTAP_TAPCELL_ROW_24_431 VGND VPWR sky130_fd_sc_hd__tapvpwrvgnd_1
XFILLER_0_36_344 VPWR VGND VPWR VGND sky130_ef_sc_hd__decap_12
XFILLER_0_91_461 VPWR VGND VPWR VGND sky130_ef_sc_hd__decap_12
XFILLER_0_36_377 VPWR VGND VPWR VGND sky130_ef_sc_hd__decap_12
XFILLER_0_51_347 VPWR VGND VPWR VGND sky130_ef_sc_hd__decap_12
XFILLER_0_91_39 VPWR VGND VPWR VGND sky130_ef_sc_hd__decap_12
XFILLER_0_59_447 VGND VGND VPWR VPWR sky130_fd_sc_hd__fill_1
XFILLER_0_59_469 VGND VGND VPWR VPWR sky130_fd_sc_hd__decap_3
X_3820_ _0411_ _0412_ VGND VGND VPWR VPWR _0413_ sky130_fd_sc_hd__and2_1
X_3751_ _0269_ _0345_ VGND VGND VPWR VPWR _0346_ sky130_fd_sc_hd__nor2_1
XFILLER_0_6_205 VGND VGND VPWR VPWR sky130_fd_sc_hd__fill_2
XFILLER_0_15_517 VPWR VGND VPWR VGND sky130_ef_sc_hd__decap_12
XFILLER_0_6_249 VGND VGND VPWR VPWR sky130_fd_sc_hd__decap_3
XFILLER_0_54_141 VPWR VGND VPWR VGND sky130_ef_sc_hd__decap_12
X_3682_ _3027_ _0232_ _0230_ VGND VGND VPWR VPWR _0279_ sky130_fd_sc_hd__a21o_1
XTAP_TAPCELL_ROW_30_489 VGND VPWR sky130_fd_sc_hd__tapvpwrvgnd_1
X_5421_ _1509_ _1209_ _0595_ _0634_ VGND VGND VPWR VPWR _1984_ sky130_fd_sc_hd__and4_1
X_5352_ _1913_ _1914_ _1915_ VGND VGND VPWR VPWR _1916_ sky130_fd_sc_hd__nand3_1
XFILLER_0_2_433 VPWR VGND VPWR VGND sky130_ef_sc_hd__decap_12
XFILLER_0_2_477 VPWR VGND VPWR VGND sky130_ef_sc_hd__decap_12
X_4303_ _0878_ _0879_ _0875_ VGND VGND VPWR VPWR _0881_ sky130_fd_sc_hd__a21o_1
X_5283_ _1843_ _1844_ _1847_ VGND VGND VPWR VPWR _1848_ sky130_fd_sc_hd__or3_4
X_4234_ _0812_ VGND VGND VPWR VPWR _0813_ sky130_fd_sc_hd__clkbuf_4
XFILLER_0_4_21 VGND VGND VPWR VPWR sky130_fd_sc_hd__fill_1
XFILLER_0_65_51 VGND VGND VPWR VPWR sky130_fd_sc_hd__decap_4
XFILLER_0_4_54 VGND VGND VPWR VPWR sky130_fd_sc_hd__decap_8
X_4165_ _0744_ _0494_ _2619_ VGND VGND VPWR VPWR _0745_ sky130_fd_sc_hd__and3_1
X_3116_ u_interface.u_compute_core.scaled_data\[15\] _2618_ _2635_ _2613_ VGND VGND
+ VPWR VPWR _2636_ sky130_fd_sc_hd__o2bb2a_1
X_4096_ _0677_ _0655_ VGND VGND VPWR VPWR _0678_ sky130_fd_sc_hd__xor2_1
X_3047_ _2581_ VGND VGND VPWR VPWR _2582_ sky130_fd_sc_hd__clkbuf_4
XTAP_TAPCELL_ROW_38_556 VGND VPWR sky130_fd_sc_hd__tapvpwrvgnd_1
XFILLER_0_92_225 VGND VGND VPWR VPWR sky130_fd_sc_hd__decap_4
XFILLER_0_92_247 VGND VGND VPWR VPWR sky130_fd_sc_hd__decap_4
X_4998_ _1565_ _0812_ VGND VGND VPWR VPWR _1566_ sky130_fd_sc_hd__xnor2_4
XTAP_TAPCELL_ROW_21_401 VGND VPWR sky130_fd_sc_hd__tapvpwrvgnd_1
XFILLER_0_73_461 VGND VGND VPWR VPWR sky130_fd_sc_hd__decap_4
X_3949_ _0534_ VGND VGND VPWR VPWR _0535_ sky130_fd_sc_hd__clkbuf_4
XFILLER_0_18_377 VPWR VGND VPWR VGND sky130_ef_sc_hd__decap_12
XFILLER_0_33_314 VGND VGND VPWR VPWR sky130_fd_sc_hd__decap_8
X_5619_ _2105_ _2108_ _2104_ VGND VGND VPWR VPWR _2180_ sky130_fd_sc_hd__o21ba_1
XFILLER_0_60_133 VGND VGND VPWR VPWR sky130_fd_sc_hd__decap_6
XFILLER_0_5_293 VPWR VGND VPWR VGND sky130_ef_sc_hd__decap_12
XFILLER_0_83_225 VGND VGND VPWR VPWR sky130_fd_sc_hd__decap_4
XTAP_TAPCELL_ROW_72_879 VGND VPWR sky130_fd_sc_hd__tapvpwrvgnd_1
XFILLER_0_56_417 VGND VGND VPWR VPWR sky130_fd_sc_hd__decap_3
XFILLER_0_24_325 VGND VGND VPWR VPWR sky130_fd_sc_hd__decap_3
XFILLER_0_51_111 VGND VGND VPWR VPWR sky130_fd_sc_hd__fill_1
XFILLER_0_10_24 VGND VGND VPWR VPWR sky130_fd_sc_hd__decap_4
XFILLER_0_51_144 VPWR VGND VPWR VGND sky130_ef_sc_hd__decap_12
XFILLER_0_10_57 VGND VGND VPWR VPWR sky130_fd_sc_hd__fill_1
XTAP_TAPCELL_ROW_9_281 VGND VPWR sky130_fd_sc_hd__tapvpwrvgnd_1
XFILLER_0_19_44 VGND VGND VPWR VPWR sky130_fd_sc_hd__fill_2
XFILLER_0_79_509 VPWR VGND VPWR VGND sky130_ef_sc_hd__decap_12
XTAP_TAPCELL_ROW_63_802 VGND VPWR sky130_fd_sc_hd__tapvpwrvgnd_1
X_5970_ _2497_ _2498_ VGND VGND VPWR VPWR _2499_ sky130_fd_sc_hd__nand2_1
XFILLER_0_59_222 VGND VGND VPWR VPWR sky130_fd_sc_hd__fill_2
X_4921_ _0835_ VGND VGND VPWR VPWR _1490_ sky130_fd_sc_hd__inv_2
X_4852_ _0813_ _1421_ VGND VGND VPWR VPWR _1422_ sky130_fd_sc_hd__xnor2_1
XFILLER_0_7_503 VGND VGND VPWR VPWR sky130_fd_sc_hd__fill_1
X_3803_ _3014_ _0300_ _0217_ _2992_ VGND VGND VPWR VPWR _0396_ sky130_fd_sc_hd__o2bb2a_1
X_4783_ _1302_ _1352_ _1353_ VGND VGND VPWR VPWR _1354_ sky130_fd_sc_hd__nand3_2
XFILLER_0_27_130 VPWR VGND VPWR VGND sky130_ef_sc_hd__decap_12
X_3734_ _2961_ _3014_ _0328_ VGND VGND VPWR VPWR _0329_ sky130_fd_sc_hd__a21oi_1
X_3665_ _0248_ _0261_ VGND VGND VPWR VPWR _0262_ sky130_fd_sc_hd__and2b_1
XFILLER_0_70_475 VGND VGND VPWR VPWR sky130_fd_sc_hd__fill_1
XFILLER_0_30_306 VGND VGND VPWR VPWR sky130_fd_sc_hd__fill_2
XFILLER_0_30_317 VGND VGND VPWR VPWR sky130_fd_sc_hd__decap_4
XFILLER_0_42_188 VGND VGND VPWR VPWR sky130_fd_sc_hd__decap_8
X_5404_ _1965_ _1966_ VGND VGND VPWR VPWR _1967_ sky130_fd_sc_hd__nor2_1
X_3596_ _3024_ _3033_ VGND VGND VPWR VPWR _3034_ sky130_fd_sc_hd__nor2_1
XFILLER_0_23_391 VGND VGND VPWR VPWR sky130_fd_sc_hd__fill_1
X_5335_ _1896_ _1897_ _1884_ VGND VGND VPWR VPWR _1899_ sky130_fd_sc_hd__a21o_1
X_5266_ _1828_ _1829_ _1669_ VGND VGND VPWR VPWR _1831_ sky130_fd_sc_hd__o21ai_1
XFILLER_0_55_3 VPWR VGND VPWR VGND sky130_ef_sc_hd__decap_12
XFILLER_0_76_83 VGND VGND VPWR VPWR sky130_fd_sc_hd__fill_1
X_4217_ _0487_ _0648_ _0753_ _0795_ VGND VGND VPWR VPWR _0796_ sky130_fd_sc_hd__a31o_1
X_5197_ _1746_ _1761_ _1762_ VGND VGND VPWR VPWR _1763_ sky130_fd_sc_hd__nand3_1
XTAP_TAPCELL_ROW_87_1023 VGND VPWR sky130_fd_sc_hd__tapvpwrvgnd_1
X_4148_ _0694_ _0728_ VGND VGND VPWR VPWR _0729_ sky130_fd_sc_hd__xor2_2
XFILLER_0_78_520 VPWR VGND VPWR VGND sky130_ef_sc_hd__decap_12
X_4079_ _0658_ _0659_ _0660_ VGND VGND VPWR VPWR _0661_ sky130_fd_sc_hd__a21oi_1
XFILLER_0_18_130 VGND VGND VPWR VPWR sky130_fd_sc_hd__decap_3
Xclkload1 clknet_leaf_0_clk VGND VGND VPWR VPWR clkload1/Y sky130_fd_sc_hd__clkinv_4
XFILLER_0_33_111 VGND VGND VPWR VPWR sky130_fd_sc_hd__fill_1
XFILLER_0_73_291 VGND VGND VPWR VPWR sky130_fd_sc_hd__fill_2
XTAP_TAPCELL_ROW_77_927 VGND VPWR sky130_fd_sc_hd__tapvpwrvgnd_1
XFILLER_0_84_545 VGND VGND VPWR VPWR sky130_fd_sc_hd__fill_2
XTAP_TAPCELL_ROW_32_507 VGND VPWR sky130_fd_sc_hd__tapvpwrvgnd_1
XTAP_TAPCELL_ROW_40_584 VGND VPWR sky130_fd_sc_hd__tapvpwrvgnd_1
XFILLER_0_52_431 VGND VGND VPWR VPWR sky130_fd_sc_hd__decap_3
XFILLER_0_52_497 VGND VGND VPWR VPWR sky130_fd_sc_hd__fill_1
X_3450_ _2899_ VGND VGND VPWR VPWR _2900_ sky130_fd_sc_hd__inv_2
X_3381_ u_interface.u_compute_core.u_mac.product_reg\[15\] u_interface.u_compute_core.mac_accum\[15\]
+ VGND VGND VPWR VPWR _2841_ sky130_fd_sc_hd__nor2_1
X_5120_ _1684_ _1685_ _1615_ VGND VGND VPWR VPWR _1687_ sky130_fd_sc_hd__a21oi_1
X_5051_ _1569_ _1618_ _1617_ VGND VGND VPWR VPWR _1619_ sky130_fd_sc_hd__or3_4
X_4002_ net21 VGND VGND VPWR VPWR _0586_ sky130_fd_sc_hd__buf_4
XFILLER_0_79_317 VGND VGND VPWR VPWR sky130_fd_sc_hd__decap_6
XFILLER_0_46_97 VGND VGND VPWR VPWR sky130_fd_sc_hd__decap_4
XTAP_TAPCELL_ROW_48_651 VGND VPWR sky130_fd_sc_hd__tapvpwrvgnd_1
XFILLER_0_1_55 VGND VGND VPWR VPWR sky130_fd_sc_hd__fill_1
X_5953_ u_interface.core_attn_out\[27\] u_interface.u_compute_core.u_av.product_reg\[30\]
+ VGND VGND VPWR VPWR _2484_ sky130_fd_sc_hd__nand2_1
XFILLER_0_87_383 VGND VGND VPWR VPWR sky130_fd_sc_hd__decap_3
X_4904_ net133 net87 net104 _1473_ VGND VGND VPWR VPWR _1474_ sky130_fd_sc_hd__o211a_4
X_5884_ _2422_ _2423_ _2415_ VGND VGND VPWR VPWR _2424_ sky130_fd_sc_hd__nand3b_1
XFILLER_0_62_85 VPWR VGND VPWR VGND sky130_ef_sc_hd__decap_12
X_4835_ _1338_ _1339_ _1403_ _1405_ VGND VGND VPWR VPWR _1406_ sky130_fd_sc_hd__a22oi_1
X_4766_ _2736_ _1335_ _1336_ _1337_ VGND VGND VPWR VPWR _0124_ sky130_fd_sc_hd__o211a_1
XFILLER_0_15_144 VGND VGND VPWR VPWR sky130_fd_sc_hd__decap_4
X_3717_ _0311_ _0312_ VGND VGND VPWR VPWR _0313_ sky130_fd_sc_hd__nor2_1
XFILLER_0_7_377 VPWR VGND VPWR VGND sky130_ef_sc_hd__decap_12
XFILLER_0_43_442 VGND VGND VPWR VPWR sky130_fd_sc_hd__decap_6
X_4697_ _1266_ _1267_ _1264_ VGND VGND VPWR VPWR _1269_ sky130_fd_sc_hd__a21oi_1
X_3648_ _0244_ _0205_ _0242_ _0243_ VGND VGND VPWR VPWR _0246_ sky130_fd_sc_hd__o211ai_2
XFILLER_0_30_114 VGND VGND VPWR VPWR sky130_fd_sc_hd__decap_4
XFILLER_0_30_136 VGND VGND VPWR VPWR sky130_fd_sc_hd__decap_4
X_3579_ net5 _2949_ _2984_ VGND VGND VPWR VPWR _3017_ sky130_fd_sc_hd__a21o_1
XFILLER_0_87_82 VGND VGND VPWR VPWR sky130_fd_sc_hd__decap_8
X_5318_ _1869_ _1881_ VGND VGND VPWR VPWR _1882_ sky130_fd_sc_hd__xnor2_1
XFILLER_0_11_361 VGND VGND VPWR VPWR sky130_fd_sc_hd__decap_8
X_5249_ _1809_ _1810_ _1812_ VGND VGND VPWR VPWR _1814_ sky130_fd_sc_hd__a21o_1
XTAP_TAPCELL_ROW_3_232 VGND VPWR sky130_fd_sc_hd__tapvpwrvgnd_1
Xhold79 u_interface.u_compute_core.mac_accum\[2\] VGND VGND VPWR VPWR net144 sky130_fd_sc_hd__dlygate4sd3_1
XTAP_TAPCELL_ROW_82_974 VGND VPWR sky130_fd_sc_hd__tapvpwrvgnd_1
XFILLER_0_66_545 VGND VGND VPWR VPWR sky130_fd_sc_hd__fill_2
XFILLER_0_53_228 VGND VGND VPWR VPWR sky130_fd_sc_hd__decap_8
XFILLER_0_21_103 VGND VGND VPWR VPWR sky130_fd_sc_hd__decap_8
XFILLER_0_21_169 VGND VGND VPWR VPWR sky130_fd_sc_hd__fill_1
XFILLER_0_88_125 VGND VGND VPWR VPWR sky130_fd_sc_hd__decap_4
XFILLER_0_88_147 VGND VGND VPWR VPWR sky130_fd_sc_hd__decap_8
XFILLER_0_16_45 VGND VGND VPWR VPWR sky130_fd_sc_hd__decap_8
XFILLER_0_76_309 VGND VGND VPWR VPWR sky130_fd_sc_hd__decap_8
XFILLER_0_69_383 VGND VGND VPWR VPWR sky130_fd_sc_hd__decap_4
XFILLER_0_29_225 VGND VGND VPWR VPWR sky130_fd_sc_hd__decap_6
X_4620_ _1191_ _1192_ _1010_ VGND VGND VPWR VPWR _1193_ sky130_fd_sc_hd__a21o_1
X_4551_ _1057_ _1065_ _1064_ VGND VGND VPWR VPWR _1125_ sky130_fd_sc_hd__a21o_1
XFILLER_0_40_412 VGND VGND VPWR VPWR sky130_fd_sc_hd__fill_2
X_4482_ _0988_ _1056_ VGND VGND VPWR VPWR _1057_ sky130_fd_sc_hd__xnor2_1
X_3502_ _2890_ _2941_ _2943_ _2867_ net138 VGND VGND VPWR VPWR _0093_ sky130_fd_sc_hd__a32o_1
XFILLER_0_12_169 VPWR VGND VPWR VGND sky130_ef_sc_hd__decap_12
X_3433_ _2833_ u_interface.u_compute_core.mac_accum\[24\] VGND VGND VPWR VPWR _2885_
+ sky130_fd_sc_hd__or2_1
X_6221_ clknet_leaf_12_clk _0134_ VGND VGND VPWR VPWR u_interface.u_compute_core.u_av.product_reg\[28\]
+ sky130_fd_sc_hd__dfxtp_1
X_6152_ clknet_leaf_20_clk _0065_ VGND VGND VPWR VPWR u_interface.u_compute_core.mac_accum\[6\]
+ sky130_fd_sc_hd__dfxtp_1
X_5103_ u_interface.u_compute_core.relu_data\[16\] _0596_ _1583_ _1582_ VGND VGND
+ VPWR VPWR _1670_ sky130_fd_sc_hd__a31o_1
XFILLER_0_20_191 VGND VGND VPWR VPWR sky130_fd_sc_hd__decap_4
X_3364_ _2824_ _2825_ VGND VGND VPWR VPWR _2826_ sky130_fd_sc_hd__nand2_1
X_6083_ _2512_ net140 _2576_ VGND VGND VPWR VPWR _0202_ sky130_fd_sc_hd__o21a_1
X_3295_ _2763_ _2764_ _2765_ VGND VGND VPWR VPWR _2767_ sky130_fd_sc_hd__a21o_1
X_5034_ _1599_ _1600_ _1601_ VGND VGND VPWR VPWR _1602_ sky130_fd_sc_hd__and3_1
XFILLER_0_79_103 VGND VGND VPWR VPWR sky130_fd_sc_hd__fill_1
XTAP_TAPCELL_ROW_0_202 VGND VPWR sky130_fd_sc_hd__tapvpwrvgnd_1
XFILLER_0_18_3 VGND VGND VPWR VPWR sky130_fd_sc_hd__decap_6
XFILLER_0_79_169 VGND VGND VPWR VPWR sky130_fd_sc_hd__decap_3
XFILLER_0_73_84 VGND VGND VPWR VPWR sky130_fd_sc_hd__decap_3
XFILLER_0_48_501 VGND VGND VPWR VPWR sky130_fd_sc_hd__fill_1
X_5936_ u_interface.core_attn_out\[25\] u_interface.u_compute_core.u_av.product_reg\[28\]
+ VGND VGND VPWR VPWR _2469_ sky130_fd_sc_hd__nor2_1
XFILLER_0_48_545 VGND VGND VPWR VPWR sky130_fd_sc_hd__fill_2
X_5867_ _2387_ _2396_ _2395_ _2402_ _2394_ VGND VGND VPWR VPWR _2409_ sky130_fd_sc_hd__o311a_1
X_4818_ _1388_ _1368_ VGND VGND VPWR VPWR _1389_ sky130_fd_sc_hd__xnor2_1
X_5798_ u_interface.core_attn_out\[7\] u_interface.u_compute_core.u_av.product_reg\[10\]
+ VGND VGND VPWR VPWR _2349_ sky130_fd_sc_hd__or2_1
XFILLER_0_28_291 VGND VGND VPWR VPWR sky130_fd_sc_hd__decap_8
X_4749_ _1262_ net72 _1319_ _1320_ VGND VGND VPWR VPWR _1321_ sky130_fd_sc_hd__a211oi_2
XFILLER_0_7_196 VPWR VGND VPWR VGND sky130_ef_sc_hd__decap_12
XFILLER_0_16_475 VGND VGND VPWR VPWR sky130_fd_sc_hd__fill_1
XFILLER_0_31_401 VGND VGND VPWR VPWR sky130_fd_sc_hd__decap_8
Xoutput47 net47 VGND VGND VPWR VPWR m_tdata[27] sky130_fd_sc_hd__buf_2
Xoutput58 net58 VGND VGND VPWR VPWR m_tdata[8] sky130_fd_sc_hd__buf_2
XFILLER_0_3_391 VGND VGND VPWR VPWR sky130_fd_sc_hd__fill_1
XFILLER_0_31_489 VGND VGND VPWR VPWR sky130_fd_sc_hd__decap_3
Xoutput36 net36 VGND VGND VPWR VPWR m_tdata[17] sky130_fd_sc_hd__buf_2
XTAP_TAPCELL_ROW_59_757 VGND VPWR sky130_fd_sc_hd__tapvpwrvgnd_1
XFILLER_0_58_309 VPWR VGND VPWR VGND sky130_ef_sc_hd__decap_12
XFILLER_0_85_139 VPWR VGND VPWR VGND sky130_ef_sc_hd__decap_12
XFILLER_0_39_545 VGND VGND VPWR VPWR sky130_fd_sc_hd__fill_2
XTAP_TAPCELL_ROW_42_602 VGND VPWR sky130_fd_sc_hd__tapvpwrvgnd_1
XFILLER_0_66_331 VGND VGND VPWR VPWR sky130_fd_sc_hd__decap_4
XTAP_TAPCELL_ROW_14_337 VGND VPWR sky130_fd_sc_hd__tapvpwrvgnd_1
XFILLER_0_78_29 VPWR VGND VPWR VGND sky130_ef_sc_hd__decap_12
XFILLER_0_1_317 VPWR VGND VPWR VGND sky130_ef_sc_hd__decap_12
X_3080_ u_interface.u_compute_core.scaled_data\[7\] _2584_ _2607_ _2587_ VGND VGND
+ VPWR VPWR _2608_ sky130_fd_sc_hd__o2bb2a_1
XFILLER_0_27_55 VGND VGND VPWR VPWR sky130_fd_sc_hd__fill_1
XFILLER_0_89_445 VGND VGND VPWR VPWR sky130_fd_sc_hd__decap_3
X_3982_ _0487_ _0536_ _0533_ _0531_ VGND VGND VPWR VPWR _0567_ sky130_fd_sc_hd__a31oi_2
X_5721_ _2277_ _2279_ VGND VGND VPWR VPWR _2280_ sky130_fd_sc_hd__xnor2_1
XFILLER_0_57_353 VGND VGND VPWR VPWR sky130_fd_sc_hd__decap_8
XFILLER_0_57_375 VPWR VGND VPWR VGND sky130_ef_sc_hd__decap_12
X_5652_ _2147_ _2211_ VGND VGND VPWR VPWR _2212_ sky130_fd_sc_hd__xnor2_1
X_4603_ _1175_ _1174_ _1099_ _1101_ VGND VGND VPWR VPWR _1177_ sky130_fd_sc_hd__o211a_4
X_5583_ _1806_ _2065_ VGND VGND VPWR VPWR _2144_ sky130_fd_sc_hd__nand2_1
XFILLER_0_13_401 VGND VGND VPWR VPWR sky130_fd_sc_hd__fill_2
XFILLER_0_32_209 VGND VGND VPWR VPWR sky130_fd_sc_hd__decap_4
XFILLER_0_4_155 VGND VGND VPWR VPWR sky130_fd_sc_hd__fill_1
X_4534_ _1044_ _1107_ _1108_ VGND VGND VPWR VPWR _1109_ sky130_fd_sc_hd__and3_1
XFILLER_0_13_478 VGND VGND VPWR VPWR sky130_fd_sc_hd__fill_1
XFILLER_0_40_242 VGND VGND VPWR VPWR sky130_fd_sc_hd__fill_2
X_4465_ _0915_ u_interface.u_compute_core.u_av.product_reg\[14\] VGND VGND VPWR VPWR
+ _1041_ sky130_fd_sc_hd__or2_1
XFILLER_0_0_350 VGND VGND VPWR VPWR sky130_fd_sc_hd__decap_3
X_6204_ clknet_leaf_10_clk _0117_ VGND VGND VPWR VPWR u_interface.u_compute_core.u_av.product_reg\[11\]
+ sky130_fd_sc_hd__dfxtp_1
X_3416_ net194 _2805_ _2869_ _2870_ VGND VGND VPWR VPWR _0080_ sky130_fd_sc_hd__a22o_1
XFILLER_0_40_297 VGND VGND VPWR VPWR sky130_fd_sc_hd__decap_8
X_4396_ _0970_ _0971_ _0918_ VGND VGND VPWR VPWR _0973_ sky130_fd_sc_hd__o21ai_1
XTAP_TAPCELL_ROW_90_1052 VGND VPWR sky130_fd_sc_hd__tapvpwrvgnd_1
X_3347_ u_interface.u_compute_core.u_mac.product_reg\[11\] u_interface.u_compute_core.mac_accum\[11\]
+ VGND VGND VPWR VPWR _2811_ sky130_fd_sc_hd__nor2_1
X_6135_ clknet_leaf_3_clk _0048_ VGND VGND VPWR VPWR u_interface.u_compute_core.scaled_data\[19\]
+ sky130_fd_sc_hd__dfxtp_1
X_6066_ _2565_ VGND VGND VPWR VPWR _0196_ sky130_fd_sc_hd__clkbuf_1
X_5017_ _2637_ _0597_ VGND VGND VPWR VPWR _1585_ sky130_fd_sc_hd__nand2_1
X_3278_ _2749_ _2751_ VGND VGND VPWR VPWR _2752_ sky130_fd_sc_hd__nor2_1
XTAP_TAPCELL_ROW_56_727 VGND VPWR sky130_fd_sc_hd__tapvpwrvgnd_1
XFILLER_0_82_109 VGND VGND VPWR VPWR sky130_fd_sc_hd__decap_3
X_5919_ net192 _2304_ _0981_ _2454_ VGND VGND VPWR VPWR _0160_ sky130_fd_sc_hd__o211a_1
XTAP_TAPCELL_ROW_11_307 VGND VPWR sky130_fd_sc_hd__tapvpwrvgnd_1
XFILLER_0_16_250 VGND VGND VPWR VPWR sky130_fd_sc_hd__fill_2
XFILLER_0_31_264 VPWR VGND VPWR VGND sky130_ef_sc_hd__decap_12
XFILLER_0_7_3 VGND VGND VPWR VPWR sky130_fd_sc_hd__decap_8
XFILLER_0_86_437 VGND VGND VPWR VPWR sky130_fd_sc_hd__fill_2
XFILLER_0_80_19 VGND VGND VPWR VPWR sky130_fd_sc_hd__decap_8
XFILLER_0_13_57 VPWR VGND VPWR VGND sky130_ef_sc_hd__decap_12
XFILLER_0_13_35 VPWR VGND VPWR VGND sky130_ef_sc_hd__decap_12
XFILLER_0_54_312 VPWR VGND VPWR VGND sky130_ef_sc_hd__decap_12
XFILLER_0_89_39 VPWR VGND VPWR VGND sky130_ef_sc_hd__decap_12
XFILLER_0_1_125 VGND VGND VPWR VPWR sky130_fd_sc_hd__decap_6
XFILLER_0_1_169 VPWR VGND VPWR VGND sky130_ef_sc_hd__decap_12
X_4250_ _0826_ _0827_ _0745_ VGND VGND VPWR VPWR _0829_ sky130_fd_sc_hd__a21o_1
XFILLER_0_38_32 VGND VGND VPWR VPWR sky130_fd_sc_hd__decap_8
X_3201_ _2696_ VGND VGND VPWR VPWR _0039_ sky130_fd_sc_hd__clkbuf_1
X_4181_ _0758_ _0759_ _0760_ VGND VGND VPWR VPWR _0761_ sky130_fd_sc_hd__nand3b_1
X_3132_ _2647_ VGND VGND VPWR VPWR _2648_ sky130_fd_sc_hd__inv_2
X_3063_ u_interface.u_compute_core.relu_data\[3\] VGND VGND VPWR VPWR _2595_ sky130_fd_sc_hd__buf_2
XFILLER_0_54_53 VGND VGND VPWR VPWR sky130_fd_sc_hd__decap_4
X_3965_ _2595_ _0525_ _0490_ _2592_ VGND VGND VPWR VPWR _0550_ sky130_fd_sc_hd__a22oi_1
XFILLER_0_70_85 VGND VGND VPWR VPWR sky130_fd_sc_hd__decap_4
X_3896_ _2580_ net27 net26 VGND VGND VPWR VPWR _0484_ sky130_fd_sc_hd__and3_1
X_5704_ u_interface.u_compute_core.relu_data\[25\] _0597_ VGND VGND VPWR VPWR _2263_
+ sky130_fd_sc_hd__nand2_1
XFILLER_0_33_529 VPWR VGND VPWR VGND sky130_ef_sc_hd__decap_12
X_5635_ _2193_ _2194_ VGND VGND VPWR VPWR _2195_ sky130_fd_sc_hd__nor2_1
XFILLER_0_85_3 VPWR VGND VPWR VGND sky130_ef_sc_hd__decap_12
XFILLER_0_72_197 VGND VGND VPWR VPWR sky130_fd_sc_hd__fill_2
XFILLER_0_13_242 VPWR VGND VPWR VGND sky130_ef_sc_hd__decap_12
XFILLER_0_5_497 VGND VGND VPWR VPWR sky130_fd_sc_hd__decap_6
Xhold110 u_interface.u_compute_core.mac_accum\[20\] VGND VGND VPWR VPWR net175 sky130_fd_sc_hd__dlygate4sd3_1
X_5566_ _2125_ _2126_ VGND VGND VPWR VPWR _2127_ sky130_fd_sc_hd__nor2_1
X_4517_ _1089_ _1090_ _0812_ VGND VGND VPWR VPWR _1092_ sky130_fd_sc_hd__a21o_1
Xhold121 u_interface.u_compute_core.mac_accum\[30\] VGND VGND VPWR VPWR net186 sky130_fd_sc_hd__dlygate4sd3_1
Xhold132 u_interface.core_attn_out\[15\] VGND VGND VPWR VPWR net197 sky130_fd_sc_hd__dlygate4sd3_1
Xhold143 u_interface.u_compute_core.mac_accum\[24\] VGND VGND VPWR VPWR net208 sky130_fd_sc_hd__dlygate4sd3_1
X_5497_ _2040_ _2058_ VGND VGND VPWR VPWR _2059_ sky130_fd_sc_hd__xnor2_1
X_4448_ _1021_ _1022_ _0835_ VGND VGND VPWR VPWR _1024_ sky130_fd_sc_hd__a21o_1
Xhold154 u_interface.u_compute_core.u_av.product_reg\[25\] VGND VGND VPWR VPWR net219
+ sky130_fd_sc_hd__dlygate4sd3_1
X_4379_ _0955_ _0954_ _0941_ VGND VGND VPWR VPWR _0956_ sky130_fd_sc_hd__and3_1
XTAP_TAPCELL_ROW_69_852 VGND VPWR sky130_fd_sc_hd__tapvpwrvgnd_1
X_6118_ clknet_leaf_3_clk _0031_ VGND VGND VPWR VPWR u_interface.u_compute_core.scaled_data\[2\]
+ sky130_fd_sc_hd__dfxtp_1
X_6049_ _2554_ VGND VGND VPWR VPWR _0190_ sky130_fd_sc_hd__clkbuf_1
XFILLER_0_68_448 VPWR VGND VPWR VGND sky130_ef_sc_hd__decap_12
XTAP_TAPCELL_ROW_24_432 VGND VPWR sky130_fd_sc_hd__tapvpwrvgnd_1
XFILLER_0_48_161 VGND VGND VPWR VPWR sky130_fd_sc_hd__fill_2
XFILLER_0_91_473 VPWR VGND VPWR VGND sky130_ef_sc_hd__decap_12
XFILLER_0_36_356 VGND VGND VPWR VPWR sky130_fd_sc_hd__decap_8
XFILLER_0_36_389 VPWR VGND VPWR VGND sky130_ef_sc_hd__decap_12
XFILLER_0_51_315 VGND VGND VPWR VPWR sky130_fd_sc_hd__decap_4
XFILLER_0_51_337 VGND VGND VPWR VPWR sky130_fd_sc_hd__fill_2
X_3750_ _0301_ _0304_ _0302_ VGND VGND VPWR VPWR _0345_ sky130_fd_sc_hd__o21ba_1
XFILLER_0_27_323 VGND VGND VPWR VPWR sky130_fd_sc_hd__fill_1
XFILLER_0_54_153 VGND VGND VPWR VPWR sky130_fd_sc_hd__decap_6
XFILLER_0_15_529 VPWR VGND VPWR VGND sky130_ef_sc_hd__decap_12
X_3681_ _0276_ _0277_ VGND VGND VPWR VPWR _0278_ sky130_fd_sc_hd__or2_1
XFILLER_0_40_66 VGND VGND VPWR VPWR sky130_fd_sc_hd__decap_3
XFILLER_0_40_77 VGND VGND VPWR VPWR sky130_fd_sc_hd__decap_6
XFILLER_0_54_186 VGND VGND VPWR VPWR sky130_fd_sc_hd__decap_4
X_5420_ _1509_ _0596_ _0634_ _1209_ VGND VGND VPWR VPWR _1983_ sky130_fd_sc_hd__a22oi_1
XFILLER_0_2_401 VPWR VGND VPWR VGND sky130_ef_sc_hd__decap_12
XFILLER_0_40_99 VPWR VGND VPWR VGND sky130_ef_sc_hd__decap_12
X_5351_ _1669_ _1829_ _1828_ VGND VGND VPWR VPWR _1915_ sky130_fd_sc_hd__o21bai_1
XFILLER_0_2_445 VPWR VGND VPWR VGND sky130_ef_sc_hd__decap_12
X_5282_ _1689_ _1846_ VGND VGND VPWR VPWR _1847_ sky130_fd_sc_hd__xnor2_1
XFILLER_0_2_489 VPWR VGND VPWR VGND sky130_ef_sc_hd__decap_12
X_4302_ _0875_ _0878_ _0879_ VGND VGND VPWR VPWR _0880_ sky130_fd_sc_hd__nand3_1
X_4233_ _0810_ _0811_ VGND VGND VPWR VPWR _0812_ sky130_fd_sc_hd__nor2_4
X_4164_ _0740_ _0743_ VGND VGND VPWR VPWR _0744_ sky130_fd_sc_hd__xnor2_1
X_3115_ net123 VGND VGND VPWR VPWR _2635_ sky130_fd_sc_hd__inv_2
X_4095_ _0665_ _0676_ VGND VGND VPWR VPWR _0677_ sky130_fd_sc_hd__xnor2_1
XTAP_TAPCELL_ROW_66_822 VGND VPWR sky130_fd_sc_hd__tapvpwrvgnd_1
X_3046_ net2 VGND VGND VPWR VPWR _2581_ sky130_fd_sc_hd__buf_4
XTAP_TAPCELL_ROW_38_557 VGND VPWR sky130_fd_sc_hd__tapvpwrvgnd_1
XFILLER_0_81_95 VPWR VGND VPWR VGND sky130_ef_sc_hd__decap_12
XFILLER_0_81_73 VGND VGND VPWR VPWR sky130_fd_sc_hd__fill_1
X_4997_ _1497_ _1563_ VGND VGND VPWR VPWR _1565_ sky130_fd_sc_hd__and2b_1
XTAP_TAPCELL_ROW_21_402 VGND VPWR sky130_fd_sc_hd__tapvpwrvgnd_1
X_3948_ net21 VGND VGND VPWR VPWR _0534_ sky130_fd_sc_hd__clkbuf_4
XFILLER_0_18_389 VGND VGND VPWR VPWR sky130_fd_sc_hd__decap_3
X_3879_ _0412_ _0469_ VGND VGND VPWR VPWR _0470_ sky130_fd_sc_hd__xnor2_1
XFILLER_0_5_261 VPWR VGND VPWR VGND sky130_ef_sc_hd__decap_12
X_5618_ _2177_ _2178_ VGND VGND VPWR VPWR _2179_ sky130_fd_sc_hd__nor2_1
X_5549_ _2109_ _2110_ VGND VGND VPWR VPWR _2111_ sky130_fd_sc_hd__xnor2_1
XFILLER_0_68_223 VGND VGND VPWR VPWR sky130_fd_sc_hd__decap_4
XFILLER_0_49_481 VPWR VGND VPWR VGND sky130_ef_sc_hd__decap_12
XFILLER_0_91_281 VPWR VGND VPWR VGND sky130_ef_sc_hd__decap_12
XFILLER_0_64_473 VGND VGND VPWR VPWR sky130_fd_sc_hd__decap_3
XFILLER_0_24_359 VGND VGND VPWR VPWR sky130_fd_sc_hd__decap_4
XFILLER_0_36_197 VPWR VGND VPWR VGND sky130_ef_sc_hd__decap_12
XFILLER_0_51_156 VPWR VGND VPWR VGND sky130_ef_sc_hd__decap_12
XFILLER_0_86_29 VPWR VGND VPWR VGND sky130_ef_sc_hd__decap_12
XFILLER_0_32_381 VPWR VGND VPWR VGND sky130_ef_sc_hd__decap_12
XTAP_TAPCELL_ROW_9_282 VGND VPWR sky130_fd_sc_hd__tapvpwrvgnd_1
XFILLER_0_19_67 VGND VGND VPWR VPWR sky130_fd_sc_hd__fill_1
X_4920_ _1424_ _1466_ _1467_ VGND VGND VPWR VPWR _1489_ sky130_fd_sc_hd__nand3_1
XFILLER_0_35_77 VGND VGND VPWR VPWR sky130_fd_sc_hd__fill_1
XFILLER_0_59_256 VGND VGND VPWR VPWR sky130_fd_sc_hd__fill_2
X_4851_ _1414_ _1420_ VGND VGND VPWR VPWR _1421_ sky130_fd_sc_hd__xnor2_1
XFILLER_0_74_204 VGND VGND VPWR VPWR sky130_fd_sc_hd__decap_3
X_3802_ _0367_ _0366_ VGND VGND VPWR VPWR _0395_ sky130_fd_sc_hd__or2b_1
X_4782_ _1350_ _1351_ _0813_ VGND VGND VPWR VPWR _1353_ sky130_fd_sc_hd__a21o_1
XFILLER_0_27_142 VPWR VGND VPWR VGND sky130_ef_sc_hd__decap_12
XFILLER_0_70_421 VGND VGND VPWR VPWR sky130_fd_sc_hd__decap_6
X_3733_ _2949_ _0217_ VGND VGND VPWR VPWR _0328_ sky130_fd_sc_hd__nor2_1
XFILLER_0_15_337 VGND VGND VPWR VPWR sky130_fd_sc_hd__decap_6
X_3664_ _0256_ _0260_ VGND VGND VPWR VPWR _0261_ sky130_fd_sc_hd__xor2_1
X_5403_ u_interface.u_compute_core.relu_data\[24\] u_interface.u_compute_core.relu_data\[23\]
+ _0816_ _0587_ VGND VGND VPWR VPWR _1966_ sky130_fd_sc_hd__and4_1
X_3595_ _3025_ _3032_ VGND VGND VPWR VPWR _3033_ sky130_fd_sc_hd__xnor2_1
XFILLER_0_2_253 VPWR VGND VPWR VGND sky130_ef_sc_hd__decap_12
X_5334_ _1884_ _1896_ _1897_ VGND VGND VPWR VPWR _1898_ sky130_fd_sc_hd__nand3_1
X_5265_ _1669_ _1828_ _1829_ VGND VGND VPWR VPWR _1830_ sky130_fd_sc_hd__or3_1
X_5196_ _1759_ _1760_ _1747_ VGND VGND VPWR VPWR _1762_ sky130_fd_sc_hd__a21o_1
XFILLER_0_48_3 VPWR VGND VPWR VGND sky130_ef_sc_hd__decap_12
X_4216_ _2595_ _2592_ _2589_ _0634_ VGND VGND VPWR VPWR _0795_ sky130_fd_sc_hd__and4_1
X_4147_ _0726_ _0727_ VGND VGND VPWR VPWR _0728_ sky130_fd_sc_hd__xnor2_2
XTAP_TAPCELL_ROW_87_1024 VGND VPWR sky130_fd_sc_hd__tapvpwrvgnd_1
X_4078_ u_interface.u_compute_core.relu_data\[3\] u_interface.u_compute_core.relu_data\[2\]
+ _0556_ _0594_ VGND VGND VPWR VPWR _0660_ sky130_fd_sc_hd__and4_1
XFILLER_0_38_429 VGND VGND VPWR VPWR sky130_fd_sc_hd__fill_2
Xclkload2 clknet_leaf_1_clk VGND VGND VPWR VPWR clkload2/Y sky130_fd_sc_hd__inv_8
XFILLER_0_18_197 VGND VGND VPWR VPWR sky130_fd_sc_hd__fill_1
XFILLER_0_61_432 VGND VGND VPWR VPWR sky130_fd_sc_hd__fill_2
XFILLER_0_21_318 VGND VGND VPWR VPWR sky130_fd_sc_hd__decap_3
XFILLER_0_61_476 VGND VGND VPWR VPWR sky130_fd_sc_hd__fill_1
XFILLER_0_14_392 VGND VGND VPWR VPWR sky130_fd_sc_hd__fill_1
XFILLER_0_14_381 VGND VGND VPWR VPWR sky130_fd_sc_hd__fill_2
XTAP_TAPCELL_ROW_6_252 VGND VPWR sky130_fd_sc_hd__tapvpwrvgnd_1
XTAP_TAPCELL_ROW_77_928 VGND VPWR sky130_fd_sc_hd__tapvpwrvgnd_1
XTAP_TAPCELL_ROW_32_508 VGND VPWR sky130_fd_sc_hd__tapvpwrvgnd_1
XFILLER_0_71_207 VGND VGND VPWR VPWR sky130_fd_sc_hd__fill_2
XFILLER_0_21_24 VPWR VGND VPWR VGND sky130_ef_sc_hd__decap_12
XFILLER_0_21_57 VGND VGND VPWR VPWR sky130_fd_sc_hd__decap_4
XFILLER_0_20_340 VGND VGND VPWR VPWR sky130_fd_sc_hd__decap_8
X_3380_ _2838_ _2839_ VGND VGND VPWR VPWR _2840_ sky130_fd_sc_hd__nand2_1
X_5050_ _1616_ _1615_ _1539_ VGND VGND VPWR VPWR _1618_ sky130_fd_sc_hd__o21a_1
X_4001_ u_interface.u_compute_core.relu_data\[3\] u_interface.u_compute_core.relu_data\[2\]
+ _0489_ _0534_ VGND VGND VPWR VPWR _0585_ sky130_fd_sc_hd__and4_1
XTAP_TAPCELL_ROW_48_652 VGND VPWR sky130_fd_sc_hd__tapvpwrvgnd_1
X_5952_ u_interface.core_attn_out\[27\] u_interface.u_compute_core.u_av.product_reg\[30\]
+ VGND VGND VPWR VPWR _2483_ sky130_fd_sc_hd__or2_1
X_4903_ _1471_ _1470_ _1354_ _1356_ VGND VGND VPWR VPWR _1473_ sky130_fd_sc_hd__o211ai_2
XFILLER_0_75_502 VGND VGND VPWR VPWR sky130_fd_sc_hd__fill_2
XFILLER_0_1_89 VGND VGND VPWR VPWR sky130_fd_sc_hd__fill_2
X_5883_ _2401_ _2409_ _2408_ _2416_ _2407_ VGND VGND VPWR VPWR _2423_ sky130_fd_sc_hd__o311ai_4
XFILLER_0_62_97 VGND VGND VPWR VPWR sky130_fd_sc_hd__decap_6
XFILLER_0_7_323 VGND VGND VPWR VPWR sky130_fd_sc_hd__decap_8
X_4834_ _1404_ VGND VGND VPWR VPWR _1405_ sky130_fd_sc_hd__inv_2
XFILLER_0_28_462 VGND VGND VPWR VPWR sky130_fd_sc_hd__decap_6
X_4765_ _2580_ VGND VGND VPWR VPWR _1337_ sky130_fd_sc_hd__buf_2
X_3716_ _0269_ _0310_ VGND VGND VPWR VPWR _0312_ sky130_fd_sc_hd__and2_1
XFILLER_0_7_389 VGND VGND VPWR VPWR sky130_fd_sc_hd__decap_3
XFILLER_0_55_292 VGND VGND VPWR VPWR sky130_fd_sc_hd__fill_2
X_4696_ _1267_ _1266_ _1264_ VGND VGND VPWR VPWR _1268_ sky130_fd_sc_hd__and3_1
XFILLER_0_70_273 VGND VGND VPWR VPWR sky130_fd_sc_hd__decap_6
XFILLER_0_70_251 VGND VGND VPWR VPWR sky130_fd_sc_hd__fill_1
X_3647_ _0242_ _0243_ _0244_ _0205_ VGND VGND VPWR VPWR _0245_ sky130_fd_sc_hd__a211o_1
X_3578_ _2982_ _3012_ _3015_ VGND VGND VPWR VPWR _3016_ sky130_fd_sc_hd__o21ai_1
X_5317_ _1873_ _1880_ VGND VGND VPWR VPWR _1881_ sky130_fd_sc_hd__xnor2_1
X_5248_ _1809_ _1810_ _1812_ VGND VGND VPWR VPWR _1813_ sky130_fd_sc_hd__nand3_1
X_5179_ _1730_ _1744_ VGND VGND VPWR VPWR _1745_ sky130_fd_sc_hd__xnor2_1
XFILLER_0_78_373 VPWR VGND VPWR VGND sky130_ef_sc_hd__decap_12
XTAP_TAPCELL_ROW_82_975 VGND VPWR sky130_fd_sc_hd__tapvpwrvgnd_1
XFILLER_0_81_505 VPWR VGND VPWR VGND sky130_ef_sc_hd__decap_12
XFILLER_0_61_262 VPWR VGND VPWR VGND sky130_ef_sc_hd__decap_12
XFILLER_0_69_340 VPWR VGND VPWR VGND sky130_ef_sc_hd__decap_12
XTAP_TAPCELL_ROW_17_357 VGND VPWR sky130_fd_sc_hd__tapvpwrvgnd_1
XFILLER_0_57_546 VGND VGND VPWR VPWR sky130_fd_sc_hd__fill_1
XFILLER_0_84_365 VPWR VGND VPWR VGND sky130_ef_sc_hd__decap_12
XFILLER_0_72_505 VPWR VGND VPWR VGND sky130_ef_sc_hd__decap_12
XFILLER_0_44_229 VGND VGND VPWR VPWR sky130_fd_sc_hd__decap_3
XFILLER_0_37_281 VGND VGND VPWR VPWR sky130_fd_sc_hd__fill_1
X_4550_ _1121_ _1122_ _1010_ VGND VGND VPWR VPWR _1124_ sky130_fd_sc_hd__a21o_1
XFILLER_0_25_465 VPWR VGND VPWR VGND sky130_ef_sc_hd__decap_12
XFILLER_0_52_240 VGND VGND VPWR VPWR sky130_fd_sc_hd__decap_8
X_4481_ _2615_ _1054_ _1055_ VGND VGND VPWR VPWR _1056_ sky130_fd_sc_hd__a21bo_1
X_3501_ _2942_ VGND VGND VPWR VPWR _2943_ sky130_fd_sc_hd__inv_2
XFILLER_0_52_273 VGND VGND VPWR VPWR sky130_fd_sc_hd__fill_1
X_3432_ _2832_ u_interface.u_compute_core.mac_accum\[23\] _2872_ _2874_ VGND VGND
+ VPWR VPWR _2884_ sky130_fd_sc_hd__a211o_1
X_6220_ clknet_leaf_12_clk _0133_ VGND VGND VPWR VPWR u_interface.u_compute_core.u_av.product_reg\[27\]
+ sky130_fd_sc_hd__dfxtp_1
X_6151_ clknet_leaf_20_clk _0064_ VGND VGND VPWR VPWR u_interface.u_compute_core.mac_accum\[5\]
+ sky130_fd_sc_hd__dfxtp_1
X_3363_ u_interface.u_compute_core.u_mac.product_reg\[14\] u_interface.u_compute_core.mac_accum\[14\]
+ VGND VGND VPWR VPWR _2825_ sky130_fd_sc_hd__or2_1
X_5102_ _1668_ VGND VGND VPWR VPWR _1669_ sky130_fd_sc_hd__clkbuf_2
X_6082_ _2512_ _2502_ _2581_ VGND VGND VPWR VPWR _2576_ sky130_fd_sc_hd__a21oi_1
X_3294_ _2763_ _2764_ _2765_ VGND VGND VPWR VPWR _2766_ sky130_fd_sc_hd__nand3_1
X_5033_ u_interface.u_compute_core.relu_data\[16\] _0558_ _1504_ _1503_ VGND VGND
+ VPWR VPWR _1601_ sky130_fd_sc_hd__a31o_1
XFILLER_0_32_6 VGND VGND VPWR VPWR sky130_fd_sc_hd__decap_8
XTAP_TAPCELL_ROW_0_203 VGND VPWR sky130_fd_sc_hd__tapvpwrvgnd_1
XFILLER_0_79_137 VGND VGND VPWR VPWR sky130_fd_sc_hd__decap_8
XFILLER_0_73_74 VGND VGND VPWR VPWR sky130_fd_sc_hd__decap_3
XPHY_EDGE_ROW_69_Left_162 VGND VGND VPWR VPWR sky130_fd_sc_hd__decap_3
X_5935_ _2462_ _2465_ _2460_ VGND VGND VPWR VPWR _2468_ sky130_fd_sc_hd__o21a_1
XFILLER_0_63_505 VPWR VGND VPWR VGND sky130_ef_sc_hd__decap_12
X_5866_ _2406_ _2407_ VGND VGND VPWR VPWR _2408_ sky130_fd_sc_hd__nand2_1
X_4817_ _1310_ _1387_ VGND VGND VPWR VPWR _1388_ sky130_fd_sc_hd__xor2_1
XFILLER_0_7_131 VGND VGND VPWR VPWR sky130_fd_sc_hd__decap_4
X_5797_ u_interface.core_attn_out\[7\] u_interface.u_compute_core.u_av.product_reg\[10\]
+ VGND VGND VPWR VPWR _2348_ sky130_fd_sc_hd__nand2_1
XFILLER_0_16_421 VGND VGND VPWR VPWR sky130_fd_sc_hd__decap_4
X_4748_ _1277_ _1278_ _1316_ _1318_ VGND VGND VPWR VPWR _1320_ sky130_fd_sc_hd__a22oi_2
XPHY_EDGE_ROW_78_Left_171 VGND VGND VPWR VPWR sky130_fd_sc_hd__decap_3
XFILLER_0_31_424 VGND VGND VPWR VPWR sky130_fd_sc_hd__decap_8
X_4679_ _0917_ _1250_ _1251_ VGND VGND VPWR VPWR _1252_ sky130_fd_sc_hd__or3_4
XPHY_EDGE_ROW_1_Right_1 VGND VGND VPWR VPWR sky130_fd_sc_hd__decap_3
Xoutput48 net48 VGND VGND VPWR VPWR m_tdata[28] sky130_fd_sc_hd__buf_2
Xoutput37 net37 VGND VGND VPWR VPWR m_tdata[18] sky130_fd_sc_hd__buf_2
XFILLER_0_11_181 VGND VGND VPWR VPWR sky130_fd_sc_hd__decap_6
Xoutput59 net59 VGND VGND VPWR VPWR m_tdata[9] sky130_fd_sc_hd__buf_2
XPHY_EDGE_ROW_87_Left_180 VGND VGND VPWR VPWR sky130_fd_sc_hd__decap_3
XTAP_TAPCELL_ROW_59_758 VGND VPWR sky130_fd_sc_hd__tapvpwrvgnd_1
XFILLER_0_39_513 VPWR VGND VPWR VGND sky130_ef_sc_hd__decap_12
XTAP_TAPCELL_ROW_42_603 VGND VPWR sky130_fd_sc_hd__tapvpwrvgnd_1
XFILLER_0_66_365 VPWR VGND VPWR VGND sky130_ef_sc_hd__decap_12
XFILLER_0_26_218 VGND VGND VPWR VPWR sky130_fd_sc_hd__decap_6
XFILLER_0_19_281 VPWR VGND VPWR VGND sky130_ef_sc_hd__decap_12
XFILLER_0_1_329 VGND VGND VPWR VPWR sky130_fd_sc_hd__decap_6
XFILLER_0_43_55 VGND VGND VPWR VPWR sky130_fd_sc_hd__fill_1
X_3981_ _0564_ _0565_ VGND VGND VPWR VPWR _0566_ sky130_fd_sc_hd__nor2_1
XFILLER_0_57_310 VGND VGND VPWR VPWR sky130_fd_sc_hd__fill_2
XFILLER_0_9_429 VPWR VGND VPWR VGND sky130_ef_sc_hd__decap_12
X_5720_ _2278_ _2223_ VGND VGND VPWR VPWR _2279_ sky130_fd_sc_hd__nor2_1
XFILLER_0_84_173 VGND VGND VPWR VPWR sky130_fd_sc_hd__fill_1
XFILLER_0_45_505 VPWR VGND VPWR VGND sky130_ef_sc_hd__decap_12
XFILLER_0_45_527 VPWR VGND VPWR VGND sky130_ef_sc_hd__decap_12
XFILLER_0_57_387 VGND VGND VPWR VPWR sky130_fd_sc_hd__decap_4
X_5651_ _2130_ _2138_ _2136_ VGND VGND VPWR VPWR _2211_ sky130_fd_sc_hd__a21oi_1
X_4602_ _1101_ net85 net101 net84 VGND VGND VPWR VPWR _1176_ sky130_fd_sc_hd__a211oi_4
X_5582_ _2048_ _2056_ VGND VGND VPWR VPWR _2143_ sky130_fd_sc_hd__or2b_1
XFILLER_0_7_11 VGND VGND VPWR VPWR sky130_fd_sc_hd__decap_3
XFILLER_0_25_284 VPWR VGND VPWR VGND sky130_ef_sc_hd__decap_12
X_4533_ _1105_ _1106_ _0982_ VGND VGND VPWR VPWR _1108_ sky130_fd_sc_hd__o21ai_1
XFILLER_0_68_41 VGND VGND VPWR VPWR sky130_fd_sc_hd__decap_3
X_6203_ clknet_leaf_19_clk _0116_ VGND VGND VPWR VPWR u_interface.u_compute_core.u_av.product_reg\[10\]
+ sky130_fd_sc_hd__dfxtp_1
X_4464_ _1036_ _1039_ VGND VGND VPWR VPWR _1040_ sky130_fd_sc_hd__xor2_1
XFILLER_0_68_85 VPWR VGND VPWR VGND sky130_ef_sc_hd__decap_12
X_3415_ _2860_ _2865_ _2868_ _2740_ VGND VGND VPWR VPWR _2870_ sky130_fd_sc_hd__o31a_1
X_4395_ _0918_ _0970_ _0971_ VGND VGND VPWR VPWR _0972_ sky130_fd_sc_hd__or3_4
XTAP_TAPCELL_ROW_90_1053 VGND VPWR sky130_fd_sc_hd__tapvpwrvgnd_1
X_3346_ net205 _2805_ _2810_ _2741_ VGND VGND VPWR VPWR _0070_ sky130_fd_sc_hd__a22o_1
X_6134_ clknet_leaf_4_clk _0047_ VGND VGND VPWR VPWR u_interface.u_compute_core.scaled_data\[18\]
+ sky130_fd_sc_hd__dfxtp_1
X_6065_ _2670_ _2564_ VGND VGND VPWR VPWR _2565_ sky130_fd_sc_hd__and2_1
X_5016_ _1582_ _1583_ VGND VGND VPWR VPWR _1584_ sky130_fd_sc_hd__or2b_1
X_3277_ u_interface.u_compute_core.u_mac.product_reg\[0\] u_interface.u_compute_core.mac_accum\[0\]
+ _2742_ _2750_ VGND VGND VPWR VPWR _2751_ sky130_fd_sc_hd__a31oi_2
XFILLER_0_30_3 VPWR VGND VPWR VGND sky130_ef_sc_hd__decap_12
XTAP_TAPCELL_ROW_56_728 VGND VPWR sky130_fd_sc_hd__tapvpwrvgnd_1
XFILLER_0_67_129 VGND VGND VPWR VPWR sky130_fd_sc_hd__decap_6
X_5918_ _2452_ _2453_ _2319_ VGND VGND VPWR VPWR _2454_ sky130_fd_sc_hd__a21o_1
XFILLER_0_48_321 VGND VGND VPWR VPWR sky130_fd_sc_hd__decap_8
XTAP_TAPCELL_ROW_11_308 VGND VPWR sky130_fd_sc_hd__tapvpwrvgnd_1
X_5849_ u_interface.core_attn_out\[14\] u_interface.u_compute_core.u_av.product_reg\[17\]
+ VGND VGND VPWR VPWR _2393_ sky130_fd_sc_hd__or2_1
XFILLER_0_90_154 VGND VGND VPWR VPWR sky130_fd_sc_hd__decap_8
XFILLER_0_31_276 VGND VGND VPWR VPWR sky130_fd_sc_hd__decap_4
XTAP_TAPCELL_ROW_27_452 VGND VPWR sky130_fd_sc_hd__tapvpwrvgnd_1
XFILLER_0_39_310 VGND VGND VPWR VPWR sky130_fd_sc_hd__fill_2
XFILLER_0_58_129 VGND VGND VPWR VPWR sky130_fd_sc_hd__fill_2
XFILLER_0_79_490 VGND VGND VPWR VPWR sky130_fd_sc_hd__fill_1
XFILLER_0_66_184 VPWR VGND VPWR VGND sky130_ef_sc_hd__decap_12
XFILLER_0_13_69 VGND VGND VPWR VPWR sky130_fd_sc_hd__decap_4
XFILLER_0_54_324 VPWR VGND VPWR VGND sky130_ef_sc_hd__decap_12
XFILLER_0_42_519 VPWR VGND VPWR VGND sky130_ef_sc_hd__decap_12
X_3200_ _2694_ _2695_ VGND VGND VPWR VPWR _2696_ sky130_fd_sc_hd__and2_1
X_4180_ u_interface.u_compute_core.relu_data\[6\] net21 net22 net86 VGND VGND VPWR
+ VPWR _0760_ sky130_fd_sc_hd__a22o_1
X_3131_ u_interface.u_compute_core.relu_data\[19\] VGND VGND VPWR VPWR _2647_ sky130_fd_sc_hd__buf_2
XFILLER_0_38_77 VGND VGND VPWR VPWR sky130_fd_sc_hd__decap_6
XFILLER_0_89_210 VGND VGND VPWR VPWR sky130_fd_sc_hd__fill_1
X_3062_ _2582_ _2594_ VGND VGND VPWR VPWR _0002_ sky130_fd_sc_hd__nor2_1
XFILLER_0_77_427 VGND VGND VPWR VPWR sky130_fd_sc_hd__fill_1
XFILLER_0_49_129 VGND VGND VPWR VPWR sky130_fd_sc_hd__fill_1
XFILLER_0_77_449 VPWR VGND VPWR VGND sky130_ef_sc_hd__decap_12
XFILLER_0_9_204 VGND VGND VPWR VPWR sky130_fd_sc_hd__decap_6
Xclkbuf_leaf_15_clk clknet_1_1__leaf_clk VGND VGND VPWR VPWR clknet_leaf_15_clk sky130_fd_sc_hd__clkbuf_8
X_3964_ _2595_ u_interface.u_compute_core.relu_data\[2\] _0499_ _0489_ VGND VGND VPWR
+ VPWR _0549_ sky130_fd_sc_hd__and4_1
X_3895_ _0483_ VGND VGND VPWR VPWR _0107_ sky130_fd_sc_hd__clkbuf_1
X_5703_ _0648_ _2200_ _2202_ _2134_ VGND VGND VPWR VPWR _2262_ sky130_fd_sc_hd__o2bb2ai_1
XTAP_TAPCELL_ROW_61_775 VGND VPWR sky130_fd_sc_hd__tapvpwrvgnd_1
XFILLER_0_45_379 VGND VGND VPWR VPWR sky130_fd_sc_hd__fill_1
X_5634_ u_interface.u_compute_core.relu_data\[27\] u_interface.u_compute_core.relu_data\[26\]
+ _0491_ _0536_ VGND VGND VPWR VPWR _2194_ sky130_fd_sc_hd__and4_1
XFILLER_0_78_3 VPWR VGND VPWR VGND sky130_ef_sc_hd__decap_12
Xhold100 u_interface.u_compute_core.mac_accum\[10\] VGND VGND VPWR VPWR net165 sky130_fd_sc_hd__dlygate4sd3_1
X_5565_ u_interface.u_compute_core.relu_data\[27\] u_interface.u_compute_core.relu_data\[26\]
+ _0516_ _0491_ VGND VGND VPWR VPWR _2126_ sky130_fd_sc_hd__and4_1
XFILLER_0_79_95 VGND VGND VPWR VPWR sky130_fd_sc_hd__decap_8
X_4516_ _0812_ _1089_ _1090_ VGND VGND VPWR VPWR _1091_ sky130_fd_sc_hd__nand3_1
XFILLER_0_13_254 VPWR VGND VPWR VGND sky130_ef_sc_hd__decap_12
Xhold111 u_interface.core_attn_out\[7\] VGND VGND VPWR VPWR net176 sky130_fd_sc_hd__dlygate4sd3_1
Xhold133 u_interface.u_compute_core.mac_accum\[0\] VGND VGND VPWR VPWR net198 sky130_fd_sc_hd__dlygate4sd3_1
Xhold122 u_interface.u_compute_core.mac_accum\[27\] VGND VGND VPWR VPWR net187 sky130_fd_sc_hd__dlygate4sd3_1
Xhold144 u_interface.u_compute_core.u_av.product_reg\[20\] VGND VGND VPWR VPWR net209
+ sky130_fd_sc_hd__dlygate4sd3_1
X_5496_ _2047_ _2057_ VGND VGND VPWR VPWR _2058_ sky130_fd_sc_hd__xor2_1
X_4447_ _0835_ _1021_ _1022_ VGND VGND VPWR VPWR _1023_ sky130_fd_sc_hd__nand3_1
Xhold155 u_interface.u_compute_core.u_av.product_reg\[18\] VGND VGND VPWR VPWR net220
+ sky130_fd_sc_hd__dlygate4sd3_1
XFILLER_0_0_181 VGND VGND VPWR VPWR sky130_fd_sc_hd__decap_4
X_4378_ _0953_ _0952_ _0942_ VGND VGND VPWR VPWR _0955_ sky130_fd_sc_hd__a21o_1
X_6117_ clknet_leaf_3_clk _0030_ VGND VGND VPWR VPWR u_interface.u_compute_core.scaled_data\[1\]
+ sky130_fd_sc_hd__dfxtp_1
XTAP_TAPCELL_ROW_69_853 VGND VPWR sky130_fd_sc_hd__tapvpwrvgnd_1
X_3329_ u_interface.u_compute_core.u_mac.product_reg\[9\] u_interface.u_compute_core.mac_accum\[9\]
+ VGND VGND VPWR VPWR _2796_ sky130_fd_sc_hd__nor2_1
X_6048_ _2539_ _2553_ VGND VGND VPWR VPWR _2554_ sky130_fd_sc_hd__and2_1
XFILLER_0_68_416 VGND VGND VPWR VPWR sky130_fd_sc_hd__fill_1
XFILLER_0_36_313 VGND VGND VPWR VPWR sky130_fd_sc_hd__decap_4
XFILLER_0_48_173 VGND VGND VPWR VPWR sky130_fd_sc_hd__fill_1
XFILLER_0_91_441 VGND VGND VPWR VPWR sky130_fd_sc_hd__decap_6
XFILLER_0_91_485 VPWR VGND VPWR VGND sky130_ef_sc_hd__decap_12
XFILLER_0_63_165 VGND VGND VPWR VPWR sky130_fd_sc_hd__decap_3
XFILLER_0_32_541 VGND VGND VPWR VPWR sky130_fd_sc_hd__fill_2
XFILLER_0_59_449 VGND VGND VPWR VPWR sky130_fd_sc_hd__fill_1
XFILLER_0_74_419 VGND VGND VPWR VPWR sky130_fd_sc_hd__fill_1
XFILLER_0_74_408 VGND VGND VPWR VPWR sky130_fd_sc_hd__fill_1
XFILLER_0_27_302 VGND VGND VPWR VPWR sky130_fd_sc_hd__fill_1
XFILLER_0_27_335 VGND VGND VPWR VPWR sky130_fd_sc_hd__fill_1
X_3680_ _0247_ _0234_ _0275_ VGND VGND VPWR VPWR _0277_ sky130_fd_sc_hd__and3_1
XFILLER_0_2_413 VGND VGND VPWR VPWR sky130_fd_sc_hd__decap_6
XFILLER_0_23_541 VGND VGND VPWR VPWR sky130_fd_sc_hd__decap_6
XFILLER_0_40_89 VGND VGND VPWR VPWR sky130_fd_sc_hd__fill_1
X_5350_ _1911_ _1912_ _1909_ VGND VGND VPWR VPWR _1914_ sky130_fd_sc_hd__a21o_1
XFILLER_0_2_457 VPWR VGND VPWR VGND sky130_ef_sc_hd__decap_12
X_5281_ net127 _1845_ VGND VGND VPWR VPWR _1846_ sky130_fd_sc_hd__xor2_1
X_4301_ _0876_ _0877_ _0818_ VGND VGND VPWR VPWR _0879_ sky130_fd_sc_hd__a21o_1
X_4232_ _0635_ _0809_ VGND VGND VPWR VPWR _0811_ sky130_fd_sc_hd__and2_1
Xclkbuf_leaf_4_clk clknet_1_0__leaf_clk VGND VGND VPWR VPWR clknet_leaf_4_clk sky130_fd_sc_hd__clkbuf_8
X_4163_ _0741_ _0742_ VGND VGND VPWR VPWR _0743_ sky130_fd_sc_hd__and2b_1
X_3114_ u_interface.u_compute_core.relu_data\[15\] VGND VGND VPWR VPWR _2634_ sky130_fd_sc_hd__buf_8
X_4094_ _0674_ _0675_ VGND VGND VPWR VPWR _0676_ sky130_fd_sc_hd__xnor2_1
XTAP_TAPCELL_ROW_66_823 VGND VPWR sky130_fd_sc_hd__tapvpwrvgnd_1
X_3045_ _2580_ VGND VGND VPWR VPWR net61 sky130_fd_sc_hd__clkbuf_4
XTAP_TAPCELL_ROW_38_558 VGND VPWR sky130_fd_sc_hd__tapvpwrvgnd_1
XFILLER_0_81_30 VPWR VGND VPWR VGND sky130_ef_sc_hd__decap_12
X_4996_ _1490_ _1498_ _1563_ VGND VGND VPWR VPWR _1564_ sky130_fd_sc_hd__o21ai_1
XTAP_TAPCELL_ROW_21_403 VGND VPWR sky130_fd_sc_hd__tapvpwrvgnd_1
X_3947_ _0531_ _0532_ VGND VGND VPWR VPWR _0533_ sky130_fd_sc_hd__nor2_1
XFILLER_0_45_154 VGND VGND VPWR VPWR sky130_fd_sc_hd__decap_4
X_3878_ _0467_ _0468_ VGND VGND VPWR VPWR _0469_ sky130_fd_sc_hd__nor2_1
XFILLER_0_33_327 VGND VGND VPWR VPWR sky130_fd_sc_hd__decap_8
XFILLER_0_60_113 VGND VGND VPWR VPWR sky130_fd_sc_hd__fill_1
XFILLER_0_14_541 VGND VGND VPWR VPWR sky130_fd_sc_hd__fill_2
XFILLER_0_5_273 VGND VGND VPWR VPWR sky130_fd_sc_hd__decap_6
X_5617_ _2174_ _2176_ VGND VGND VPWR VPWR _2178_ sky130_fd_sc_hd__nor2_1
X_5548_ _2018_ _2021_ _2017_ VGND VGND VPWR VPWR _2110_ sky130_fd_sc_hd__a21oi_1
XFILLER_0_41_360 VPWR VGND VPWR VGND sky130_ef_sc_hd__decap_12
XFILLER_0_41_382 VGND VGND VPWR VPWR sky130_fd_sc_hd__decap_8
XFILLER_0_41_393 VGND VGND VPWR VPWR sky130_fd_sc_hd__decap_6
X_5479_ u_interface.u_compute_core.relu_data\[27\] _0496_ _0516_ u_interface.u_compute_core.relu_data\[26\]
+ VGND VGND VPWR VPWR _2041_ sky130_fd_sc_hd__a22oi_1
XPHY_EDGE_ROW_14_Left_107 VGND VGND VPWR VPWR sky130_fd_sc_hd__decap_3
XFILLER_0_76_290 VGND VGND VPWR VPWR sky130_fd_sc_hd__decap_3
XFILLER_0_64_441 VPWR VGND VPWR VGND sky130_ef_sc_hd__decap_12
XFILLER_0_91_271 VGND VGND VPWR VPWR sky130_fd_sc_hd__decap_8
XFILLER_0_91_293 VPWR VGND VPWR VGND sky130_ef_sc_hd__decap_12
XFILLER_0_20_500 VGND VGND VPWR VPWR sky130_fd_sc_hd__decap_8
XPHY_EDGE_ROW_23_Left_116 VGND VGND VPWR VPWR sky130_fd_sc_hd__decap_3
XFILLER_0_20_533 VGND VGND VPWR VPWR sky130_fd_sc_hd__decap_8
XFILLER_0_32_393 VGND VGND VPWR VPWR sky130_fd_sc_hd__decap_8
XTAP_TAPCELL_ROW_9_283 VGND VPWR sky130_fd_sc_hd__tapvpwrvgnd_1
XPHY_EDGE_ROW_32_Left_125 VGND VGND VPWR VPWR sky130_fd_sc_hd__decap_3
XTAP_TAPCELL_ROW_35_528 VGND VPWR sky130_fd_sc_hd__tapvpwrvgnd_1
X_4850_ _1416_ _1419_ VGND VGND VPWR VPWR _1420_ sky130_fd_sc_hd__xnor2_1
XFILLER_0_74_216 VPWR VGND VPWR VGND sky130_ef_sc_hd__decap_12
XTAP_TAPCELL_ROW_71_870 VGND VPWR sky130_fd_sc_hd__tapvpwrvgnd_1
XFILLER_0_7_505 VPWR VGND VPWR VGND sky130_ef_sc_hd__decap_12
X_3801_ _2890_ _0393_ _0394_ _2745_ net160 VGND VGND VPWR VPWR _0102_ sky130_fd_sc_hd__a32o_1
X_4781_ _0813_ _1350_ _1351_ VGND VGND VPWR VPWR _1352_ sky130_fd_sc_hd__nand3_1
XFILLER_0_70_400 VGND VGND VPWR VPWR sky130_fd_sc_hd__fill_2
XFILLER_0_15_327 VGND VGND VPWR VPWR sky130_fd_sc_hd__decap_3
X_3732_ _0292_ _0295_ _0293_ VGND VGND VPWR VPWR _0327_ sky130_fd_sc_hd__o21ba_1
XFILLER_0_27_154 VPWR VGND VPWR VGND sky130_ef_sc_hd__decap_12
XFILLER_0_70_455 VGND VGND VPWR VPWR sky130_fd_sc_hd__decap_3
XFILLER_0_70_444 VGND VGND VPWR VPWR sky130_fd_sc_hd__decap_6
X_3663_ _0225_ _0259_ VGND VGND VPWR VPWR _0260_ sky130_fd_sc_hd__xnor2_1
Xclkload20 clknet_leaf_19_clk VGND VGND VPWR VPWR clkload20/Y sky130_fd_sc_hd__clkinv_1
XPHY_EDGE_ROW_41_Left_134 VGND VGND VPWR VPWR sky130_fd_sc_hd__decap_3
X_5402_ _2660_ _0490_ _0535_ u_interface.u_compute_core.relu_data\[23\] VGND VGND
+ VPWR VPWR _1965_ sky130_fd_sc_hd__a22oi_1
X_5333_ _1894_ _1895_ _1888_ VGND VGND VPWR VPWR _1897_ sky130_fd_sc_hd__a21o_1
XFILLER_0_11_511 VPWR VGND VPWR VGND sky130_ef_sc_hd__decap_12
X_3594_ _3030_ _3031_ VGND VGND VPWR VPWR _3032_ sky130_fd_sc_hd__and2b_1
XFILLER_0_2_265 VPWR VGND VPWR VGND sky130_ef_sc_hd__decap_12
XFILLER_0_76_41 VGND VGND VPWR VPWR sky130_fd_sc_hd__decap_6
X_5264_ net118 _1600_ _1827_ VGND VGND VPWR VPWR _1829_ sky130_fd_sc_hd__a21oi_1
X_5195_ _1747_ _1759_ _1760_ VGND VGND VPWR VPWR _1761_ sky130_fd_sc_hd__nand3_1
XFILLER_0_76_85 VPWR VGND VPWR VGND sky130_ef_sc_hd__decap_12
X_4215_ _2736_ _0793_ _0794_ net61 VGND VGND VPWR VPWR _0116_ sky130_fd_sc_hd__o211a_1
X_4146_ _0655_ _0677_ _0678_ _0654_ VGND VGND VPWR VPWR _0727_ sky130_fd_sc_hd__a2bb2o_1
XPHY_EDGE_ROW_50_Left_143 VGND VGND VPWR VPWR sky130_fd_sc_hd__decap_3
XTAP_TAPCELL_ROW_87_1025 VGND VPWR sky130_fd_sc_hd__tapvpwrvgnd_1
X_4077_ u_interface.u_compute_core.relu_data\[2\] _0594_ VGND VGND VPWR VPWR _0659_
+ sky130_fd_sc_hd__nand2_1
XFILLER_0_78_533 VPWR VGND VPWR VGND sky130_ef_sc_hd__decap_12
XFILLER_0_65_205 VPWR VGND VPWR VGND sky130_ef_sc_hd__decap_12
XFILLER_0_18_110 VPWR VGND VPWR VGND sky130_ef_sc_hd__decap_12
X_4979_ _1546_ _1545_ _1487_ _1488_ VGND VGND VPWR VPWR _1548_ sky130_fd_sc_hd__o211a_1
Xclkload3 clknet_leaf_2_clk VGND VGND VPWR VPWR clkload3/Y sky130_fd_sc_hd__clkinvlp_4
XFILLER_0_46_463 VGND VGND VPWR VPWR sky130_fd_sc_hd__decap_6
XFILLER_0_33_113 VGND VGND VPWR VPWR sky130_fd_sc_hd__decap_4
XTAP_TAPCELL_ROW_6_253 VGND VPWR sky130_fd_sc_hd__tapvpwrvgnd_1
XTAP_TAPCELL_ROW_77_929 VGND VPWR sky130_fd_sc_hd__tapvpwrvgnd_1
XFILLER_0_37_441 VGND VGND VPWR VPWR sky130_fd_sc_hd__fill_2
XFILLER_0_21_36 VGND VGND VPWR VPWR sky130_fd_sc_hd__decap_8
XFILLER_0_52_411 VGND VGND VPWR VPWR sky130_fd_sc_hd__decap_8
XTAP_TAPCELL_ROW_40_575 VGND VPWR sky130_fd_sc_hd__tapvpwrvgnd_1
XFILLER_0_24_179 VPWR VGND VPWR VGND sky130_ef_sc_hd__decap_12
XFILLER_0_52_477 VPWR VGND VPWR VGND sky130_ef_sc_hd__decap_12
X_4000_ _0582_ _0583_ VGND VGND VPWR VPWR _0584_ sky130_fd_sc_hd__or2_1
XTAP_TAPCELL_ROW_48_653 VGND VPWR sky130_fd_sc_hd__tapvpwrvgnd_1
X_5951_ net179 _2304_ _0981_ _2482_ VGND VGND VPWR VPWR _0164_ sky130_fd_sc_hd__o211a_1
X_4902_ _1354_ _1356_ _1471_ _1470_ VGND VGND VPWR VPWR _1472_ sky130_fd_sc_hd__a211o_4
XFILLER_0_1_68 VPWR VGND VPWR VGND sky130_ef_sc_hd__decap_12
XFILLER_0_1_57 VGND VGND VPWR VPWR sky130_fd_sc_hd__decap_8
X_5882_ _2420_ _2421_ VGND VGND VPWR VPWR _2422_ sky130_fd_sc_hd__nand2_1
XFILLER_0_47_216 VGND VGND VPWR VPWR sky130_fd_sc_hd__decap_8
X_4833_ _1402_ _1400_ _1401_ VGND VGND VPWR VPWR _1404_ sky130_fd_sc_hd__and3_1
XFILLER_0_7_357 VGND VGND VPWR VPWR sky130_fd_sc_hd__fill_1
X_4764_ _0915_ net220 VGND VGND VPWR VPWR _1336_ sky130_fd_sc_hd__or2_1
XFILLER_0_15_113 VGND VGND VPWR VPWR sky130_fd_sc_hd__decap_6
X_3715_ _0269_ _0310_ VGND VGND VPWR VPWR _0311_ sky130_fd_sc_hd__nor2_1
X_4695_ _1193_ _1194_ _1265_ VGND VGND VPWR VPWR _1267_ sky130_fd_sc_hd__a21o_1
XFILLER_0_70_285 VGND VGND VPWR VPWR sky130_fd_sc_hd__fill_2
XFILLER_0_3_541 VGND VGND VPWR VPWR sky130_fd_sc_hd__decap_6
X_3646_ _3042_ VGND VGND VPWR VPWR _0244_ sky130_fd_sc_hd__inv_2
XFILLER_0_30_127 VGND VGND VPWR VPWR sky130_fd_sc_hd__fill_1
XFILLER_0_87_51 VGND VGND VPWR VPWR sky130_fd_sc_hd__decap_4
X_3577_ _2931_ _3013_ _3014_ _2929_ VGND VGND VPWR VPWR _3015_ sky130_fd_sc_hd__a22o_1
X_5316_ _1878_ _1879_ VGND VGND VPWR VPWR _1880_ sky130_fd_sc_hd__xor2_1
X_5247_ _2644_ _0596_ _1732_ _1811_ VGND VGND VPWR VPWR _1812_ sky130_fd_sc_hd__a31o_1
X_5178_ _1742_ _1743_ VGND VGND VPWR VPWR _1744_ sky130_fd_sc_hd__xnor2_1
X_4129_ _0635_ _0708_ VGND VGND VPWR VPWR _0710_ sky130_fd_sc_hd__and2_1
XFILLER_0_78_363 VGND VGND VPWR VPWR sky130_fd_sc_hd__fill_1
XTAP_TAPCELL_ROW_82_976 VGND VPWR sky130_fd_sc_hd__tapvpwrvgnd_1
XFILLER_0_78_385 VGND VGND VPWR VPWR sky130_fd_sc_hd__decap_8
XFILLER_0_38_249 VGND VGND VPWR VPWR sky130_fd_sc_hd__decap_3
XFILLER_0_81_517 VPWR VGND VPWR VGND sky130_ef_sc_hd__decap_12
XFILLER_0_19_463 VGND VGND VPWR VPWR sky130_fd_sc_hd__fill_1
XFILLER_0_46_260 VPWR VGND VPWR VGND sky130_ef_sc_hd__decap_12
XFILLER_0_34_411 VGND VGND VPWR VPWR sky130_fd_sc_hd__fill_1
XFILLER_0_61_274 VGND VGND VPWR VPWR sky130_fd_sc_hd__decap_6
XFILLER_0_16_58 VGND VGND VPWR VPWR sky130_fd_sc_hd__decap_4
XFILLER_0_69_352 VPWR VGND VPWR VGND sky130_ef_sc_hd__decap_12
XTAP_TAPCELL_ROW_45_623 VGND VPWR sky130_fd_sc_hd__tapvpwrvgnd_1
XFILLER_0_69_396 VGND VGND VPWR VPWR sky130_fd_sc_hd__decap_6
XTAP_TAPCELL_ROW_17_358 VGND VPWR sky130_fd_sc_hd__tapvpwrvgnd_1
XFILLER_0_29_216 VGND VGND VPWR VPWR sky130_fd_sc_hd__fill_1
XFILLER_0_84_377 VGND VGND VPWR VPWR sky130_fd_sc_hd__decap_4
XFILLER_0_72_517 VPWR VGND VPWR VGND sky130_ef_sc_hd__decap_12
X_3500_ _2929_ _2935_ _2939_ _2940_ VGND VGND VPWR VPWR _2942_ sky130_fd_sc_hd__and4_1
XFILLER_0_25_477 VPWR VGND VPWR VGND sky130_ef_sc_hd__decap_12
X_4480_ _2615_ _0819_ _0656_ _2611_ VGND VGND VPWR VPWR _1055_ sky130_fd_sc_hd__a22o_1
XFILLER_0_12_127 VPWR VGND VPWR VGND sky130_ef_sc_hd__decap_12
X_3431_ net62 _2878_ _2882_ VGND VGND VPWR VPWR _2883_ sky130_fd_sc_hd__and3_1
XFILLER_0_0_533 VPWR VGND VPWR VGND sky130_ef_sc_hd__decap_12
X_6150_ clknet_leaf_2_clk _0063_ VGND VGND VPWR VPWR u_interface.u_compute_core.mac_accum\[4\]
+ sky130_fd_sc_hd__dfxtp_1
X_3362_ u_interface.u_compute_core.u_mac.product_reg\[14\] u_interface.u_compute_core.mac_accum\[14\]
+ VGND VGND VPWR VPWR _2824_ sky130_fd_sc_hd__nand2_1
X_5101_ _1596_ _1598_ VGND VGND VPWR VPWR _1668_ sky130_fd_sc_hd__nor2b_1
X_6081_ _2575_ VGND VGND VPWR VPWR _0201_ sky130_fd_sc_hd__clkbuf_1
X_3293_ _2758_ _2759_ _2757_ VGND VGND VPWR VPWR _2765_ sky130_fd_sc_hd__a21bo_1
XFILLER_0_57_87 VGND VGND VPWR VPWR sky130_fd_sc_hd__decap_8
X_5032_ _1596_ _1597_ _1447_ VGND VGND VPWR VPWR _1600_ sky130_fd_sc_hd__o21ai_4
XTAP_TAPCELL_ROW_0_204 VGND VPWR sky130_fd_sc_hd__tapvpwrvgnd_1
X_5934_ _2320_ _2466_ _2467_ _2327_ VGND VGND VPWR VPWR _0162_ sky130_fd_sc_hd__o211a_1
XFILLER_0_75_344 VGND VGND VPWR VPWR sky130_fd_sc_hd__decap_6
X_5865_ u_interface.core_attn_out\[16\] u_interface.u_compute_core.u_av.product_reg\[19\]
+ VGND VGND VPWR VPWR _2407_ sky130_fd_sc_hd__nand2_2
X_4816_ _1385_ _1386_ VGND VGND VPWR VPWR _1387_ sky130_fd_sc_hd__and2_4
XFILLER_0_75_388 VGND VGND VPWR VPWR sky130_fd_sc_hd__decap_4
XFILLER_0_75_377 VGND VGND VPWR VPWR sky130_fd_sc_hd__decap_4
XFILLER_0_63_517 VPWR VGND VPWR VGND sky130_ef_sc_hd__decap_12
XFILLER_0_90_336 VGND VGND VPWR VPWR sky130_fd_sc_hd__fill_1
X_5796_ net177 _2304_ _0981_ _2347_ VGND VGND VPWR VPWR _0144_ sky130_fd_sc_hd__o211a_1
X_4747_ _1278_ _1277_ _1316_ _1318_ VGND VGND VPWR VPWR _1319_ sky130_fd_sc_hd__and4_4
XFILLER_0_16_477 VGND VGND VPWR VPWR sky130_fd_sc_hd__fill_1
X_4678_ _1248_ _1249_ net111 _1174_ VGND VGND VPWR VPWR _1251_ sky130_fd_sc_hd__a211oi_2
X_3629_ _2993_ _0225_ _0226_ VGND VGND VPWR VPWR _0227_ sky130_fd_sc_hd__o21a_1
XFILLER_0_31_447 VGND VGND VPWR VPWR sky130_fd_sc_hd__fill_1
Xoutput49 net49 VGND VGND VPWR VPWR m_tdata[29] sky130_fd_sc_hd__buf_2
XFILLER_0_3_393 VPWR VGND VPWR VGND sky130_ef_sc_hd__decap_12
Xoutput38 net38 VGND VGND VPWR VPWR m_tdata[19] sky130_fd_sc_hd__buf_2
XFILLER_0_11_193 VGND VGND VPWR VPWR sky130_fd_sc_hd__decap_8
X_6279_ clknet_leaf_13_clk _0192_ VGND VGND VPWR VPWR net40 sky130_fd_sc_hd__dfxtp_1
XTAP_TAPCELL_ROW_59_759 VGND VPWR sky130_fd_sc_hd__tapvpwrvgnd_1
XFILLER_0_39_503 VGND VGND VPWR VPWR sky130_fd_sc_hd__fill_1
XFILLER_0_39_525 VPWR VGND VPWR VGND sky130_ef_sc_hd__decap_12
XFILLER_0_66_355 VGND VGND VPWR VPWR sky130_fd_sc_hd__fill_2
XTAP_TAPCELL_ROW_14_328 VGND VPWR sky130_fd_sc_hd__tapvpwrvgnd_1
XFILLER_0_66_377 VGND VGND VPWR VPWR sky130_fd_sc_hd__fill_1
XFILLER_0_19_271 VGND VGND VPWR VPWR sky130_fd_sc_hd__decap_8
XFILLER_0_19_293 VGND VGND VPWR VPWR sky130_fd_sc_hd__fill_2
XTAP_TAPCELL_ROW_50_670 VGND VPWR sky130_fd_sc_hd__tapvpwrvgnd_1
XFILLER_0_22_403 VGND VGND VPWR VPWR sky130_fd_sc_hd__decap_3
XFILLER_0_27_35 VPWR VGND VPWR VGND sky130_ef_sc_hd__decap_12
XFILLER_0_27_57 VPWR VGND VPWR VGND sky130_ef_sc_hd__decap_12
XFILLER_0_69_160 VGND VGND VPWR VPWR sky130_fd_sc_hd__decap_8
X_3980_ _0523_ _0538_ _0562_ _0563_ VGND VGND VPWR VPWR _0565_ sky130_fd_sc_hd__o22a_1
XFILLER_0_84_152 VGND VGND VPWR VPWR sky130_fd_sc_hd__decap_8
XFILLER_0_84_141 VGND VGND VPWR VPWR sky130_fd_sc_hd__fill_1
Xclkbuf_0_clk clk VGND VGND VPWR VPWR clknet_0_clk sky130_fd_sc_hd__clkbuf_16
XFILLER_0_45_517 VGND VGND VPWR VPWR sky130_fd_sc_hd__decap_4
X_5650_ _1981_ _2144_ _2068_ VGND VGND VPWR VPWR _2210_ sky130_fd_sc_hd__a21boi_1
X_4601_ _1173_ _1172_ _1093_ _1095_ VGND VGND VPWR VPWR _1175_ sky130_fd_sc_hd__o211a_1
XFILLER_0_45_539 VGND VGND VPWR VPWR sky130_fd_sc_hd__decap_8
X_5581_ _1981_ _2069_ _2068_ VGND VGND VPWR VPWR _2142_ sky130_fd_sc_hd__a21bo_1
X_4532_ _0918_ _1105_ _1106_ VGND VGND VPWR VPWR _1107_ sky130_fd_sc_hd__or3_1
XFILLER_0_4_179 VGND VGND VPWR VPWR sky130_fd_sc_hd__fill_1
XFILLER_0_25_296 VPWR VGND VPWR VGND sky130_ef_sc_hd__decap_12
X_4463_ net132 _1038_ VGND VGND VPWR VPWR _1039_ sky130_fd_sc_hd__nand2_1
X_6202_ clknet_leaf_19_clk _0115_ VGND VGND VPWR VPWR u_interface.u_compute_core.u_av.product_reg\[9\]
+ sky130_fd_sc_hd__dfxtp_1
X_3414_ _2860_ _2865_ _2868_ VGND VGND VPWR VPWR _2869_ sky130_fd_sc_hd__o21ai_1
XPHY_EDGE_ROW_15_Right_15 VGND VGND VPWR VPWR sky130_fd_sc_hd__decap_3
XFILLER_0_7_89 VGND VGND VPWR VPWR sky130_fd_sc_hd__decap_3
X_4394_ _0968_ _0969_ _0899_ _0919_ VGND VGND VPWR VPWR _0971_ sky130_fd_sc_hd__a211oi_2
XTAP_TAPCELL_ROW_90_1054 VGND VPWR sky130_fd_sc_hd__tapvpwrvgnd_1
XFILLER_0_68_97 VGND VGND VPWR VPWR sky130_fd_sc_hd__decap_6
XFILLER_0_0_385 VGND VGND VPWR VPWR sky130_fd_sc_hd__decap_6
X_3345_ _2806_ _2809_ VGND VGND VPWR VPWR _2810_ sky130_fd_sc_hd__xnor2_1
X_6133_ clknet_leaf_4_clk _0046_ VGND VGND VPWR VPWR u_interface.u_compute_core.scaled_data\[17\]
+ sky130_fd_sc_hd__dfxtp_1
XFILLER_0_84_41 VGND VGND VPWR VPWR sky130_fd_sc_hd__decap_8
X_3276_ u_interface.u_compute_core.u_mac.product_reg\[1\] u_interface.u_compute_core.mac_accum\[1\]
+ VGND VGND VPWR VPWR _2750_ sky130_fd_sc_hd__and2_1
X_6064_ net44 u_interface.core_attn_out\[24\] _2544_ VGND VGND VPWR VPWR _2564_ sky130_fd_sc_hd__mux2_1
X_5015_ _2650_ _0525_ _0816_ u_interface.u_compute_core.relu_data\[19\] VGND VGND
+ VPWR VPWR _1583_ sky130_fd_sc_hd__a22o_1
XFILLER_0_23_3 VGND VGND VPWR VPWR sky130_fd_sc_hd__decap_8
XTAP_TAPCELL_ROW_56_729 VGND VPWR sky130_fd_sc_hd__tapvpwrvgnd_1
XPHY_EDGE_ROW_24_Right_24 VGND VGND VPWR VPWR sky130_fd_sc_hd__decap_3
XFILLER_0_75_130 VGND VGND VPWR VPWR sky130_fd_sc_hd__decap_3
X_5917_ _2448_ _2451_ VGND VGND VPWR VPWR _2453_ sky130_fd_sc_hd__nand2_1
XFILLER_0_75_141 VGND VGND VPWR VPWR sky130_fd_sc_hd__fill_2
XFILLER_0_63_303 VGND VGND VPWR VPWR sky130_fd_sc_hd__decap_8
X_5848_ net204 _2309_ _2391_ _2392_ _0855_ VGND VGND VPWR VPWR _0151_ sky130_fd_sc_hd__o221a_1
X_5779_ u_interface.core_attn_out\[4\] _2301_ VGND VGND VPWR VPWR _2333_ sky130_fd_sc_hd__or2_1
XFILLER_0_31_222 VGND VGND VPWR VPWR sky130_fd_sc_hd__fill_2
XPHY_EDGE_ROW_33_Right_33 VGND VGND VPWR VPWR sky130_fd_sc_hd__decap_3
XFILLER_0_12_491 VGND VGND VPWR VPWR sky130_fd_sc_hd__fill_2
XFILLER_0_31_299 VPWR VGND VPWR VGND sky130_ef_sc_hd__decap_12
XPHY_EDGE_ROW_42_Right_42 VGND VGND VPWR VPWR sky130_fd_sc_hd__decap_3
XTAP_TAPCELL_ROW_27_453 VGND VPWR sky130_fd_sc_hd__tapvpwrvgnd_1
XFILLER_0_66_130 VGND VGND VPWR VPWR sky130_fd_sc_hd__decap_8
XFILLER_0_39_333 VGND VGND VPWR VPWR sky130_fd_sc_hd__decap_3
XFILLER_0_66_141 VPWR VGND VPWR VGND sky130_ef_sc_hd__decap_12
XFILLER_0_54_336 VPWR VGND VPWR VGND sky130_ef_sc_hd__decap_12
XPHY_EDGE_ROW_51_Right_51 VGND VGND VPWR VPWR sky130_fd_sc_hd__decap_3
XFILLER_0_10_439 VPWR VGND VPWR VGND sky130_ef_sc_hd__decap_12
X_3130_ _2643_ _2646_ VGND VGND VPWR VPWR _0018_ sky130_fd_sc_hd__nor2_1
X_3061_ u_interface.u_compute_core.scaled_data\[2\] _2584_ _2593_ _2587_ VGND VGND
+ VPWR VPWR _2594_ sky130_fd_sc_hd__o2bb2a_1
XPHY_EDGE_ROW_60_Right_60 VGND VGND VPWR VPWR sky130_fd_sc_hd__decap_3
XFILLER_0_54_66 VGND VGND VPWR VPWR sky130_fd_sc_hd__decap_8
XFILLER_0_54_99 VGND VGND VPWR VPWR sky130_fd_sc_hd__fill_2
X_3963_ _2602_ _0547_ _0523_ VGND VGND VPWR VPWR _0548_ sky130_fd_sc_hd__or3_4
XFILLER_0_85_494 VGND VGND VPWR VPWR sky130_fd_sc_hd__decap_8
XFILLER_0_72_111 VPWR VGND VPWR VGND sky130_ef_sc_hd__decap_12
XFILLER_0_70_54 VGND VGND VPWR VPWR sky130_fd_sc_hd__decap_6
X_3894_ _2587_ _2670_ VGND VGND VPWR VPWR _0483_ sky130_fd_sc_hd__and2_1
X_5702_ _2257_ _2260_ VGND VGND VPWR VPWR _2261_ sky130_fd_sc_hd__xor2_1
XFILLER_0_57_185 VPWR VGND VPWR VGND sky130_ef_sc_hd__decap_12
XTAP_TAPCELL_ROW_61_776 VGND VPWR sky130_fd_sc_hd__tapvpwrvgnd_1
X_5633_ u_interface.u_compute_core.relu_data\[27\] _0491_ _0536_ u_interface.u_compute_core.relu_data\[26\]
+ VGND VGND VPWR VPWR _2193_ sky130_fd_sc_hd__a22oi_1
X_5564_ u_interface.u_compute_core.relu_data\[27\] _0516_ _0491_ u_interface.u_compute_core.relu_data\[26\]
+ VGND VGND VPWR VPWR _2125_ sky130_fd_sc_hd__a22oi_1
X_4515_ _1086_ _1087_ _1088_ VGND VGND VPWR VPWR _1090_ sky130_fd_sc_hd__a21o_1
Xhold101 u_interface.u_compute_core.mac_accum\[18\] VGND VGND VPWR VPWR net166 sky130_fd_sc_hd__dlygate4sd3_1
Xhold112 u_interface.core_attn_out\[6\] VGND VGND VPWR VPWR net177 sky130_fd_sc_hd__dlygate4sd3_1
XFILLER_0_13_266 VPWR VGND VPWR VGND sky130_ef_sc_hd__decap_12
Xhold123 u_interface.core_attn_out\[23\] VGND VGND VPWR VPWR net188 sky130_fd_sc_hd__dlygate4sd3_1
Xhold134 u_interface.u_compute_core.u_av.product_reg\[29\] VGND VGND VPWR VPWR net199
+ sky130_fd_sc_hd__dlygate4sd3_1
X_5495_ _2048_ _2056_ VGND VGND VPWR VPWR _2057_ sky130_fd_sc_hd__xnor2_1
X_4446_ _1018_ _1019_ _1020_ VGND VGND VPWR VPWR _1022_ sky130_fd_sc_hd__a21o_1
Xhold145 u_interface.u_compute_core.u_mac.product_reg\[0\] VGND VGND VPWR VPWR net210
+ sky130_fd_sc_hd__dlygate4sd3_1
Xhold156 u_interface.u_compute_core.u_av.product_reg\[11\] VGND VGND VPWR VPWR net221
+ sky130_fd_sc_hd__dlygate4sd3_1
X_4377_ _0942_ _0952_ _0953_ VGND VGND VPWR VPWR _0954_ sky130_fd_sc_hd__nand3_1
XFILLER_0_0_160 VGND VGND VPWR VPWR sky130_fd_sc_hd__decap_4
X_3328_ u_interface.u_compute_core.u_mac.product_reg\[9\] u_interface.u_compute_core.mac_accum\[9\]
+ VGND VGND VPWR VPWR _2795_ sky130_fd_sc_hd__and2_1
X_6116_ clknet_leaf_3_clk _0029_ VGND VGND VPWR VPWR u_interface.u_compute_core.scaled_data\[0\]
+ sky130_fd_sc_hd__dfxtp_1
XTAP_TAPCELL_ROW_69_854 VGND VPWR sky130_fd_sc_hd__tapvpwrvgnd_1
X_6047_ net37 u_interface.core_attn_out\[18\] _2544_ VGND VGND VPWR VPWR _2553_ sky130_fd_sc_hd__mux2_1
X_3259_ _2735_ VGND VGND VPWR VPWR _2736_ sky130_fd_sc_hd__buf_2
XTAP_TAPCELL_ROW_24_423 VGND VPWR sky130_fd_sc_hd__tapvpwrvgnd_1
XFILLER_0_48_141 VPWR VGND VPWR VGND sky130_ef_sc_hd__decap_12
XFILLER_0_63_111 VGND VGND VPWR VPWR sky130_fd_sc_hd__fill_1
XFILLER_0_91_497 VGND VGND VPWR VPWR sky130_fd_sc_hd__decap_6
XFILLER_0_32_531 VGND VGND VPWR VPWR sky130_fd_sc_hd__fill_1
XFILLER_0_67_494 VGND VGND VPWR VPWR sky130_fd_sc_hd__fill_1
XFILLER_0_82_431 VPWR VGND VPWR VGND sky130_ef_sc_hd__decap_12
XFILLER_0_35_391 VGND VGND VPWR VPWR sky130_fd_sc_hd__fill_1
X_5280_ _1747_ _1760_ _1759_ VGND VGND VPWR VPWR _1845_ sky130_fd_sc_hd__a21bo_1
XFILLER_0_2_469 VGND VGND VPWR VPWR sky130_fd_sc_hd__decap_6
XFILLER_0_49_55 VGND VGND VPWR VPWR sky130_fd_sc_hd__fill_1
XFILLER_0_50_383 VPWR VGND VPWR VGND sky130_ef_sc_hd__decap_12
X_4300_ _0818_ _0876_ _0877_ VGND VGND VPWR VPWR _0878_ sky130_fd_sc_hd__nand3_1
X_4231_ _2585_ _0809_ VGND VGND VPWR VPWR _0810_ sky130_fd_sc_hd__nor2_1
X_4162_ u_interface.u_compute_core.relu_data\[9\] _0503_ _0498_ _2610_ VGND VGND VPWR
+ VPWR _0742_ sky130_fd_sc_hd__a22o_1
X_3113_ _2609_ _2633_ VGND VGND VPWR VPWR _0014_ sky130_fd_sc_hd__nor2_1
XFILLER_0_65_76 VPWR VGND VPWR VGND sky130_ef_sc_hd__decap_12
X_4093_ net65 _0621_ _0620_ VGND VGND VPWR VPWR _0675_ sky130_fd_sc_hd__a21oi_1
XTAP_TAPCELL_ROW_66_824 VGND VPWR sky130_fd_sc_hd__tapvpwrvgnd_1
X_3044_ _2579_ VGND VGND VPWR VPWR _2580_ sky130_fd_sc_hd__buf_2
XFILLER_0_77_203 VGND VGND VPWR VPWR sky130_fd_sc_hd__decap_3
XTAP_TAPCELL_ROW_38_559 VGND VPWR sky130_fd_sc_hd__tapvpwrvgnd_1
XFILLER_0_81_42 VGND VGND VPWR VPWR sky130_fd_sc_hd__fill_1
X_4995_ _1417_ _1494_ VGND VGND VPWR VPWR _1563_ sky130_fd_sc_hd__nand2_2
XFILLER_0_18_325 VGND VGND VPWR VPWR sky130_fd_sc_hd__decap_6
XFILLER_0_45_111 VGND VGND VPWR VPWR sky130_fd_sc_hd__fill_1
X_3946_ _0505_ _0524_ _0530_ VGND VGND VPWR VPWR _0532_ sky130_fd_sc_hd__nor3_1
XFILLER_0_73_431 VPWR VGND VPWR VGND sky130_ef_sc_hd__decap_12
XFILLER_0_14_91 VPWR VGND VPWR VGND sky130_ef_sc_hd__decap_12
XFILLER_0_90_3 VPWR VGND VPWR VGND sky130_ef_sc_hd__decap_12
X_3877_ _0466_ _0455_ VGND VGND VPWR VPWR _0468_ sky130_fd_sc_hd__and2b_1
X_5616_ _2174_ _2176_ VGND VGND VPWR VPWR _2177_ sky130_fd_sc_hd__and2_1
X_5547_ _2106_ _2108_ VGND VGND VPWR VPWR _2109_ sky130_fd_sc_hd__xnor2_1
XFILLER_0_41_372 VGND VGND VPWR VPWR sky130_fd_sc_hd__fill_2
X_5478_ _1963_ _1971_ VGND VGND VPWR VPWR _2040_ sky130_fd_sc_hd__or2_1
X_4429_ _1003_ _1004_ VGND VGND VPWR VPWR _1005_ sky130_fd_sc_hd__and2_4
XFILLER_0_68_236 VGND VGND VPWR VPWR sky130_fd_sc_hd__fill_1
XFILLER_0_64_453 VPWR VGND VPWR VGND sky130_ef_sc_hd__decap_12
XFILLER_0_91_250 VGND VGND VPWR VPWR sky130_fd_sc_hd__decap_6
XTAP_TAPCELL_ROW_9_284 VGND VPWR sky130_fd_sc_hd__tapvpwrvgnd_1
XFILLER_0_35_57 VGND VGND VPWR VPWR sky130_fd_sc_hd__decap_3
XTAP_TAPCELL_ROW_35_529 VGND VPWR sky130_fd_sc_hd__tapvpwrvgnd_1
XFILLER_0_59_214 VGND VGND VPWR VPWR sky130_fd_sc_hd__decap_8
XFILLER_0_59_225 VPWR VGND VPWR VGND sky130_ef_sc_hd__decap_12
X_4780_ _1348_ _1347_ _1349_ VGND VGND VPWR VPWR _1351_ sky130_fd_sc_hd__a21o_1
XFILLER_0_74_228 VPWR VGND VPWR VGND sky130_ef_sc_hd__decap_12
X_3800_ _0356_ _0359_ _0392_ VGND VGND VPWR VPWR _0394_ sky130_fd_sc_hd__a21o_1
XTAP_TAPCELL_ROW_71_871 VGND VPWR sky130_fd_sc_hd__tapvpwrvgnd_1
XFILLER_0_7_517 VPWR VGND VPWR VGND sky130_ef_sc_hd__decap_12
X_3731_ _0299_ _0305_ _0297_ VGND VGND VPWR VPWR _0326_ sky130_fd_sc_hd__o21a_1
XFILLER_0_55_442 VGND VGND VPWR VPWR sky130_fd_sc_hd__decap_6
XFILLER_0_82_272 VPWR VGND VPWR VGND sky130_ef_sc_hd__decap_12
XFILLER_0_27_166 VGND VGND VPWR VPWR sky130_fd_sc_hd__fill_2
X_3662_ _0257_ _0258_ VGND VGND VPWR VPWR _0259_ sky130_fd_sc_hd__nor2_1
Xclkload10 clknet_leaf_22_clk VGND VGND VPWR VPWR clkload10/Y sky130_fd_sc_hd__clkinv_4
X_3593_ _2985_ _2987_ _3029_ VGND VGND VPWR VPWR _3031_ sky130_fd_sc_hd__or3b_1
Xclkload21 clknet_leaf_21_clk VGND VGND VPWR VPWR clkload21/Y sky130_fd_sc_hd__inv_6
XFILLER_0_42_147 VGND VGND VPWR VPWR sky130_fd_sc_hd__fill_1
X_5401_ _2655_ _0536_ _1876_ _1875_ VGND VGND VPWR VPWR _1964_ sky130_fd_sc_hd__a31o_1
X_5332_ _1888_ _1894_ _1895_ VGND VGND VPWR VPWR _1896_ sky130_fd_sc_hd__nand3_1
XFILLER_0_11_523 VPWR VGND VPWR VGND sky130_ef_sc_hd__decap_12
XFILLER_0_2_277 VPWR VGND VPWR VGND sky130_ef_sc_hd__decap_12
X_5263_ _1599_ _1600_ _1827_ VGND VGND VPWR VPWR _1828_ sky130_fd_sc_hd__and3_1
X_5194_ _1757_ _1758_ _1748_ VGND VGND VPWR VPWR _1760_ sky130_fd_sc_hd__o21ai_1
X_4214_ _0521_ u_interface.u_compute_core.u_av.product_reg\[10\] VGND VGND VPWR VPWR
+ _0794_ sky130_fd_sc_hd__or2_1
XFILLER_0_76_97 VPWR VGND VPWR VGND sky130_ef_sc_hd__decap_12
X_4145_ _0699_ _0725_ VGND VGND VPWR VPWR _0726_ sky130_fd_sc_hd__xor2_2
XFILLER_0_92_41 VPWR VGND VPWR VGND sky130_ef_sc_hd__decap_12
XTAP_TAPCELL_ROW_87_1026 VGND VPWR sky130_fd_sc_hd__tapvpwrvgnd_1
X_4076_ u_interface.u_compute_core.relu_data\[3\] _0556_ VGND VGND VPWR VPWR _0658_
+ sky130_fd_sc_hd__nand2_1
XFILLER_0_92_85 VPWR VGND VPWR VGND sky130_ef_sc_hd__decap_12
XFILLER_0_78_545 VGND VGND VPWR VPWR sky130_fd_sc_hd__fill_2
X_4978_ _1487_ _1488_ _1545_ _1546_ VGND VGND VPWR VPWR _1547_ sky130_fd_sc_hd__a211oi_2
XFILLER_0_18_122 VGND VGND VPWR VPWR sky130_fd_sc_hd__decap_8
XFILLER_0_58_291 VGND VGND VPWR VPWR sky130_fd_sc_hd__decap_4
X_3929_ _0500_ VGND VGND VPWR VPWR _0516_ sky130_fd_sc_hd__clkbuf_4
XFILLER_0_73_272 VGND VGND VPWR VPWR sky130_fd_sc_hd__fill_1
Xclkload4 clknet_leaf_3_clk VGND VGND VPWR VPWR clkload4/Y sky130_fd_sc_hd__inv_8
XFILLER_0_61_401 VGND VGND VPWR VPWR sky130_fd_sc_hd__fill_2
XFILLER_0_61_412 VPWR VGND VPWR VGND sky130_ef_sc_hd__decap_12
XFILLER_0_46_497 VGND VGND VPWR VPWR sky130_fd_sc_hd__decap_8
XFILLER_0_61_456 VPWR VGND VPWR VGND sky130_ef_sc_hd__decap_12
XTAP_TAPCELL_ROW_6_254 VGND VPWR sky130_fd_sc_hd__tapvpwrvgnd_1
XFILLER_0_69_501 VGND VGND VPWR VPWR sky130_fd_sc_hd__decap_3
XFILLER_0_84_504 VPWR VGND VPWR VGND sky130_ef_sc_hd__decap_12
XFILLER_0_21_15 VGND VGND VPWR VPWR sky130_fd_sc_hd__decap_3
XFILLER_0_37_497 VGND VGND VPWR VPWR sky130_fd_sc_hd__decap_6
XTAP_TAPCELL_ROW_40_576 VGND VPWR sky130_fd_sc_hd__tapvpwrvgnd_1
XFILLER_0_52_489 VGND VGND VPWR VPWR sky130_fd_sc_hd__decap_8
XFILLER_0_32_180 VGND VGND VPWR VPWR sky130_fd_sc_hd__decap_8
XFILLER_0_46_23 VGND VGND VPWR VPWR sky130_fd_sc_hd__fill_2
X_5950_ _2480_ _2481_ _2309_ VGND VGND VPWR VPWR _2482_ sky130_fd_sc_hd__o21ai_1
XTAP_TAPCELL_ROW_48_654 VGND VPWR sky130_fd_sc_hd__tapvpwrvgnd_1
X_4901_ _1469_ _1468_ _1409_ _1392_ VGND VGND VPWR VPWR _1471_ sky130_fd_sc_hd__o211a_1
X_5881_ u_interface.core_attn_out\[18\] u_interface.u_compute_core.u_av.product_reg\[21\]
+ VGND VGND VPWR VPWR _2421_ sky130_fd_sc_hd__nand2_1
X_4832_ _1400_ _1401_ _1402_ VGND VGND VPWR VPWR _1403_ sky130_fd_sc_hd__a21o_1
X_4763_ _1330_ _1334_ VGND VGND VPWR VPWR _1335_ sky130_fd_sc_hd__xor2_1
X_4694_ _1193_ _1194_ _1265_ VGND VGND VPWR VPWR _1266_ sky130_fd_sc_hd__nand3_1
X_3714_ _0225_ _0257_ _0258_ VGND VGND VPWR VPWR _0310_ sky130_fd_sc_hd__o21ba_1
XFILLER_0_15_169 VGND VGND VPWR VPWR sky130_fd_sc_hd__decap_6
X_3645_ _0240_ _0241_ _3037_ _3040_ VGND VGND VPWR VPWR _0243_ sky130_fd_sc_hd__o211ai_2
X_3576_ net8 VGND VGND VPWR VPWR _3014_ sky130_fd_sc_hd__clkbuf_2
X_5315_ _2655_ _0491_ _1792_ _1791_ VGND VGND VPWR VPWR _1879_ sky130_fd_sc_hd__a31o_1
X_5246_ _1509_ _1209_ _0816_ _0702_ VGND VGND VPWR VPWR _1811_ sky130_fd_sc_hd__and4_1
XFILLER_0_11_386 VGND VGND VPWR VPWR sky130_fd_sc_hd__decap_6
XFILLER_0_53_3 VPWR VGND VPWR VGND sky130_ef_sc_hd__decap_12
XPHY_EDGE_ROW_89_Right_89 VGND VGND VPWR VPWR sky130_fd_sc_hd__decap_3
X_5177_ _1654_ _1658_ _1659_ _1653_ _1652_ VGND VGND VPWR VPWR _1743_ sky130_fd_sc_hd__a32o_1
XTAP_TAPCELL_ROW_3_224 VGND VPWR sky130_fd_sc_hd__tapvpwrvgnd_1
X_4128_ _0635_ _0708_ VGND VGND VPWR VPWR _0709_ sky130_fd_sc_hd__nor2_1
X_4059_ _0592_ _0591_ VGND VGND VPWR VPWR _0642_ sky130_fd_sc_hd__and2b_1
XFILLER_0_78_331 VPWR VGND VPWR VGND sky130_ef_sc_hd__decap_12
XTAP_TAPCELL_ROW_82_977 VGND VPWR sky130_fd_sc_hd__tapvpwrvgnd_1
XFILLER_0_19_431 VGND VGND VPWR VPWR sky130_fd_sc_hd__fill_1
XFILLER_0_81_529 VPWR VGND VPWR VGND sky130_ef_sc_hd__decap_12
XFILLER_0_34_434 VGND VGND VPWR VPWR sky130_fd_sc_hd__fill_1
XFILLER_0_46_272 VPWR VGND VPWR VGND sky130_ef_sc_hd__decap_12
XFILLER_0_88_139 VGND VGND VPWR VPWR sky130_fd_sc_hd__fill_1
XFILLER_0_16_37 VGND VGND VPWR VPWR sky130_fd_sc_hd__decap_3
XTAP_TAPCELL_ROW_45_624 VGND VPWR sky130_fd_sc_hd__tapvpwrvgnd_1
XFILLER_0_69_364 VGND VGND VPWR VPWR sky130_fd_sc_hd__fill_1
XTAP_TAPCELL_ROW_17_359 VGND VPWR sky130_fd_sc_hd__tapvpwrvgnd_1
XFILLER_0_57_526 VPWR VGND VPWR VGND sky130_ef_sc_hd__decap_12
XFILLER_0_72_529 VGND VGND VPWR VPWR sky130_fd_sc_hd__decap_3
XFILLER_0_25_401 VGND VGND VPWR VPWR sky130_fd_sc_hd__fill_1
XFILLER_0_25_445 VGND VGND VPWR VPWR sky130_fd_sc_hd__decap_3
XFILLER_0_25_489 VGND VGND VPWR VPWR sky130_fd_sc_hd__decap_4
XFILLER_0_40_404 VGND VGND VPWR VPWR sky130_fd_sc_hd__fill_2
XFILLER_0_12_139 VGND VGND VPWR VPWR sky130_fd_sc_hd__fill_1
XFILLER_0_0_501 VGND VGND VPWR VPWR sky130_fd_sc_hd__decap_3
X_3430_ _2861_ _2868_ _2873_ VGND VGND VPWR VPWR _2882_ sky130_fd_sc_hd__and3_1
XFILLER_0_0_545 VGND VGND VPWR VPWR sky130_fd_sc_hd__fill_2
X_3361_ u_interface.u_compute_core.u_mac.product_reg\[13\] u_interface.u_compute_core.mac_accum\[13\]
+ VGND VGND VPWR VPWR _2823_ sky130_fd_sc_hd__nand2_1
X_5100_ _1607_ _1609_ VGND VGND VPWR VPWR _1667_ sky130_fd_sc_hd__nand2_1
X_6080_ _2670_ _2574_ VGND VGND VPWR VPWR _2575_ sky130_fd_sc_hd__and2_1
X_5031_ _1598_ VGND VGND VPWR VPWR _1599_ sky130_fd_sc_hd__buf_6
X_3292_ u_interface.u_compute_core.u_mac.product_reg\[4\] u_interface.u_compute_core.mac_accum\[4\]
+ VGND VGND VPWR VPWR _2764_ sky130_fd_sc_hd__or2_1
X_5933_ u_interface.core_attn_out\[24\] _2308_ VGND VGND VPWR VPWR _2467_ sky130_fd_sc_hd__or2_1
XFILLER_0_75_334 VGND VGND VPWR VPWR sky130_fd_sc_hd__fill_2
X_5864_ u_interface.core_attn_out\[16\] u_interface.u_compute_core.u_av.product_reg\[19\]
+ VGND VGND VPWR VPWR _2406_ sky130_fd_sc_hd__or2_1
X_4815_ _1383_ _1384_ _1374_ VGND VGND VPWR VPWR _1386_ sky130_fd_sc_hd__a21o_1
XFILLER_0_63_529 VPWR VGND VPWR VGND sky130_ef_sc_hd__decap_12
XFILLER_0_28_250 VGND VGND VPWR VPWR sky130_fd_sc_hd__fill_2
X_5795_ _2345_ _2346_ _2319_ VGND VGND VPWR VPWR _2347_ sky130_fd_sc_hd__a21o_1
X_4746_ _1317_ _1313_ _1214_ _1241_ VGND VGND VPWR VPWR _1318_ sky130_fd_sc_hd__a2bb2o_4
X_4677_ net110 net102 _1249_ _1248_ VGND VGND VPWR VPWR _1250_ sky130_fd_sc_hd__o211a_4
X_3628_ net4 _2992_ net17 net25 VGND VGND VPWR VPWR _0226_ sky130_fd_sc_hd__a22o_1
XFILLER_0_3_361 VPWR VGND VPWR VGND sky130_ef_sc_hd__decap_12
Xoutput28 net28 VGND VGND VPWR VPWR m_tdata[0] sky130_fd_sc_hd__buf_2
Xoutput39 net39 VGND VGND VPWR VPWR m_tdata[1] sky130_fd_sc_hd__buf_2
X_3559_ _2963_ _2996_ VGND VGND VPWR VPWR _2998_ sky130_fd_sc_hd__nand2_1
X_6278_ clknet_leaf_13_clk _0191_ VGND VGND VPWR VPWR net38 sky130_fd_sc_hd__dfxtp_1
X_5229_ u_interface.u_compute_core.relu_data\[22\] _0491_ VGND VGND VPWR VPWR _1794_
+ sky130_fd_sc_hd__nand2_1
XFILLER_0_66_312 VGND VGND VPWR VPWR sky130_fd_sc_hd__decap_4
XFILLER_0_78_194 VGND VGND VPWR VPWR sky130_fd_sc_hd__fill_2
XFILLER_0_39_537 VGND VGND VPWR VPWR sky130_fd_sc_hd__decap_8
XTAP_TAPCELL_ROW_14_329 VGND VPWR sky130_fd_sc_hd__tapvpwrvgnd_1
XFILLER_0_81_337 VGND VGND VPWR VPWR sky130_fd_sc_hd__decap_6
XTAP_TAPCELL_ROW_50_671 VGND VPWR sky130_fd_sc_hd__tapvpwrvgnd_1
XFILLER_0_27_47 VGND VGND VPWR VPWR sky130_fd_sc_hd__decap_8
XFILLER_0_27_69 VGND VGND VPWR VPWR sky130_fd_sc_hd__decap_6
XFILLER_0_43_35 VPWR VGND VPWR VGND sky130_ef_sc_hd__decap_12
XFILLER_0_9_409 VPWR VGND VPWR VGND sky130_ef_sc_hd__decap_12
XFILLER_0_43_57 VGND VGND VPWR VPWR sky130_fd_sc_hd__decap_4
XFILLER_0_17_209 VGND VGND VPWR VPWR sky130_fd_sc_hd__fill_1
XFILLER_0_57_367 VGND VGND VPWR VPWR sky130_fd_sc_hd__decap_3
XFILLER_0_84_197 VGND VGND VPWR VPWR sky130_fd_sc_hd__decap_8
X_4600_ _1093_ _1095_ _1173_ _1172_ VGND VGND VPWR VPWR _1174_ sky130_fd_sc_hd__a211oi_4
X_5580_ _2124_ _2140_ VGND VGND VPWR VPWR _2141_ sky130_fd_sc_hd__xnor2_1
X_4531_ _1101_ _1102_ _1104_ VGND VGND VPWR VPWR _1106_ sky130_fd_sc_hd__a21oi_2
XFILLER_0_40_201 VGND VGND VPWR VPWR sky130_fd_sc_hd__fill_1
XFILLER_0_80_392 VGND VGND VPWR VPWR sky130_fd_sc_hd__decap_4
X_4462_ _0908_ _0975_ net78 VGND VGND VPWR VPWR _1038_ sky130_fd_sc_hd__o21ba_1
XFILLER_0_7_57 VGND VGND VPWR VPWR sky130_fd_sc_hd__fill_1
X_6201_ clknet_leaf_19_clk _0114_ VGND VGND VPWR VPWR u_interface.u_compute_core.u_av.product_reg\[8\]
+ sky130_fd_sc_hd__dfxtp_1
X_3413_ _2832_ u_interface.u_compute_core.mac_accum\[21\] VGND VGND VPWR VPWR _2868_
+ sky130_fd_sc_hd__xor2_1
XFILLER_0_40_256 VPWR VGND VPWR VGND sky130_ef_sc_hd__decap_12
X_4393_ _0899_ _0919_ _0968_ _0969_ VGND VGND VPWR VPWR _0970_ sky130_fd_sc_hd__o211a_4
XTAP_TAPCELL_ROW_90_1055 VGND VPWR sky130_fd_sc_hd__tapvpwrvgnd_1
X_3344_ _2807_ _2808_ VGND VGND VPWR VPWR _2809_ sky130_fd_sc_hd__nand2_1
X_6132_ clknet_leaf_2_clk _0045_ VGND VGND VPWR VPWR u_interface.u_compute_core.scaled_data\[16\]
+ sky130_fd_sc_hd__dfxtp_1
X_3275_ _2747_ _2748_ VGND VGND VPWR VPWR _2749_ sky130_fd_sc_hd__or2_1
X_6063_ _2563_ VGND VGND VPWR VPWR _0195_ sky130_fd_sc_hd__clkbuf_1
X_5014_ u_interface.u_compute_core.relu_data\[20\] u_interface.u_compute_core.relu_data\[19\]
+ _0499_ _0816_ VGND VGND VPWR VPWR _1582_ sky130_fd_sc_hd__and4_1
XFILLER_0_16_3 VPWR VGND VPWR VGND sky130_ef_sc_hd__decap_12
XFILLER_0_17_91 VGND VGND VPWR VPWR sky130_fd_sc_hd__decap_4
X_5916_ _2448_ _2451_ VGND VGND VPWR VPWR _2452_ sky130_fd_sc_hd__or2_1
X_5847_ _2389_ _2390_ _2318_ VGND VGND VPWR VPWR _2392_ sky130_fd_sc_hd__a21o_1
XFILLER_0_8_475 VGND VGND VPWR VPWR sky130_fd_sc_hd__fill_1
X_5778_ _2330_ _2331_ VGND VGND VPWR VPWR _2332_ sky130_fd_sc_hd__xor2_1
X_4729_ _1288_ _1299_ VGND VGND VPWR VPWR _1301_ sky130_fd_sc_hd__and2_1
XFILLER_0_16_253 VGND VGND VPWR VPWR sky130_fd_sc_hd__decap_4
XFILLER_0_31_201 VGND VGND VPWR VPWR sky130_fd_sc_hd__decap_8
XFILLER_0_79_470 VPWR VGND VPWR VGND sky130_ef_sc_hd__decap_12
XTAP_TAPCELL_ROW_27_454 VGND VPWR sky130_fd_sc_hd__tapvpwrvgnd_1
XFILLER_0_66_153 VPWR VGND VPWR VGND sky130_ef_sc_hd__decap_12
XFILLER_0_66_197 VPWR VGND VPWR VGND sky130_ef_sc_hd__decap_12
XFILLER_0_66_175 VGND VGND VPWR VPWR sky130_fd_sc_hd__fill_1
XFILLER_0_54_348 VGND VGND VPWR VPWR sky130_fd_sc_hd__decap_4
XFILLER_0_54_359 VGND VGND VPWR VPWR sky130_fd_sc_hd__decap_4
XFILLER_0_81_167 VGND VGND VPWR VPWR sky130_fd_sc_hd__fill_1
XFILLER_0_22_212 VGND VGND VPWR VPWR sky130_fd_sc_hd__decap_4
XFILLER_0_62_392 VGND VGND VPWR VPWR sky130_fd_sc_hd__decap_3
X_3060_ _2592_ VGND VGND VPWR VPWR _2593_ sky130_fd_sc_hd__inv_2
XFILLER_0_85_440 VGND VGND VPWR VPWR sky130_fd_sc_hd__fill_2
X_3962_ _0495_ VGND VGND VPWR VPWR _0547_ sky130_fd_sc_hd__inv_2
X_5701_ _1644_ _2258_ _2259_ VGND VGND VPWR VPWR _2260_ sky130_fd_sc_hd__a21o_1
XFILLER_0_57_153 VGND VGND VPWR VPWR sky130_fd_sc_hd__decap_4
X_3893_ _2834_ _2805_ _0471_ _0482_ VGND VGND VPWR VPWR _0106_ sky130_fd_sc_hd__a22o_1
XFILLER_0_57_197 VGND VGND VPWR VPWR sky130_fd_sc_hd__decap_4
XTAP_TAPCELL_ROW_61_777 VGND VPWR sky130_fd_sc_hd__tapvpwrvgnd_1
XFILLER_0_72_123 VGND VGND VPWR VPWR sky130_fd_sc_hd__fill_2
X_5632_ _2129_ _2139_ VGND VGND VPWR VPWR _2192_ sky130_fd_sc_hd__nand2_1
XFILLER_0_72_189 VGND VGND VPWR VPWR sky130_fd_sc_hd__fill_2
X_5563_ _2047_ _2057_ VGND VGND VPWR VPWR _2124_ sky130_fd_sc_hd__nand2_1
XFILLER_0_79_31 VPWR VGND VPWR VGND sky130_ef_sc_hd__decap_12
X_4514_ _1086_ _1087_ _1088_ VGND VGND VPWR VPWR _1089_ sky130_fd_sc_hd__nand3_1
XFILLER_0_13_223 VGND VGND VPWR VPWR sky130_fd_sc_hd__fill_1
XFILLER_0_13_212 VGND VGND VPWR VPWR sky130_fd_sc_hd__fill_1
XFILLER_0_79_64 VGND VGND VPWR VPWR sky130_fd_sc_hd__fill_1
Xhold124 u_interface.core_attn_out\[30\] VGND VGND VPWR VPWR net189 sky130_fd_sc_hd__dlygate4sd3_1
Xhold102 u_interface.u_compute_core.mac_accum\[29\] VGND VGND VPWR VPWR net167 sky130_fd_sc_hd__dlygate4sd3_1
Xhold113 u_interface.u_compute_core.mac_accum\[25\] VGND VGND VPWR VPWR net178 sky130_fd_sc_hd__dlygate4sd3_1
Xhold135 u_interface.u_compute_core.mac_accum\[13\] VGND VGND VPWR VPWR net200 sky130_fd_sc_hd__dlygate4sd3_1
X_5494_ _2054_ _2055_ VGND VGND VPWR VPWR _2056_ sky130_fd_sc_hd__and2_1
X_4445_ _1018_ _1019_ _1020_ VGND VGND VPWR VPWR _1021_ sky130_fd_sc_hd__nand3_1
XFILLER_0_13_278 VGND VGND VPWR VPWR sky130_fd_sc_hd__fill_2
Xhold157 net60 VGND VGND VPWR VPWR net222 sky130_fd_sc_hd__dlygate4sd3_1
Xhold146 u_interface.u_compute_core.u_av.product_reg\[26\] VGND VGND VPWR VPWR net211
+ sky130_fd_sc_hd__dlygate4sd3_1
X_4376_ _0950_ _0951_ _0943_ VGND VGND VPWR VPWR _0953_ sky130_fd_sc_hd__a21o_1
X_3327_ _2789_ _2790_ _2788_ VGND VGND VPWR VPWR _2794_ sky130_fd_sc_hd__a21bo_1
X_6115_ clknet_leaf_19_clk _0028_ VGND VGND VPWR VPWR u_interface.u_compute_core.scaled_valid
+ sky130_fd_sc_hd__dfxtp_1
XTAP_TAPCELL_ROW_69_855 VGND VPWR sky130_fd_sc_hd__tapvpwrvgnd_1
X_6046_ _2552_ VGND VGND VPWR VPWR _0189_ sky130_fd_sc_hd__clkbuf_1
X_3258_ u_interface.u_compute_core.relu_valid VGND VGND VPWR VPWR _2735_ sky130_fd_sc_hd__inv_2
X_3189_ _2672_ _2687_ VGND VGND VPWR VPWR _2688_ sky130_fd_sc_hd__and2_1
XTAP_TAPCELL_ROW_24_424 VGND VPWR sky130_fd_sc_hd__tapvpwrvgnd_1
XFILLER_0_48_153 VGND VGND VPWR VPWR sky130_fd_sc_hd__decap_8
XFILLER_0_76_484 VGND VGND VPWR VPWR sky130_fd_sc_hd__decap_8
XFILLER_0_17_540 VGND VGND VPWR VPWR sky130_fd_sc_hd__decap_3
XFILLER_0_5_3 VPWR VGND VPWR VGND sky130_ef_sc_hd__decap_12
XFILLER_0_24_15 VGND VGND VPWR VPWR sky130_fd_sc_hd__decap_4
XFILLER_0_86_226 VGND VGND VPWR VPWR sky130_fd_sc_hd__fill_1
XFILLER_0_67_484 VGND VGND VPWR VPWR sky130_fd_sc_hd__decap_3
XFILLER_0_39_186 VPWR VGND VPWR VGND sky130_ef_sc_hd__decap_12
XFILLER_0_50_395 VGND VGND VPWR VPWR sky130_fd_sc_hd__decap_8
X_4230_ _0657_ _0750_ _0704_ _0795_ VGND VGND VPWR VPWR _0809_ sky130_fd_sc_hd__a31o_1
X_4161_ u_interface.u_compute_core.relu_data\[9\] _2610_ _0503_ _0498_ VGND VGND VPWR
+ VPWR _0741_ sky130_fd_sc_hd__and4_1
X_3112_ u_interface.u_compute_core.scaled_data\[14\] _2618_ _2632_ _2613_ VGND VGND
+ VPWR VPWR _2633_ sky130_fd_sc_hd__o2bb2a_1
XFILLER_0_65_55 VGND VGND VPWR VPWR sky130_fd_sc_hd__fill_1
XFILLER_0_4_69 VPWR VGND VPWR VGND sky130_ef_sc_hd__decap_12
X_4092_ _0672_ _0673_ VGND VGND VPWR VPWR _0674_ sky130_fd_sc_hd__and2_1
XTAP_TAPCELL_ROW_66_825 VGND VPWR sky130_fd_sc_hd__tapvpwrvgnd_1
XFILLER_0_65_88 VPWR VGND VPWR VGND sky130_ef_sc_hd__decap_12
X_3043_ net2 VGND VGND VPWR VPWR _2579_ sky130_fd_sc_hd__inv_2
X_4994_ _1492_ _1500_ VGND VGND VPWR VPWR _1562_ sky130_fd_sc_hd__and2_1
XFILLER_0_81_65 VGND VGND VPWR VPWR sky130_fd_sc_hd__decap_8
XFILLER_0_58_451 VGND VGND VPWR VPWR sky130_fd_sc_hd__fill_1
X_3945_ _0505_ _0524_ _0530_ VGND VGND VPWR VPWR _0531_ sky130_fd_sc_hd__o21a_1
XFILLER_0_58_473 VGND VGND VPWR VPWR sky130_fd_sc_hd__decap_3
XFILLER_0_85_281 VGND VGND VPWR VPWR sky130_fd_sc_hd__fill_2
XFILLER_0_73_443 VGND VGND VPWR VPWR sky130_fd_sc_hd__decap_4
XFILLER_0_18_337 VPWR VGND VPWR VGND sky130_ef_sc_hd__decap_12
XFILLER_0_73_476 VPWR VGND VPWR VGND sky130_ef_sc_hd__decap_12
XFILLER_0_73_465 VGND VGND VPWR VPWR sky130_fd_sc_hd__fill_1
X_5615_ _1935_ _2099_ _2175_ VGND VGND VPWR VPWR _2176_ sky130_fd_sc_hd__o21ai_1
X_3876_ _0455_ _0466_ VGND VGND VPWR VPWR _0467_ sky130_fd_sc_hd__and2b_1
XFILLER_0_45_167 VGND VGND VPWR VPWR sky130_fd_sc_hd__fill_1
XFILLER_0_83_3 VPWR VGND VPWR VGND sky130_ef_sc_hd__decap_12
XFILLER_0_26_392 VGND VGND VPWR VPWR sky130_fd_sc_hd__fill_1
X_5546_ _1639_ _2011_ _2107_ VGND VGND VPWR VPWR _2108_ sky130_fd_sc_hd__o21a_1
XFILLER_0_60_159 VGND VGND VPWR VPWR sky130_fd_sc_hd__fill_2
X_5477_ _1973_ _1990_ VGND VGND VPWR VPWR _2039_ sky130_fd_sc_hd__and2_1
X_4428_ _0986_ _1002_ VGND VGND VPWR VPWR _1004_ sky130_fd_sc_hd__nand2_1
X_4359_ _0925_ _0935_ VGND VGND VPWR VPWR _0936_ sky130_fd_sc_hd__xnor2_1
X_6029_ _2539_ _2540_ VGND VGND VPWR VPWR _2541_ sky130_fd_sc_hd__and2_1
XFILLER_0_83_229 VGND VGND VPWR VPWR sky130_fd_sc_hd__fill_1
XFILLER_0_49_473 VGND VGND VPWR VPWR sky130_fd_sc_hd__fill_1
XFILLER_0_64_421 VGND VGND VPWR VPWR sky130_fd_sc_hd__fill_2
XFILLER_0_64_465 VGND VGND VPWR VPWR sky130_fd_sc_hd__decap_8
XFILLER_0_24_307 VGND VGND VPWR VPWR sky130_fd_sc_hd__fill_1
XFILLER_0_17_381 VGND VGND VPWR VPWR sky130_fd_sc_hd__decap_8
XFILLER_0_20_524 VGND VGND VPWR VPWR sky130_fd_sc_hd__decap_8
XFILLER_0_32_362 VGND VGND VPWR VPWR sky130_fd_sc_hd__fill_2
XTAP_TAPCELL_ROW_9_285 VGND VPWR sky130_fd_sc_hd__tapvpwrvgnd_1
XFILLER_0_59_237 VGND VGND VPWR VPWR sky130_fd_sc_hd__decap_6
XTAP_TAPCELL_ROW_71_872 VGND VPWR sky130_fd_sc_hd__tapvpwrvgnd_1
XFILLER_0_67_281 VGND VGND VPWR VPWR sky130_fd_sc_hd__decap_4
XFILLER_0_7_529 VPWR VGND VPWR VGND sky130_ef_sc_hd__decap_12
X_3730_ _2890_ _0324_ _0325_ _2745_ net145 VGND VGND VPWR VPWR _0100_ sky130_fd_sc_hd__a32o_1
XFILLER_0_15_307 VPWR VGND VPWR VGND sky130_ef_sc_hd__decap_12
XFILLER_0_82_284 VPWR VGND VPWR VGND sky130_ef_sc_hd__decap_12
XFILLER_0_70_435 VGND VGND VPWR VPWR sky130_fd_sc_hd__decap_6
X_3661_ net5 _2970_ net15 net16 VGND VGND VPWR VPWR _0258_ sky130_fd_sc_hd__and4_1
XFILLER_0_42_137 VGND VGND VPWR VPWR sky130_fd_sc_hd__decap_3
X_3592_ _2985_ _2987_ _3029_ VGND VGND VPWR VPWR _3030_ sky130_fd_sc_hd__o21ba_1
X_5400_ _1961_ _1962_ VGND VGND VPWR VPWR _1963_ sky130_fd_sc_hd__or2_1
Xclkload11 clknet_leaf_9_clk VGND VGND VPWR VPWR clkload11/Y sky130_fd_sc_hd__clkinv_4
X_5331_ _1891_ _1892_ _1893_ VGND VGND VPWR VPWR _1895_ sky130_fd_sc_hd__a21o_1
XFILLER_0_50_170 VPWR VGND VPWR VGND sky130_ef_sc_hd__decap_12
XFILLER_0_11_535 VGND VGND VPWR VPWR sky130_fd_sc_hd__decap_8
XFILLER_0_2_289 VPWR VGND VPWR VGND sky130_ef_sc_hd__decap_12
X_5262_ u_interface.u_compute_core.relu_data\[16\] _0634_ _1739_ _1738_ VGND VGND
+ VPWR VPWR _1827_ sky130_fd_sc_hd__a31o_1
X_5193_ _1748_ _1757_ _1758_ VGND VGND VPWR VPWR _1759_ sky130_fd_sc_hd__or3_4
X_4213_ _0790_ _0792_ VGND VGND VPWR VPWR _0793_ sky130_fd_sc_hd__xnor2_1
XTAP_TAPCELL_ROW_79_950 VGND VPWR sky130_fd_sc_hd__tapvpwrvgnd_1
X_4144_ _0701_ _0724_ VGND VGND VPWR VPWR _0725_ sky130_fd_sc_hd__xor2_2
XFILLER_0_92_53 VGND VGND VPWR VPWR sky130_fd_sc_hd__decap_3
XTAP_TAPCELL_ROW_87_1027 VGND VPWR sky130_fd_sc_hd__tapvpwrvgnd_1
X_4075_ u_interface.u_compute_core.relu_data\[1\] _0656_ VGND VGND VPWR VPWR _0657_
+ sky130_fd_sc_hd__nand2_2
XFILLER_0_92_97 VPWR VGND VPWR VGND sky130_ef_sc_hd__decap_12
XFILLER_0_18_101 VGND VGND VPWR VPWR sky130_fd_sc_hd__fill_1
X_4977_ _1543_ _1544_ _1466_ _1489_ VGND VGND VPWR VPWR _1546_ sky130_fd_sc_hd__o211a_1
XFILLER_0_46_421 VGND VGND VPWR VPWR sky130_fd_sc_hd__decap_8
XFILLER_0_73_262 VGND VGND VPWR VPWR sky130_fd_sc_hd__decap_6
X_3928_ _0494_ VGND VGND VPWR VPWR _0515_ sky130_fd_sc_hd__clkbuf_4
XFILLER_0_73_240 VGND VGND VPWR VPWR sky130_fd_sc_hd__decap_4
XFILLER_0_18_167 VGND VGND VPWR VPWR sky130_fd_sc_hd__fill_2
Xclkload5 clknet_leaf_5_clk VGND VGND VPWR VPWR clkload5/Y sky130_fd_sc_hd__clkinv_8
X_3859_ _0420_ _0423_ _0449_ _2740_ VGND VGND VPWR VPWR _0451_ sky130_fd_sc_hd__o31ai_1
XFILLER_0_61_424 VGND VGND VPWR VPWR sky130_fd_sc_hd__decap_8
XFILLER_0_61_468 VGND VGND VPWR VPWR sky130_fd_sc_hd__decap_8
XFILLER_0_14_362 VGND VGND VPWR VPWR sky130_fd_sc_hd__fill_2
X_5529_ _2076_ _2077_ _2090_ VGND VGND VPWR VPWR _2091_ sky130_fd_sc_hd__or3_1
XTAP_TAPCELL_ROW_6_255 VGND VPWR sky130_fd_sc_hd__tapvpwrvgnd_1
XFILLER_0_69_546 VGND VGND VPWR VPWR sky130_fd_sc_hd__fill_1
XFILLER_0_84_516 VPWR VGND VPWR VGND sky130_ef_sc_hd__decap_12
XFILLER_0_49_281 VGND VGND VPWR VPWR sky130_fd_sc_hd__fill_2
XFILLER_0_24_126 VGND VGND VPWR VPWR sky130_fd_sc_hd__fill_2
XFILLER_0_37_487 VGND VGND VPWR VPWR sky130_fd_sc_hd__fill_2
XTAP_TAPCELL_ROW_40_577 VGND VPWR sky130_fd_sc_hd__tapvpwrvgnd_1
XTAP_TAPCELL_ROW_76_920 VGND VPWR sky130_fd_sc_hd__tapvpwrvgnd_1
XFILLER_0_1_15 VPWR VGND VPWR VGND sky130_ef_sc_hd__decap_12
XTAP_TAPCELL_ROW_48_655 VGND VPWR sky130_fd_sc_hd__tapvpwrvgnd_1
X_4900_ _1409_ _1392_ _1469_ net76 VGND VGND VPWR VPWR _1470_ sky130_fd_sc_hd__a211oi_2
XFILLER_0_75_505 VGND VGND VPWR VPWR sky130_fd_sc_hd__fill_1
X_5880_ u_interface.core_attn_out\[18\] u_interface.u_compute_core.u_av.product_reg\[21\]
+ VGND VGND VPWR VPWR _2420_ sky130_fd_sc_hd__or2_1
X_4831_ _0982_ _1326_ _1325_ VGND VGND VPWR VPWR _1402_ sky130_fd_sc_hd__o21bai_1
XFILLER_0_28_421 VGND VGND VPWR VPWR sky130_fd_sc_hd__decap_6
XFILLER_0_28_443 VGND VGND VPWR VPWR sky130_fd_sc_hd__decap_3
X_4762_ _1185_ _1331_ _1333_ VGND VGND VPWR VPWR _1334_ sky130_fd_sc_hd__o21bai_1
XFILLER_0_55_251 VGND VGND VPWR VPWR sky130_fd_sc_hd__decap_8
X_4693_ _1225_ _1143_ _1224_ VGND VGND VPWR VPWR _1265_ sky130_fd_sc_hd__a21o_1
XFILLER_0_15_104 VGND VGND VPWR VPWR sky130_fd_sc_hd__decap_8
X_3713_ _0307_ _0308_ VGND VGND VPWR VPWR _0309_ sky130_fd_sc_hd__nand2_1
XFILLER_0_55_284 VGND VGND VPWR VPWR sky130_fd_sc_hd__decap_8
XFILLER_0_15_148 VGND VGND VPWR VPWR sky130_fd_sc_hd__fill_1
X_3644_ _3037_ _3040_ _0240_ _0241_ VGND VGND VPWR VPWR _0242_ sky130_fd_sc_hd__a211o_1
XFILLER_0_30_118 VGND VGND VPWR VPWR sky130_fd_sc_hd__fill_1
XFILLER_0_11_321 VPWR VGND VPWR VGND sky130_ef_sc_hd__decap_12
X_3575_ net7 VGND VGND VPWR VPWR _3013_ sky130_fd_sc_hd__buf_2
X_5314_ _1876_ _1877_ VGND VGND VPWR VPWR _1878_ sky130_fd_sc_hd__xnor2_1
X_5245_ _1807_ _1808_ _1806_ VGND VGND VPWR VPWR _1810_ sky130_fd_sc_hd__o21ai_1
XFILLER_0_46_3 VPWR VGND VPWR VGND sky130_ef_sc_hd__decap_12
X_5176_ _1737_ _1741_ VGND VGND VPWR VPWR _1742_ sky130_fd_sc_hd__xnor2_1
XTAP_TAPCELL_ROW_3_225 VGND VPWR sky130_fd_sc_hd__tapvpwrvgnd_1
X_4127_ _0703_ _0707_ VGND VGND VPWR VPWR _0708_ sky130_fd_sc_hd__xnor2_1
XFILLER_0_78_321 VGND VGND VPWR VPWR sky130_fd_sc_hd__decap_4
X_4058_ _0610_ _0640_ VGND VGND VPWR VPWR _0641_ sky130_fd_sc_hd__xnor2_1
XFILLER_0_78_343 VPWR VGND VPWR VGND sky130_ef_sc_hd__decap_12
XTAP_TAPCELL_ROW_82_978 VGND VPWR sky130_fd_sc_hd__tapvpwrvgnd_1
XFILLER_0_78_365 VGND VGND VPWR VPWR sky130_fd_sc_hd__decap_4
XFILLER_0_46_240 VPWR VGND VPWR VGND sky130_ef_sc_hd__decap_12
XFILLER_0_46_284 VGND VGND VPWR VPWR sky130_fd_sc_hd__fill_1
XFILLER_0_6_381 VPWR VGND VPWR VGND sky130_ef_sc_hd__decap_12
XTAP_TAPCELL_ROW_45_625 VGND VPWR sky130_fd_sc_hd__tapvpwrvgnd_1
XFILLER_0_84_302 VGND VGND VPWR VPWR sky130_fd_sc_hd__decap_6
XFILLER_0_57_505 VPWR VGND VPWR VGND sky130_ef_sc_hd__decap_12
XFILLER_0_32_26 VGND VGND VPWR VPWR sky130_fd_sc_hd__fill_2
XFILLER_0_57_538 VGND VGND VPWR VPWR sky130_fd_sc_hd__decap_8
XFILLER_0_4_307 VGND VGND VPWR VPWR sky130_fd_sc_hd__fill_1
XFILLER_0_37_262 VGND VGND VPWR VPWR sky130_fd_sc_hd__decap_4
XFILLER_0_37_273 VGND VGND VPWR VPWR sky130_fd_sc_hd__decap_6
X_3360_ net200 _2805_ _2822_ _2741_ VGND VGND VPWR VPWR _0072_ sky130_fd_sc_hd__a22o_1
XPHY_EDGE_ROW_29_Left_122 VGND VGND VPWR VPWR sky130_fd_sc_hd__decap_3
X_5030_ _1447_ _1597_ _1596_ VGND VGND VPWR VPWR _1598_ sky130_fd_sc_hd__or3_4
XFILLER_0_20_195 VGND VGND VPWR VPWR sky130_fd_sc_hd__fill_1
X_3291_ u_interface.u_compute_core.u_mac.product_reg\[4\] u_interface.u_compute_core.mac_accum\[4\]
+ VGND VGND VPWR VPWR _2763_ sky130_fd_sc_hd__nand2_1
XFILLER_0_79_129 VGND VGND VPWR VPWR sky130_fd_sc_hd__fill_1
XFILLER_0_73_55 VGND VGND VPWR VPWR sky130_fd_sc_hd__fill_1
X_5932_ _2462_ _2465_ VGND VGND VPWR VPWR _2466_ sky130_fd_sc_hd__xor2_1
XFILLER_0_87_173 VPWR VGND VPWR VGND sky130_ef_sc_hd__decap_12
XFILLER_0_87_151 VGND VGND VPWR VPWR sky130_fd_sc_hd__fill_1
XFILLER_0_48_516 VGND VGND VPWR VPWR sky130_fd_sc_hd__decap_4
XFILLER_0_48_527 VGND VGND VPWR VPWR sky130_fd_sc_hd__decap_4
X_5863_ net197 _2309_ _2404_ _2405_ _0855_ VGND VGND VPWR VPWR _0153_ sky130_fd_sc_hd__o221a_1
XPHY_EDGE_ROW_38_Left_131 VGND VGND VPWR VPWR sky130_fd_sc_hd__decap_3
X_4814_ _1374_ _1383_ _1384_ VGND VGND VPWR VPWR _1385_ sky130_fd_sc_hd__nand3_1
X_5794_ _2336_ _2344_ _2343_ VGND VGND VPWR VPWR _2346_ sky130_fd_sc_hd__o21ai_1
X_4745_ _1314_ VGND VGND VPWR VPWR _1317_ sky130_fd_sc_hd__inv_2
XFILLER_0_71_541 VGND VGND VPWR VPWR sky130_fd_sc_hd__decap_6
XFILLER_0_7_167 VGND VGND VPWR VPWR sky130_fd_sc_hd__fill_1
X_4676_ _1246_ _1247_ _1134_ _1136_ VGND VGND VPWR VPWR _1249_ sky130_fd_sc_hd__o211ai_2
X_3627_ net4 net17 VGND VGND VPWR VPWR _0225_ sky130_fd_sc_hd__nand2_1
XFILLER_0_31_449 VGND VGND VPWR VPWR sky130_fd_sc_hd__fill_1
X_3558_ _2963_ _2996_ VGND VGND VPWR VPWR _2997_ sky130_fd_sc_hd__or2_1
Xoutput29 net29 VGND VGND VPWR VPWR m_tdata[10] sky130_fd_sc_hd__buf_2
XFILLER_0_3_373 VPWR VGND VPWR VGND sky130_ef_sc_hd__decap_12
XPHY_EDGE_ROW_47_Left_140 VGND VGND VPWR VPWR sky130_fd_sc_hd__decap_3
XFILLER_0_11_151 VGND VGND VPWR VPWR sky130_fd_sc_hd__fill_1
X_3489_ _2930_ _2931_ VGND VGND VPWR VPWR _2932_ sky130_fd_sc_hd__and2_1
X_6277_ clknet_leaf_15_clk _0190_ VGND VGND VPWR VPWR net37 sky130_fd_sc_hd__dfxtp_1
X_5228_ _1791_ _1792_ VGND VGND VPWR VPWR _1793_ sky130_fd_sc_hd__and2b_1
X_5159_ _1723_ _1724_ VGND VGND VPWR VPWR _1725_ sky130_fd_sc_hd__or2b_1
XFILLER_0_39_505 VGND VGND VPWR VPWR sky130_fd_sc_hd__fill_1
XFILLER_0_74_390 VGND VGND VPWR VPWR sky130_fd_sc_hd__decap_4
XTAP_TAPCELL_ROW_50_672 VGND VPWR sky130_fd_sc_hd__tapvpwrvgnd_1
XTAP_TAPCELL_ROW_58_750 VGND VPWR sky130_fd_sc_hd__tapvpwrvgnd_1
XFILLER_0_89_449 VPWR VGND VPWR VGND sky130_ef_sc_hd__decap_12
XFILLER_0_43_47 VGND VGND VPWR VPWR sky130_fd_sc_hd__decap_8
XFILLER_0_57_302 VGND VGND VPWR VPWR sky130_fd_sc_hd__decap_8
XFILLER_0_57_335 VGND VGND VPWR VPWR sky130_fd_sc_hd__fill_1
XFILLER_0_65_390 VGND VGND VPWR VPWR sky130_fd_sc_hd__fill_2
XFILLER_0_80_371 VGND VGND VPWR VPWR sky130_fd_sc_hd__fill_1
X_4530_ _1102_ _1101_ _1104_ VGND VGND VPWR VPWR _1105_ sky130_fd_sc_hd__and3_1
XFILLER_0_13_416 VGND VGND VPWR VPWR sky130_fd_sc_hd__decap_6
XFILLER_0_13_449 VGND VGND VPWR VPWR sky130_fd_sc_hd__decap_3
XFILLER_0_7_36 VGND VGND VPWR VPWR sky130_fd_sc_hd__decap_4
X_4461_ _0976_ _0975_ _0911_ VGND VGND VPWR VPWR _1037_ sky130_fd_sc_hd__or3_4
X_6200_ clknet_leaf_18_clk _0113_ VGND VGND VPWR VPWR u_interface.u_compute_core.u_av.product_reg\[7\]
+ sky130_fd_sc_hd__dfxtp_1
X_3412_ _2781_ _2864_ _2866_ _2867_ net175 VGND VGND VPWR VPWR _0079_ sky130_fd_sc_hd__a32o_1
XFILLER_0_40_268 VGND VGND VPWR VPWR sky130_fd_sc_hd__decap_6
X_6131_ clknet_leaf_4_clk _0044_ VGND VGND VPWR VPWR u_interface.u_compute_core.scaled_data\[15\]
+ sky130_fd_sc_hd__dfxtp_1
X_4392_ _0967_ _0966_ _0892_ VGND VGND VPWR VPWR _0969_ sky130_fd_sc_hd__a21bo_1
XTAP_TAPCELL_ROW_90_1056 VGND VPWR sky130_fd_sc_hd__tapvpwrvgnd_1
XFILLER_0_0_365 VGND VGND VPWR VPWR sky130_fd_sc_hd__fill_2
X_3343_ u_interface.u_compute_core.u_mac.product_reg\[11\] u_interface.u_compute_core.mac_accum\[11\]
+ VGND VGND VPWR VPWR _2808_ sky130_fd_sc_hd__or2_1
X_3274_ u_interface.u_compute_core.u_mac.product_reg\[2\] u_interface.u_compute_core.mac_accum\[2\]
+ VGND VGND VPWR VPWR _2748_ sky130_fd_sc_hd__nor2_1
X_6062_ _2670_ _2562_ VGND VGND VPWR VPWR _2563_ sky130_fd_sc_hd__and2_1
X_5013_ _1579_ _1580_ VGND VGND VPWR VPWR _1581_ sky130_fd_sc_hd__xnor2_1
XPHY_EDGE_ROW_5_Right_5 VGND VGND VPWR VPWR sky130_fd_sc_hd__decap_3
Xclkbuf_leaf_18_clk clknet_1_1__leaf_clk VGND VGND VPWR VPWR clknet_leaf_18_clk sky130_fd_sc_hd__clkbuf_8
XFILLER_0_75_110 VGND VGND VPWR VPWR sky130_fd_sc_hd__fill_2
X_5915_ _2441_ _2450_ VGND VGND VPWR VPWR _2451_ sky130_fd_sc_hd__nand2_1
XFILLER_0_8_421 VPWR VGND VPWR VGND sky130_ef_sc_hd__decap_12
X_5846_ _2389_ _2390_ VGND VGND VPWR VPWR _2391_ sky130_fd_sc_hd__nor2_1
XFILLER_0_48_379 VGND VGND VPWR VPWR sky130_fd_sc_hd__decap_4
XFILLER_0_63_316 VGND VGND VPWR VPWR sky130_fd_sc_hd__decap_6
X_5777_ _2322_ _2324_ _2321_ VGND VGND VPWR VPWR _2331_ sky130_fd_sc_hd__a21boi_2
XFILLER_0_44_530 VGND VGND VPWR VPWR sky130_fd_sc_hd__fill_2
X_4728_ _1288_ _1299_ VGND VGND VPWR VPWR _1300_ sky130_fd_sc_hd__nor2_2
X_4659_ net124 net19 _0488_ u_interface.u_compute_core.relu_data\[14\] VGND VGND VPWR
+ VPWR _1232_ sky130_fd_sc_hd__a22o_1
XTAP_TAPCELL_ROW_55_720 VGND VPWR sky130_fd_sc_hd__tapvpwrvgnd_1
XFILLER_0_79_482 VGND VGND VPWR VPWR sky130_fd_sc_hd__decap_8
XTAP_TAPCELL_ROW_27_455 VGND VPWR sky130_fd_sc_hd__tapvpwrvgnd_1
XFILLER_0_81_113 VGND VGND VPWR VPWR sky130_fd_sc_hd__fill_1
XFILLER_0_50_533 VPWR VGND VPWR VGND sky130_ef_sc_hd__decap_12
XFILLER_0_62_371 VGND VGND VPWR VPWR sky130_fd_sc_hd__fill_1
XFILLER_0_22_246 VGND VGND VPWR VPWR sky130_fd_sc_hd__fill_1
XFILLER_0_10_419 VGND VGND VPWR VPWR sky130_fd_sc_hd__fill_1
XFILLER_0_54_57 VGND VGND VPWR VPWR sky130_fd_sc_hd__fill_1
X_3961_ net95 _0494_ _0496_ _2598_ VGND VGND VPWR VPWR _0546_ sky130_fd_sc_hd__a22o_1
X_5700_ _1644_ _2258_ _0648_ VGND VGND VPWR VPWR _2259_ sky130_fd_sc_hd__o21ai_1
XFILLER_0_57_121 VGND VGND VPWR VPWR sky130_fd_sc_hd__decap_6
X_3892_ _2740_ _0475_ _0481_ VGND VGND VPWR VPWR _0482_ sky130_fd_sc_hd__and3_1
XFILLER_0_45_316 VPWR VGND VPWR VGND sky130_ef_sc_hd__decap_12
XTAP_TAPCELL_ROW_61_778 VGND VPWR sky130_fd_sc_hd__tapvpwrvgnd_1
XFILLER_0_70_89 VGND VGND VPWR VPWR sky130_fd_sc_hd__fill_1
X_5631_ _2141_ _2151_ VGND VGND VPWR VPWR _2191_ sky130_fd_sc_hd__nor2_1
X_5562_ _1860_ _2111_ VGND VGND VPWR VPWR _2123_ sky130_fd_sc_hd__nand2_1
XFILLER_0_79_43 VGND VGND VPWR VPWR sky130_fd_sc_hd__decap_6
X_4513_ _1008_ _1017_ _1016_ VGND VGND VPWR VPWR _1088_ sky130_fd_sc_hd__a21bo_1
Xhold114 u_interface.core_attn_out\[26\] VGND VGND VPWR VPWR net179 sky130_fd_sc_hd__dlygate4sd3_1
Xhold125 u_interface.u_compute_core.mac_accum\[9\] VGND VGND VPWR VPWR net190 sky130_fd_sc_hd__dlygate4sd3_1
Xhold103 u_interface.u_compute_core.mac_accum\[8\] VGND VGND VPWR VPWR net168 sky130_fd_sc_hd__dlygate4sd3_1
X_5493_ _1960_ _1962_ _2053_ VGND VGND VPWR VPWR _2055_ sky130_fd_sc_hd__or3_1
Xclkbuf_leaf_7_clk clknet_1_0__leaf_clk VGND VGND VPWR VPWR clknet_leaf_7_clk sky130_fd_sc_hd__clkbuf_8
X_4444_ _0941_ _0955_ _0954_ VGND VGND VPWR VPWR _1020_ sky130_fd_sc_hd__a21bo_1
Xhold136 u_interface.core_attn_out\[9\] VGND VGND VPWR VPWR net201 sky130_fd_sc_hd__dlygate4sd3_1
Xhold158 u_interface.u_compute_core.u_mac.product_reg\[14\] VGND VGND VPWR VPWR net223
+ sky130_fd_sc_hd__dlygate4sd3_1
Xhold147 u_interface.u_compute_core.u_av.product_reg\[27\] VGND VGND VPWR VPWR net212
+ sky130_fd_sc_hd__dlygate4sd3_1
X_4375_ _0943_ _0950_ _0951_ VGND VGND VPWR VPWR _0952_ sky130_fd_sc_hd__nand3_1
XFILLER_0_0_195 VGND VGND VPWR VPWR sky130_fd_sc_hd__fill_1
X_3326_ _2781_ _2792_ _2793_ _2746_ net168 VGND VGND VPWR VPWR _0067_ sky130_fd_sc_hd__a32o_1
X_6114_ clknet_leaf_9_clk _0027_ VGND VGND VPWR VPWR u_interface.u_compute_core.relu_data\[27\]
+ sky130_fd_sc_hd__dfxtp_2
X_6045_ _2539_ _2551_ VGND VGND VPWR VPWR _2552_ sky130_fd_sc_hd__and2_1
XTAP_TAPCELL_ROW_69_856 VGND VPWR sky130_fd_sc_hd__tapvpwrvgnd_1
X_3257_ _2734_ VGND VGND VPWR VPWR _0057_ sky130_fd_sc_hd__clkbuf_1
X_3188_ u_interface.u_compute_core.scaled_data\[7\] u_interface.u_compute_core.mac_accum\[10\]
+ _2669_ VGND VGND VPWR VPWR _2687_ sky130_fd_sc_hd__mux2_1
XTAP_TAPCELL_ROW_24_425 VGND VPWR sky130_fd_sc_hd__tapvpwrvgnd_1
XFILLER_0_36_327 VGND VGND VPWR VPWR sky130_fd_sc_hd__decap_3
XFILLER_0_8_251 VGND VGND VPWR VPWR sky130_fd_sc_hd__fill_1
X_5829_ _2374_ _2375_ VGND VGND VPWR VPWR _2376_ sky130_fd_sc_hd__and2b_1
XFILLER_0_29_390 VGND VGND VPWR VPWR sky130_fd_sc_hd__fill_2
XFILLER_0_51_319 VGND VGND VPWR VPWR sky130_fd_sc_hd__fill_1
XFILLER_0_32_533 VGND VGND VPWR VPWR sky130_fd_sc_hd__decap_8
XFILLER_0_86_249 VGND VGND VPWR VPWR sky130_fd_sc_hd__decap_3
XFILLER_0_67_441 VGND VGND VPWR VPWR sky130_fd_sc_hd__decap_6
XFILLER_0_40_15 VGND VGND VPWR VPWR sky130_fd_sc_hd__decap_8
XFILLER_0_39_198 VGND VGND VPWR VPWR sky130_fd_sc_hd__fill_1
XFILLER_0_54_179 VGND VGND VPWR VPWR sky130_fd_sc_hd__decap_4
XFILLER_0_50_363 VGND VGND VPWR VPWR sky130_fd_sc_hd__fill_1
XFILLER_0_49_57 VPWR VGND VPWR VGND sky130_ef_sc_hd__decap_12
XFILLER_0_4_15 VGND VGND VPWR VPWR sky130_fd_sc_hd__decap_6
X_4160_ _0612_ _0490_ VGND VGND VPWR VPWR _0740_ sky130_fd_sc_hd__nand2_1
X_3111_ _2631_ VGND VGND VPWR VPWR _2632_ sky130_fd_sc_hd__inv_2
X_4091_ _0669_ _0670_ _0671_ VGND VGND VPWR VPWR _0673_ sky130_fd_sc_hd__a21o_1
XTAP_TAPCELL_ROW_66_826 VGND VPWR sky130_fd_sc_hd__tapvpwrvgnd_1
X_4993_ _1499_ _1493_ VGND VGND VPWR VPWR _1561_ sky130_fd_sc_hd__and2b_1
XFILLER_0_81_88 VGND VGND VPWR VPWR sky130_fd_sc_hd__decap_3
XFILLER_0_18_305 VGND VGND VPWR VPWR sky130_fd_sc_hd__decap_3
XFILLER_0_18_316 VGND VGND VPWR VPWR sky130_fd_sc_hd__fill_2
X_3944_ _0528_ _0529_ VGND VGND VPWR VPWR _0530_ sky130_fd_sc_hd__xnor2_1
XFILLER_0_14_82 VGND VGND VPWR VPWR sky130_fd_sc_hd__fill_2
X_3875_ _0414_ _0465_ VGND VGND VPWR VPWR _0466_ sky130_fd_sc_hd__xor2_1
XFILLER_0_18_349 VPWR VGND VPWR VGND sky130_ef_sc_hd__decap_12
XFILLER_0_45_113 VPWR VGND VPWR VGND sky130_ef_sc_hd__decap_12
XFILLER_0_73_488 VPWR VGND VPWR VGND sky130_ef_sc_hd__decap_12
X_5614_ _2096_ _2097_ _1639_ VGND VGND VPWR VPWR _2175_ sky130_fd_sc_hd__a21o_1
XFILLER_0_14_533 VGND VGND VPWR VPWR sky130_fd_sc_hd__decap_8
X_5545_ _1935_ _2012_ VGND VGND VPWR VPWR _2107_ sky130_fd_sc_hd__or2_1
X_5476_ _1958_ _1972_ VGND VGND VPWR VPWR _2038_ sky130_fd_sc_hd__nor2_1
X_4427_ _0986_ _1002_ VGND VGND VPWR VPWR _1003_ sky130_fd_sc_hd__or2_1
X_4358_ _0933_ _0934_ VGND VGND VPWR VPWR _0935_ sky130_fd_sc_hd__and2b_1
X_4289_ _0803_ _0865_ _0866_ VGND VGND VPWR VPWR _0867_ sky130_fd_sc_hd__and3_1
X_3309_ _2769_ _2775_ _2778_ VGND VGND VPWR VPWR _2779_ sky130_fd_sc_hd__a21oi_1
X_6028_ net31 u_interface.core_attn_out\[12\] _2521_ VGND VGND VPWR VPWR _2540_ sky130_fd_sc_hd__mux2_1
XTAP_TAPCELL_ROW_37_550 VGND VPWR sky130_fd_sc_hd__tapvpwrvgnd_1
XFILLER_0_49_463 VGND VGND VPWR VPWR sky130_fd_sc_hd__decap_3
XFILLER_0_64_477 VPWR VGND VPWR VGND sky130_ef_sc_hd__decap_12
XFILLER_0_10_29 VPWR VGND VPWR VGND sky130_ef_sc_hd__decap_12
XTAP_TAPCELL_ROW_9_286 VGND VPWR sky130_fd_sc_hd__tapvpwrvgnd_1
XFILLER_0_35_15 VGND VGND VPWR VPWR sky130_fd_sc_hd__decap_3
XFILLER_0_87_503 VGND VGND VPWR VPWR sky130_fd_sc_hd__fill_1
XTAP_TAPCELL_ROW_71_873 VGND VPWR sky130_fd_sc_hd__tapvpwrvgnd_1
XFILLER_0_27_113 VPWR VGND VPWR VGND sky130_ef_sc_hd__decap_12
XFILLER_0_82_296 VPWR VGND VPWR VGND sky130_ef_sc_hd__decap_12
XFILLER_0_15_319 VGND VGND VPWR VPWR sky130_fd_sc_hd__decap_8
X_3660_ _2970_ net15 net16 net5 VGND VGND VPWR VPWR _0257_ sky130_fd_sc_hd__a22oi_1
X_3591_ _3027_ _3028_ VGND VGND VPWR VPWR _3029_ sky130_fd_sc_hd__or2_1
Xclkload12 clknet_leaf_10_clk VGND VGND VPWR VPWR clkload12/Y sky130_fd_sc_hd__clkinvlp_4
X_5330_ _1891_ _1892_ _1893_ VGND VGND VPWR VPWR _1894_ sky130_fd_sc_hd__nand3_1
XFILLER_0_11_503 VGND VGND VPWR VPWR sky130_fd_sc_hd__fill_1
X_5261_ _1742_ _1743_ VGND VGND VPWR VPWR _1826_ sky130_fd_sc_hd__and2_1
XPHY_EDGE_ROW_10_Left_103 VGND VGND VPWR VPWR sky130_fd_sc_hd__decap_3
XFILLER_0_50_182 VGND VGND VPWR VPWR sky130_fd_sc_hd__decap_4
X_4212_ _0730_ _0732_ _0791_ VGND VGND VPWR VPWR _0792_ sky130_fd_sc_hd__o21a_1
X_5192_ _1755_ _1756_ _1593_ VGND VGND VPWR VPWR _1758_ sky130_fd_sc_hd__a21oi_1
XTAP_TAPCELL_ROW_79_951 VGND VPWR sky130_fd_sc_hd__tapvpwrvgnd_1
X_4143_ _0711_ _0723_ VGND VGND VPWR VPWR _0724_ sky130_fd_sc_hd__xnor2_2
X_4074_ s_tdata[7] VGND VGND VPWR VPWR _0656_ sky130_fd_sc_hd__buf_4
XTAP_TAPCELL_ROW_87_1028 VGND VPWR sky130_fd_sc_hd__tapvpwrvgnd_1
XTAP_TAPCELL_ROW_34_520 VGND VPWR sky130_fd_sc_hd__tapvpwrvgnd_1
X_4976_ _1466_ _1489_ _1543_ _1544_ VGND VGND VPWR VPWR _1545_ sky130_fd_sc_hd__a211oi_2
XFILLER_0_46_477 VGND VGND VPWR VPWR sky130_fd_sc_hd__decap_3
X_3927_ _0512_ _0513_ VGND VGND VPWR VPWR _0514_ sky130_fd_sc_hd__nor2_1
Xclkload6 clknet_leaf_6_clk VGND VGND VPWR VPWR clkload6/Y sky130_fd_sc_hd__inv_8
X_3858_ _0420_ _0423_ _0449_ VGND VGND VPWR VPWR _0450_ sky130_fd_sc_hd__o21a_1
XFILLER_0_33_105 VGND VGND VPWR VPWR sky130_fd_sc_hd__fill_1
X_3789_ _0378_ _0382_ VGND VGND VPWR VPWR _0383_ sky130_fd_sc_hd__xnor2_1
XFILLER_0_61_447 VGND VGND VPWR VPWR sky130_fd_sc_hd__fill_1
X_5528_ _2079_ _2089_ VGND VGND VPWR VPWR _2090_ sky130_fd_sc_hd__xnor2_1
X_5459_ _2019_ _2021_ VGND VGND VPWR VPWR _2022_ sky130_fd_sc_hd__xnor2_2
XTAP_TAPCELL_ROW_6_256 VGND VPWR sky130_fd_sc_hd__tapvpwrvgnd_1
XFILLER_0_84_528 VGND VGND VPWR VPWR sky130_fd_sc_hd__decap_4
XFILLER_0_64_241 VGND VGND VPWR VPWR sky130_fd_sc_hd__decap_8
XFILLER_0_64_285 VGND VGND VPWR VPWR sky130_fd_sc_hd__decap_6
XTAP_TAPCELL_ROW_40_578 VGND VPWR sky130_fd_sc_hd__tapvpwrvgnd_1
XFILLER_0_24_138 VGND VGND VPWR VPWR sky130_fd_sc_hd__fill_2
XTAP_TAPCELL_ROW_76_921 VGND VPWR sky130_fd_sc_hd__tapvpwrvgnd_1
XFILLER_0_87_311 VGND VGND VPWR VPWR sky130_fd_sc_hd__fill_1
XFILLER_0_1_27 VPWR VGND VPWR VGND sky130_ef_sc_hd__decap_12
XTAP_TAPCELL_ROW_48_656 VGND VPWR sky130_fd_sc_hd__tapvpwrvgnd_1
XFILLER_0_62_35 VGND VGND VPWR VPWR sky130_fd_sc_hd__fill_1
XFILLER_0_75_517 VPWR VGND VPWR VGND sky130_ef_sc_hd__decap_12
X_4830_ _1398_ _1399_ _0982_ VGND VGND VPWR VPWR _1401_ sky130_fd_sc_hd__o21ai_1
X_4761_ net107 _1332_ _1256_ VGND VGND VPWR VPWR _1333_ sky130_fd_sc_hd__a21o_1
X_4692_ _1191_ _1194_ VGND VGND VPWR VPWR _1264_ sky130_fd_sc_hd__nand2_1
X_3712_ _0306_ _0289_ VGND VGND VPWR VPWR _0308_ sky130_fd_sc_hd__or2b_1
X_3643_ _0238_ _0239_ VGND VGND VPWR VPWR _0241_ sky130_fd_sc_hd__and2_1
XFILLER_0_11_94 VPWR VGND VPWR VGND sky130_ef_sc_hd__decap_12
XFILLER_0_11_333 VGND VGND VPWR VPWR sky130_fd_sc_hd__decap_3
X_3574_ _2931_ net8 VGND VGND VPWR VPWR _3012_ sky130_fd_sc_hd__nand2_1
X_5313_ u_interface.u_compute_core.relu_data\[22\] _0535_ VGND VGND VPWR VPWR _1877_
+ sky130_fd_sc_hd__nand2_1
XFILLER_0_60_6 VPWR VGND VPWR VGND sky130_ef_sc_hd__decap_12
X_5244_ _1806_ _1807_ _1808_ VGND VGND VPWR VPWR _1809_ sky130_fd_sc_hd__or3_1
X_5175_ _1655_ _1740_ VGND VGND VPWR VPWR _1741_ sky130_fd_sc_hd__xnor2_1
XTAP_TAPCELL_ROW_3_226 VGND VPWR sky130_fd_sc_hd__tapvpwrvgnd_1
XFILLER_0_39_3 VPWR VGND VPWR VGND sky130_ef_sc_hd__decap_12
X_4126_ _0657_ _0706_ VGND VGND VPWR VPWR _0707_ sky130_fd_sc_hd__xnor2_1
X_4057_ _0611_ _0639_ VGND VGND VPWR VPWR _0640_ sky130_fd_sc_hd__xnor2_1
XFILLER_0_78_355 VGND VGND VPWR VPWR sky130_fd_sc_hd__decap_8
XTAP_TAPCELL_ROW_82_979 VGND VPWR sky130_fd_sc_hd__tapvpwrvgnd_1
XTAP_TAPCELL_ROW_19_380 VGND VPWR sky130_fd_sc_hd__tapvpwrvgnd_1
X_4959_ _1526_ _1525_ _1522_ VGND VGND VPWR VPWR _1528_ sky130_fd_sc_hd__a21o_1
XFILLER_0_34_469 VGND VGND VPWR VPWR sky130_fd_sc_hd__decap_3
XFILLER_0_6_393 VPWR VGND VPWR VGND sky130_ef_sc_hd__decap_12
XFILLER_0_69_311 VGND VGND VPWR VPWR sky130_fd_sc_hd__decap_8
XTAP_TAPCELL_ROW_45_626 VGND VPWR sky130_fd_sc_hd__tapvpwrvgnd_1
XFILLER_0_57_517 VGND VGND VPWR VPWR sky130_fd_sc_hd__fill_2
XFILLER_0_80_531 VGND VGND VPWR VPWR sky130_fd_sc_hd__fill_1
XFILLER_0_52_266 VGND VGND VPWR VPWR sky130_fd_sc_hd__fill_1
XFILLER_0_20_174 VGND VGND VPWR VPWR sky130_fd_sc_hd__fill_1
X_3290_ _2741_ _2760_ _2762_ _2746_ net162 VGND VGND VPWR VPWR _0062_ sky130_fd_sc_hd__a32o_1
X_5931_ _2455_ _2464_ VGND VGND VPWR VPWR _2465_ sky130_fd_sc_hd__nand2_1
XFILLER_0_87_196 VGND VGND VPWR VPWR sky130_fd_sc_hd__fill_1
XFILLER_0_87_185 VGND VGND VPWR VPWR sky130_fd_sc_hd__fill_2
XFILLER_0_75_314 VGND VGND VPWR VPWR sky130_fd_sc_hd__decap_3
XTAP_TAPCELL_ROW_16_350 VGND VPWR sky130_fd_sc_hd__tapvpwrvgnd_1
X_5862_ _2394_ _2400_ _2403_ _2318_ VGND VGND VPWR VPWR _2405_ sky130_fd_sc_hd__a31o_1
X_4813_ _1381_ _1382_ _1296_ VGND VGND VPWR VPWR _1384_ sky130_fd_sc_hd__o21ai_1
X_5793_ _2336_ _2343_ _2344_ VGND VGND VPWR VPWR _2345_ sky130_fd_sc_hd__or3_1
X_4744_ _1315_ VGND VGND VPWR VPWR _1316_ sky130_fd_sc_hd__inv_2
XFILLER_0_7_135 VGND VGND VPWR VPWR sky130_fd_sc_hd__fill_1
X_4675_ _1134_ _1136_ _1247_ _1246_ VGND VGND VPWR VPWR _1248_ sky130_fd_sc_hd__a211o_4
X_3626_ _2935_ _2961_ _3017_ _3018_ VGND VGND VPWR VPWR _0224_ sky130_fd_sc_hd__a31o_1
X_3557_ _2991_ _2995_ VGND VGND VPWR VPWR _2996_ sky130_fd_sc_hd__xnor2_1
XFILLER_0_3_385 VGND VGND VPWR VPWR sky130_fd_sc_hd__decap_6
X_6276_ clknet_leaf_11_clk _0189_ VGND VGND VPWR VPWR net36 sky130_fd_sc_hd__dfxtp_1
X_5227_ u_interface.u_compute_core.relu_data\[24\] _0504_ _0525_ u_interface.u_compute_core.relu_data\[23\]
+ VGND VGND VPWR VPWR _1792_ sky130_fd_sc_hd__a22o_1
X_3488_ net11 VGND VGND VPWR VPWR _2931_ sky130_fd_sc_hd__buf_2
X_5158_ u_interface.u_compute_core.relu_data\[24\] _0493_ _0496_ u_interface.u_compute_core.relu_data\[23\]
+ VGND VGND VPWR VPWR _1724_ sky130_fd_sc_hd__a22o_1
X_5089_ u_interface.u_compute_core.relu_data\[20\] u_interface.u_compute_core.relu_data\[19\]
+ _0489_ _0534_ VGND VGND VPWR VPWR _1656_ sky130_fd_sc_hd__and4_1
X_4109_ _0684_ _0686_ VGND VGND VPWR VPWR _0690_ sky130_fd_sc_hd__nor2_1
XFILLER_0_78_141 VPWR VGND VPWR VGND sky130_ef_sc_hd__decap_12
XFILLER_0_78_174 VGND VGND VPWR VPWR sky130_fd_sc_hd__fill_1
XFILLER_0_66_347 VGND VGND VPWR VPWR sky130_fd_sc_hd__decap_8
XTAP_TAPCELL_ROW_50_673 VGND VPWR sky130_fd_sc_hd__tapvpwrvgnd_1
XFILLER_0_34_244 VGND VGND VPWR VPWR sky130_fd_sc_hd__decap_3
XFILLER_0_6_190 VGND VGND VPWR VPWR sky130_fd_sc_hd__fill_1
XFILLER_0_22_439 VGND VGND VPWR VPWR sky130_fd_sc_hd__fill_2
XFILLER_0_30_483 VGND VGND VPWR VPWR sky130_fd_sc_hd__fill_1
XTAP_TAPCELL_ROW_58_751 VGND VPWR sky130_fd_sc_hd__tapvpwrvgnd_1
XFILLER_0_43_15 VGND VGND VPWR VPWR sky130_fd_sc_hd__decap_4
XFILLER_0_72_306 VGND VGND VPWR VPWR sky130_fd_sc_hd__fill_2
XTAP_TAPCELL_ROW_13_320 VGND VPWR sky130_fd_sc_hd__tapvpwrvgnd_1
X_4460_ _1034_ _1035_ VGND VGND VPWR VPWR _1036_ sky130_fd_sc_hd__and2b_1
X_3411_ _2745_ VGND VGND VPWR VPWR _2867_ sky130_fd_sc_hd__clkbuf_4
X_4391_ _0892_ _0966_ _0967_ VGND VGND VPWR VPWR _0968_ sky130_fd_sc_hd__nand3b_1
XFILLER_0_0_322 VGND VGND VPWR VPWR sky130_fd_sc_hd__decap_3
X_3342_ u_interface.u_compute_core.u_mac.product_reg\[11\] u_interface.u_compute_core.mac_accum\[11\]
+ VGND VGND VPWR VPWR _2807_ sky130_fd_sc_hd__nand2_1
X_6130_ clknet_leaf_4_clk _0043_ VGND VGND VPWR VPWR u_interface.u_compute_core.scaled_data\[14\]
+ sky130_fd_sc_hd__dfxtp_1
XTAP_TAPCELL_ROW_90_1057 VGND VPWR sky130_fd_sc_hd__tapvpwrvgnd_1
X_3273_ u_interface.u_compute_core.u_mac.product_reg\[2\] u_interface.u_compute_core.mac_accum\[2\]
+ VGND VGND VPWR VPWR _2747_ sky130_fd_sc_hd__and2_1
X_6061_ net43 u_interface.core_attn_out\[23\] _2544_ VGND VGND VPWR VPWR _2562_ sky130_fd_sc_hd__mux2_1
X_5012_ _1573_ _1510_ _1508_ VGND VGND VPWR VPWR _1580_ sky130_fd_sc_hd__o21bai_1
X_5914_ _2428_ _2432_ _2435_ _2436_ _2449_ VGND VGND VPWR VPWR _2450_ sky130_fd_sc_hd__a41o_1
X_5845_ _2382_ _2384_ _2381_ VGND VGND VPWR VPWR _2390_ sky130_fd_sc_hd__o21a_1
XFILLER_0_75_177 VGND VGND VPWR VPWR sky130_fd_sc_hd__decap_4
XFILLER_0_8_433 VPWR VGND VPWR VGND sky130_ef_sc_hd__decap_12
XFILLER_0_8_477 VPWR VGND VPWR VGND sky130_ef_sc_hd__decap_12
X_5776_ _2328_ _2329_ VGND VGND VPWR VPWR _2330_ sky130_fd_sc_hd__nand2_1
XFILLER_0_56_380 VGND VGND VPWR VPWR sky130_fd_sc_hd__decap_4
X_4727_ _1289_ _1298_ VGND VGND VPWR VPWR _1299_ sky130_fd_sc_hd__xnor2_1
XFILLER_0_71_361 VGND VGND VPWR VPWR sky130_fd_sc_hd__decap_8
XFILLER_0_71_350 VGND VGND VPWR VPWR sky130_fd_sc_hd__decap_4
X_4658_ net124 net119 net19 net20 VGND VGND VPWR VPWR _1231_ sky130_fd_sc_hd__and4_1
XFILLER_0_31_225 VGND VGND VPWR VPWR sky130_fd_sc_hd__decap_3
X_3609_ _2890_ _0206_ _0207_ _2867_ net142 VGND VGND VPWR VPWR _0097_ sky130_fd_sc_hd__a32o_1
XFILLER_0_31_247 VGND VGND VPWR VPWR sky130_fd_sc_hd__fill_2
X_4589_ _1153_ _1161_ VGND VGND VPWR VPWR _1163_ sky130_fd_sc_hd__and2_4
X_6259_ clknet_leaf_17_clk _0172_ VGND VGND VPWR VPWR net28 sky130_fd_sc_hd__dfxtp_1
XTAP_TAPCELL_ROW_55_721 VGND VPWR sky130_fd_sc_hd__tapvpwrvgnd_1
XTAP_TAPCELL_ROW_27_456 VGND VPWR sky130_fd_sc_hd__tapvpwrvgnd_1
XPHY_EDGE_ROW_11_Right_11 VGND VGND VPWR VPWR sky130_fd_sc_hd__decap_3
XFILLER_0_54_306 VGND VGND VPWR VPWR sky130_fd_sc_hd__fill_2
XFILLER_0_47_391 VGND VGND VPWR VPWR sky130_fd_sc_hd__fill_1
XFILLER_0_81_169 VPWR VGND VPWR VGND sky130_ef_sc_hd__decap_12
XFILLER_0_50_523 VGND VGND VPWR VPWR sky130_fd_sc_hd__fill_2
XFILLER_0_1_108 VGND VGND VPWR VPWR sky130_fd_sc_hd__decap_4
XFILLER_0_50_545 VGND VGND VPWR VPWR sky130_fd_sc_hd__fill_2
XPHY_EDGE_ROW_20_Right_20 VGND VGND VPWR VPWR sky130_fd_sc_hd__decap_3
XFILLER_0_38_15 VPWR VGND VPWR VGND sky130_ef_sc_hd__decap_12
XPHY_EDGE_ROW_66_Left_159 VGND VGND VPWR VPWR sky130_fd_sc_hd__decap_3
XFILLER_0_89_225 VGND VGND VPWR VPWR sky130_fd_sc_hd__decap_3
X_3960_ _0509_ _0512_ _0539_ VGND VGND VPWR VPWR _0545_ sky130_fd_sc_hd__o21a_1
X_3891_ _0477_ _0480_ VGND VGND VPWR VPWR _0481_ sky130_fd_sc_hd__xnor2_1
XTAP_TAPCELL_ROW_61_779 VGND VPWR sky130_fd_sc_hd__tapvpwrvgnd_1
XPHY_EDGE_ROW_75_Left_168 VGND VGND VPWR VPWR sky130_fd_sc_hd__decap_3
XFILLER_0_72_147 VPWR VGND VPWR VGND sky130_ef_sc_hd__decap_12
XFILLER_0_26_520 VPWR VGND VPWR VGND sky130_ef_sc_hd__decap_12
X_5630_ _2124_ _2140_ VGND VGND VPWR VPWR _2190_ sky130_fd_sc_hd__nor2_1
XFILLER_0_72_169 VPWR VGND VPWR VGND sky130_ef_sc_hd__decap_12
XFILLER_0_5_447 VGND VGND VPWR VPWR sky130_fd_sc_hd__fill_1
X_5561_ _2110_ _2109_ VGND VGND VPWR VPWR _2122_ sky130_fd_sc_hd__or2b_1
XFILLER_0_60_309 VGND VGND VPWR VPWR sky130_fd_sc_hd__decap_8
X_4512_ _1084_ _1085_ _1076_ VGND VGND VPWR VPWR _1087_ sky130_fd_sc_hd__a21o_1
X_5492_ _1960_ _1962_ _2053_ VGND VGND VPWR VPWR _2054_ sky130_fd_sc_hd__o21ai_1
XFILLER_0_79_55 VGND VGND VPWR VPWR sky130_fd_sc_hd__fill_1
Xhold115 u_interface.u_compute_core.u_mac.product_reg\[13\] VGND VGND VPWR VPWR net180
+ sky130_fd_sc_hd__dlygate4sd3_1
Xhold104 u_interface.u_compute_core.u_av.product_reg\[4\] VGND VGND VPWR VPWR net169
+ sky130_fd_sc_hd__dlygate4sd3_1
Xhold126 u_interface.core_attn_out\[21\] VGND VGND VPWR VPWR net191 sky130_fd_sc_hd__dlygate4sd3_1
XFILLER_0_41_545 VGND VGND VPWR VPWR sky130_fd_sc_hd__fill_2
X_4443_ _1016_ _1017_ _1008_ VGND VGND VPWR VPWR _1019_ sky130_fd_sc_hd__a21o_1
Xhold137 u_interface.core_attn_out\[19\] VGND VGND VPWR VPWR net202 sky130_fd_sc_hd__dlygate4sd3_1
Xhold148 u_interface.u_compute_core.mac_accum\[17\] VGND VGND VPWR VPWR net213 sky130_fd_sc_hd__dlygate4sd3_1
X_4374_ _0947_ _0948_ _0949_ VGND VGND VPWR VPWR _0951_ sky130_fd_sc_hd__a21o_1
XFILLER_0_0_141 VGND VGND VPWR VPWR sky130_fd_sc_hd__fill_2
X_3325_ _2788_ _2789_ _2790_ VGND VGND VPWR VPWR _2793_ sky130_fd_sc_hd__a21o_1
X_6113_ clknet_leaf_8_clk _0026_ VGND VGND VPWR VPWR u_interface.u_compute_core.relu_data\[26\]
+ sky130_fd_sc_hd__dfxtp_2
XPHY_EDGE_ROW_84_Left_177 VGND VGND VPWR VPWR sky130_fd_sc_hd__decap_3
X_3256_ _2716_ _2733_ VGND VGND VPWR VPWR _2734_ sky130_fd_sc_hd__and2_1
X_6044_ net36 u_interface.core_attn_out\[17\] _2544_ VGND VGND VPWR VPWR _2551_ sky130_fd_sc_hd__mux2_1
XTAP_TAPCELL_ROW_69_857 VGND VPWR sky130_fd_sc_hd__tapvpwrvgnd_1
XFILLER_0_21_3 VPWR VGND VPWR VGND sky130_ef_sc_hd__decap_12
X_3187_ _2686_ VGND VGND VPWR VPWR _0035_ sky130_fd_sc_hd__clkbuf_1
XTAP_TAPCELL_ROW_24_426 VGND VPWR sky130_fd_sc_hd__tapvpwrvgnd_1
XFILLER_0_48_133 VGND VGND VPWR VPWR sky130_fd_sc_hd__decap_6
XFILLER_0_76_475 VGND VGND VPWR VPWR sky130_fd_sc_hd__fill_1
XFILLER_0_36_317 VGND VGND VPWR VPWR sky130_fd_sc_hd__fill_1
X_5828_ u_interface.core_attn_out\[11\] u_interface.u_compute_core.u_av.product_reg\[14\]
+ VGND VGND VPWR VPWR _2375_ sky130_fd_sc_hd__nand2_1
X_5759_ _2311_ _2312_ _2314_ VGND VGND VPWR VPWR _2315_ sky130_fd_sc_hd__and3_1
XFILLER_0_71_180 VPWR VGND VPWR VGND sky130_ef_sc_hd__decap_12
XFILLER_0_40_38 VPWR VGND VPWR VGND sky130_ef_sc_hd__decap_12
XFILLER_0_35_383 VGND VGND VPWR VPWR sky130_fd_sc_hd__decap_8
XFILLER_0_49_69 VPWR VGND VPWR VGND sky130_ef_sc_hd__decap_12
X_3110_ u_interface.u_compute_core.relu_data\[14\] VGND VGND VPWR VPWR _2631_ sky130_fd_sc_hd__buf_8
XFILLER_0_4_49 VGND VGND VPWR VPWR sky130_fd_sc_hd__fill_2
XFILLER_0_65_57 VGND VGND VPWR VPWR sky130_fd_sc_hd__fill_2
X_4090_ _0669_ _0670_ _0671_ VGND VGND VPWR VPWR _0672_ sky130_fd_sc_hd__nand3_1
XTAP_TAPCELL_ROW_66_827 VGND VPWR sky130_fd_sc_hd__tapvpwrvgnd_1
X_4992_ _2736_ _1559_ _1560_ _1337_ VGND VGND VPWR VPWR _0127_ sky130_fd_sc_hd__o211a_1
XFILLER_0_92_209 VPWR VGND VPWR VGND sky130_ef_sc_hd__decap_12
X_3943_ _2589_ _0490_ VGND VGND VPWR VPWR _0529_ sky130_fd_sc_hd__nand2_1
X_3874_ _0463_ _0464_ VGND VGND VPWR VPWR _0465_ sky130_fd_sc_hd__nor2_1
XFILLER_0_45_125 VPWR VGND VPWR VGND sky130_ef_sc_hd__decap_12
XFILLER_0_26_350 VGND VGND VPWR VPWR sky130_fd_sc_hd__fill_1
XFILLER_0_45_158 VGND VGND VPWR VPWR sky130_fd_sc_hd__fill_1
X_5613_ _2172_ _2173_ VGND VGND VPWR VPWR _2174_ sky130_fd_sc_hd__xor2_1
XFILLER_0_26_383 VGND VGND VPWR VPWR sky130_fd_sc_hd__decap_3
XFILLER_0_41_342 VGND VGND VPWR VPWR sky130_fd_sc_hd__fill_2
X_5544_ _2104_ _2105_ VGND VGND VPWR VPWR _2106_ sky130_fd_sc_hd__nor2_1
XFILLER_0_60_139 VGND VGND VPWR VPWR sky130_fd_sc_hd__fill_1
XFILLER_0_30_93 VGND VGND VPWR VPWR sky130_fd_sc_hd__fill_1
X_5475_ _1708_ _1707_ _1711_ _1948_ _2034_ VGND VGND VPWR VPWR _2037_ sky130_fd_sc_hd__a311o_1
X_4426_ _0992_ _1001_ VGND VGND VPWR VPWR _1002_ sky130_fd_sc_hd__xnor2_1
XFILLER_0_69_3 VPWR VGND VPWR VGND sky130_ef_sc_hd__decap_12
XFILLER_0_1_461 VPWR VGND VPWR VGND sky130_ef_sc_hd__decap_12
X_4357_ _0931_ _0930_ _0932_ VGND VGND VPWR VPWR _0934_ sky130_fd_sc_hd__a21o_1
X_4288_ _0863_ _0864_ _0862_ VGND VGND VPWR VPWR _0866_ sky130_fd_sc_hd__a21o_1
X_3308_ _2776_ _2777_ VGND VGND VPWR VPWR _2778_ sky130_fd_sc_hd__and2b_1
X_6027_ _2579_ VGND VGND VPWR VPWR _2539_ sky130_fd_sc_hd__buf_2
X_3239_ _2722_ VGND VGND VPWR VPWR _0051_ sky130_fd_sc_hd__clkbuf_1
XTAP_TAPCELL_ROW_37_551 VGND VPWR sky130_fd_sc_hd__tapvpwrvgnd_1
XFILLER_0_64_489 VPWR VGND VPWR VGND sky130_ef_sc_hd__decap_12
XFILLER_0_51_128 VGND VGND VPWR VPWR sky130_fd_sc_hd__fill_2
XFILLER_0_19_17 VGND VGND VPWR VPWR sky130_fd_sc_hd__fill_1
XTAP_TAPCELL_ROW_9_287 VGND VPWR sky130_fd_sc_hd__tapvpwrvgnd_1
XFILLER_0_51_15 VPWR VGND VPWR VGND sky130_ef_sc_hd__decap_12
XTAP_TAPCELL_ROW_71_874 VGND VPWR sky130_fd_sc_hd__tapvpwrvgnd_1
XFILLER_0_67_272 VGND VGND VPWR VPWR sky130_fd_sc_hd__decap_3
XFILLER_0_27_125 VGND VGND VPWR VPWR sky130_fd_sc_hd__fill_2
XFILLER_0_82_231 VGND VGND VPWR VPWR sky130_fd_sc_hd__decap_4
XFILLER_0_55_467 VPWR VGND VPWR VGND sky130_ef_sc_hd__decap_12
X_3590_ net24 net17 _3026_ VGND VGND VPWR VPWR _3028_ sky130_fd_sc_hd__a21oi_1
Xclkload13 clknet_leaf_11_clk VGND VGND VPWR VPWR clkload13/Y sky130_fd_sc_hd__bufinv_16
X_5260_ _1752_ _1753_ _1754_ _1757_ VGND VGND VPWR VPWR _1825_ sky130_fd_sc_hd__a31o_1
X_4211_ _0645_ _0687_ _0730_ _0732_ _0690_ VGND VGND VPWR VPWR _0791_ sky130_fd_sc_hd__a221o_1
X_5191_ net71 _1755_ _1756_ VGND VGND VPWR VPWR _1757_ sky130_fd_sc_hd__and3_1
XFILLER_0_76_56 VGND VGND VPWR VPWR sky130_fd_sc_hd__fill_1
XTAP_TAPCELL_ROW_79_952 VGND VPWR sky130_fd_sc_hd__tapvpwrvgnd_1
X_4142_ net83 _0722_ VGND VGND VPWR VPWR _0723_ sky130_fd_sc_hd__xor2_2
X_4073_ _0623_ _0636_ VGND VGND VPWR VPWR _0655_ sky130_fd_sc_hd__nand2_1
XTAP_TAPCELL_ROW_87_1029 VGND VPWR sky130_fd_sc_hd__tapvpwrvgnd_1
X_4975_ _1541_ _1542_ _1501_ VGND VGND VPWR VPWR _1544_ sky130_fd_sc_hd__o21a_1
XTAP_TAPCELL_ROW_34_521 VGND VPWR sky130_fd_sc_hd__tapvpwrvgnd_1
XFILLER_0_46_401 VPWR VGND VPWR VGND sky130_ef_sc_hd__decap_12
X_3926_ _0487_ _0491_ _0511_ VGND VGND VPWR VPWR _0513_ sky130_fd_sc_hd__a21oi_1
Xclkload7 clknet_leaf_7_clk VGND VGND VPWR VPWR clkload7/Y sky130_fd_sc_hd__clkinv_8
XFILLER_0_6_531 VGND VGND VPWR VPWR sky130_fd_sc_hd__fill_1
X_3857_ _0446_ _0448_ VGND VGND VPWR VPWR _0449_ sky130_fd_sc_hd__xnor2_1
XFILLER_0_33_117 VGND VGND VPWR VPWR sky130_fd_sc_hd__fill_1
X_3788_ _0380_ _0381_ VGND VGND VPWR VPWR _0382_ sky130_fd_sc_hd__nor2_1
X_5527_ _2087_ _2088_ VGND VGND VPWR VPWR _2089_ sky130_fd_sc_hd__and2_1
XFILLER_0_14_386 VGND VGND VPWR VPWR sky130_fd_sc_hd__fill_1
X_5458_ _1639_ _1928_ _2020_ VGND VGND VPWR VPWR _2021_ sky130_fd_sc_hd__o21ai_2
X_4409_ _2631_ _2628_ _0493_ _0504_ VGND VGND VPWR VPWR _0985_ sky130_fd_sc_hd__and4_1
X_5389_ _0915_ net211 VGND VGND VPWR VPWR _1953_ sky130_fd_sc_hd__or2_1
XTAP_TAPCELL_ROW_6_257 VGND VPWR sky130_fd_sc_hd__tapvpwrvgnd_1
XFILLER_0_49_250 VPWR VGND VPWR VGND sky130_ef_sc_hd__decap_12
XTAP_TAPCELL_ROW_40_579 VGND VPWR sky130_fd_sc_hd__tapvpwrvgnd_1
XFILLER_0_52_437 VPWR VGND VPWR VGND sky130_ef_sc_hd__decap_12
XFILLER_0_46_15 VGND VGND VPWR VPWR sky130_fd_sc_hd__decap_8
XTAP_TAPCELL_ROW_76_922 VGND VPWR sky130_fd_sc_hd__tapvpwrvgnd_1
XTAP_TAPCELL_ROW_48_657 VGND VPWR sky130_fd_sc_hd__tapvpwrvgnd_1
XFILLER_0_1_39 VPWR VGND VPWR VGND sky130_ef_sc_hd__decap_12
XFILLER_0_75_529 VPWR VGND VPWR VGND sky130_ef_sc_hd__decap_12
X_4760_ _1252_ _1253_ _1254_ VGND VGND VPWR VPWR _1332_ sky130_fd_sc_hd__a21o_1
XFILLER_0_55_220 VGND VGND VPWR VPWR sky130_fd_sc_hd__decap_4
X_4691_ _1201_ _1203_ VGND VGND VPWR VPWR _1263_ sky130_fd_sc_hd__nand2_1
X_3711_ _0289_ _0306_ VGND VGND VPWR VPWR _0307_ sky130_fd_sc_hd__or2b_1
XFILLER_0_28_489 VGND VGND VPWR VPWR sky130_fd_sc_hd__fill_1
XFILLER_0_43_415 VGND VGND VPWR VPWR sky130_fd_sc_hd__fill_2
X_3642_ _0238_ _0239_ VGND VGND VPWR VPWR _0240_ sky130_fd_sc_hd__nor2_1
X_3573_ _2995_ _2991_ VGND VGND VPWR VPWR _3011_ sky130_fd_sc_hd__or2b_1
XPHY_EDGE_ROW_49_Right_49 VGND VGND VPWR VPWR sky130_fd_sc_hd__decap_3
X_5312_ _1874_ _1875_ VGND VGND VPWR VPWR _1876_ sky130_fd_sc_hd__nor2_1
XFILLER_0_87_55 VGND VGND VPWR VPWR sky130_fd_sc_hd__fill_1
X_5243_ _1509_ _2640_ _0587_ _0633_ VGND VGND VPWR VPWR _1808_ sky130_fd_sc_hd__and4_1
X_5174_ _1738_ _1739_ VGND VGND VPWR VPWR _1740_ sky130_fd_sc_hd__and2b_1
X_4125_ _0659_ _0704_ _0705_ VGND VGND VPWR VPWR _0706_ sky130_fd_sc_hd__o21a_1
XTAP_TAPCELL_ROW_3_227 VGND VPWR sky130_fd_sc_hd__tapvpwrvgnd_1
XFILLER_0_78_301 VGND VGND VPWR VPWR sky130_fd_sc_hd__decap_6
X_4056_ _0613_ net91 VGND VGND VPWR VPWR _0639_ sky130_fd_sc_hd__xnor2_2
XPHY_EDGE_ROW_58_Right_58 VGND VGND VPWR VPWR sky130_fd_sc_hd__decap_3
XTAP_TAPCELL_ROW_19_381 VGND VPWR sky130_fd_sc_hd__tapvpwrvgnd_1
X_4958_ _1522_ _1525_ _1526_ VGND VGND VPWR VPWR _1527_ sky130_fd_sc_hd__nand3_1
XFILLER_0_19_467 VGND VGND VPWR VPWR sky130_fd_sc_hd__decap_8
X_4889_ _1456_ _1457_ _1444_ VGND VGND VPWR VPWR _1459_ sky130_fd_sc_hd__a21o_1
X_3909_ _0495_ VGND VGND VPWR VPWR _0496_ sky130_fd_sc_hd__clkbuf_4
XFILLER_0_46_253 VGND VGND VPWR VPWR sky130_fd_sc_hd__fill_1
XFILLER_0_6_361 VGND VGND VPWR VPWR sky130_fd_sc_hd__decap_3
XFILLER_0_34_459 VGND VGND VPWR VPWR sky130_fd_sc_hd__decap_4
XFILLER_0_61_223 VGND VGND VPWR VPWR sky130_fd_sc_hd__fill_1
XPHY_EDGE_ROW_67_Right_67 VGND VGND VPWR VPWR sky130_fd_sc_hd__decap_3
XPHY_EDGE_ROW_76_Right_76 VGND VGND VPWR VPWR sky130_fd_sc_hd__decap_3
XFILLER_0_88_109 VPWR VGND VPWR VGND sky130_ef_sc_hd__decap_12
XFILLER_0_16_29 VGND VGND VPWR VPWR sky130_fd_sc_hd__decap_8
XTAP_TAPCELL_ROW_45_627 VGND VPWR sky130_fd_sc_hd__tapvpwrvgnd_1
XFILLER_0_84_326 VPWR VGND VPWR VGND sky130_ef_sc_hd__decap_12
XFILLER_0_84_315 VGND VGND VPWR VPWR sky130_fd_sc_hd__fill_1
XFILLER_0_32_39 VGND VGND VPWR VPWR sky130_fd_sc_hd__decap_8
XFILLER_0_37_242 VGND VGND VPWR VPWR sky130_fd_sc_hd__decap_6
XFILLER_0_25_415 VPWR VGND VPWR VGND sky130_ef_sc_hd__decap_12
XPHY_EDGE_ROW_85_Right_85 VGND VGND VPWR VPWR sky130_fd_sc_hd__decap_3
XFILLER_0_4_309 VPWR VGND VPWR VGND sky130_ef_sc_hd__decap_12
XFILLER_0_20_131 VGND VGND VPWR VPWR sky130_fd_sc_hd__fill_1
X_5930_ _2441_ _2450_ _2446_ _2447_ _2463_ VGND VGND VPWR VPWR _2464_ sky130_fd_sc_hd__a41o_1
X_5861_ _2394_ _2400_ _2403_ VGND VGND VPWR VPWR _2404_ sky130_fd_sc_hd__a21oi_1
X_4812_ _1296_ _1381_ _1382_ VGND VGND VPWR VPWR _1383_ sky130_fd_sc_hd__or3_4
XTAP_TAPCELL_ROW_16_351 VGND VPWR sky130_fd_sc_hd__tapvpwrvgnd_1
X_5792_ _2330_ _2331_ _2337_ _2328_ VGND VGND VPWR VPWR _2344_ sky130_fd_sc_hd__o211a_1
XFILLER_0_90_307 VGND VGND VPWR VPWR sky130_fd_sc_hd__fill_1
X_4743_ _1313_ _1314_ _1214_ _1241_ VGND VGND VPWR VPWR _1315_ sky130_fd_sc_hd__and4b_1
XFILLER_0_16_415 VGND VGND VPWR VPWR sky130_fd_sc_hd__decap_4
XFILLER_0_83_381 VGND VGND VPWR VPWR sky130_fd_sc_hd__fill_1
XFILLER_0_7_169 VPWR VGND VPWR VGND sky130_ef_sc_hd__decap_12
XFILLER_0_16_459 VPWR VGND VPWR VGND sky130_ef_sc_hd__decap_12
XFILLER_0_22_83 VGND VGND VPWR VPWR sky130_fd_sc_hd__fill_1
X_4674_ _1244_ _1245_ _1170_ VGND VGND VPWR VPWR _1247_ sky130_fd_sc_hd__a21oi_1
X_3625_ _0209_ _0222_ VGND VGND VPWR VPWR _0223_ sky130_fd_sc_hd__xor2_1
X_3556_ _2962_ _2993_ _2994_ VGND VGND VPWR VPWR _2995_ sky130_fd_sc_hd__o21ai_1
X_6275_ clknet_leaf_15_clk _0188_ VGND VGND VPWR VPWR net35 sky130_fd_sc_hd__dfxtp_1
X_5226_ u_interface.u_compute_core.relu_data\[24\] u_interface.u_compute_core.relu_data\[23\]
+ _0495_ _0499_ VGND VGND VPWR VPWR _1791_ sky130_fd_sc_hd__and4_1
X_3487_ net25 VGND VGND VPWR VPWR _2930_ sky130_fd_sc_hd__buf_2
XFILLER_0_51_3 VPWR VGND VPWR VGND sky130_ef_sc_hd__decap_12
X_5157_ u_interface.u_compute_core.relu_data\[24\] u_interface.u_compute_core.relu_data\[23\]
+ _0502_ _0504_ VGND VGND VPWR VPWR _1723_ sky130_fd_sc_hd__and4_1
X_5088_ u_interface.u_compute_core.relu_data\[16\] _0702_ VGND VGND VPWR VPWR _1655_
+ sky130_fd_sc_hd__nand2_4
X_4108_ _2736_ _0688_ _0689_ net61 VGND VGND VPWR VPWR _0114_ sky130_fd_sc_hd__o211a_1
X_4039_ _0620_ _0621_ VGND VGND VPWR VPWR _0622_ sky130_fd_sc_hd__or2b_1
XFILLER_0_78_153 VPWR VGND VPWR VGND sky130_ef_sc_hd__decap_12
XTAP_TAPCELL_ROW_50_674 VGND VPWR sky130_fd_sc_hd__tapvpwrvgnd_1
XFILLER_0_22_429 VGND VGND VPWR VPWR sky130_fd_sc_hd__fill_2
XFILLER_0_34_289 VGND VGND VPWR VPWR sky130_fd_sc_hd__decap_6
XTAP_TAPCELL_ROW_58_752 VGND VPWR sky130_fd_sc_hd__tapvpwrvgnd_1
Xmax_cap62 _2862_ VGND VGND VPWR VPWR net62 sky130_fd_sc_hd__clkbuf_1
XFILLER_0_57_315 VPWR VGND VPWR VGND sky130_ef_sc_hd__decap_12
XFILLER_0_57_337 VGND VGND VPWR VPWR sky130_fd_sc_hd__fill_1
XFILLER_0_72_329 VGND VGND VPWR VPWR sky130_fd_sc_hd__fill_2
XTAP_TAPCELL_ROW_13_321 VGND VPWR sky130_fd_sc_hd__tapvpwrvgnd_1
XFILLER_0_4_117 VPWR VGND VPWR VGND sky130_ef_sc_hd__decap_12
XFILLER_0_25_278 VGND VGND VPWR VPWR sky130_fd_sc_hd__fill_2
XFILLER_0_0_301 VGND VGND VPWR VPWR sky130_fd_sc_hd__decap_3
X_3410_ _2865_ VGND VGND VPWR VPWR _2866_ sky130_fd_sc_hd__inv_2
X_4390_ _0964_ _0965_ _0894_ VGND VGND VPWR VPWR _0967_ sky130_fd_sc_hd__o21ai_1
XFILLER_0_0_345 VGND VGND VPWR VPWR sky130_fd_sc_hd__fill_1
X_3341_ _2799_ _2803_ VGND VGND VPWR VPWR _2806_ sky130_fd_sc_hd__nand2_1
XFILLER_0_0_378 VGND VGND VPWR VPWR sky130_fd_sc_hd__decap_3
XTAP_TAPCELL_ROW_90_1058 VGND VPWR sky130_fd_sc_hd__tapvpwrvgnd_1
X_6060_ _2561_ VGND VGND VPWR VPWR _0194_ sky130_fd_sc_hd__clkbuf_1
X_3272_ _2741_ _2743_ _2744_ _2746_ net146 VGND VGND VPWR VPWR _0060_ sky130_fd_sc_hd__a32o_1
X_5011_ _1577_ _1578_ VGND VGND VPWR VPWR _1579_ sky130_fd_sc_hd__xnor2_1
XFILLER_0_88_473 VGND VGND VPWR VPWR sky130_fd_sc_hd__decap_3
X_5913_ _2436_ _2442_ VGND VGND VPWR VPWR _2449_ sky130_fd_sc_hd__nand2_1
X_5844_ _2387_ _2388_ VGND VGND VPWR VPWR _2389_ sky130_fd_sc_hd__and2b_1
XFILLER_0_75_167 VGND VGND VPWR VPWR sky130_fd_sc_hd__fill_1
XFILLER_0_8_445 VPWR VGND VPWR VGND sky130_ef_sc_hd__decap_12
XFILLER_0_33_93 VPWR VGND VPWR VGND sky130_ef_sc_hd__decap_12
XFILLER_0_75_189 VPWR VGND VPWR VGND sky130_ef_sc_hd__decap_12
XFILLER_0_8_489 VPWR VGND VPWR VGND sky130_ef_sc_hd__decap_12
X_5775_ u_interface.core_attn_out\[4\] u_interface.u_compute_core.u_av.product_reg\[7\]
+ VGND VGND VPWR VPWR _2329_ sky130_fd_sc_hd__or2_1
X_4726_ _1296_ _1297_ VGND VGND VPWR VPWR _1298_ sky130_fd_sc_hd__and2_1
X_4657_ _2628_ _0587_ VGND VGND VPWR VPWR _1230_ sky130_fd_sc_hd__nand2_1
XFILLER_0_71_384 VGND VGND VPWR VPWR sky130_fd_sc_hd__fill_1
X_3608_ _3008_ _3009_ _3042_ _0204_ VGND VGND VPWR VPWR _0207_ sky130_fd_sc_hd__a22o_1
X_4588_ _1161_ _1153_ VGND VGND VPWR VPWR _1162_ sky130_fd_sc_hd__nor2_4
X_3539_ _2958_ _2977_ _2754_ VGND VGND VPWR VPWR _2979_ sky130_fd_sc_hd__a21o_1
X_6258_ clknet_leaf_21_clk _0171_ VGND VGND VPWR VPWR net60 sky130_fd_sc_hd__dfxtp_1
X_6189_ clknet_leaf_22_clk _0102_ VGND VGND VPWR VPWR u_interface.u_compute_core.u_mac.product_reg\[11\]
+ sky130_fd_sc_hd__dfxtp_1
X_5209_ _1773_ _1774_ VGND VGND VPWR VPWR _1775_ sky130_fd_sc_hd__and2_1
XTAP_TAPCELL_ROW_55_722 VGND VPWR sky130_fd_sc_hd__tapvpwrvgnd_1
XTAP_TAPCELL_ROW_27_457 VGND VPWR sky130_fd_sc_hd__tapvpwrvgnd_1
XFILLER_0_39_337 VGND VGND VPWR VPWR sky130_fd_sc_hd__decap_6
XFILLER_0_62_384 VGND VGND VPWR VPWR sky130_fd_sc_hd__decap_8
XFILLER_0_38_27 VGND VGND VPWR VPWR sky130_fd_sc_hd__fill_1
XFILLER_0_54_15 VPWR VGND VPWR VGND sky130_ef_sc_hd__decap_12
X_3890_ _0478_ _0479_ VGND VGND VPWR VPWR _0480_ sky130_fd_sc_hd__xnor2_1
XFILLER_0_72_159 VGND VGND VPWR VPWR sky130_fd_sc_hd__decap_4
X_5560_ _0571_ _2120_ _2121_ _1337_ VGND VGND VPWR VPWR _0134_ sky130_fd_sc_hd__o211a_1
XFILLER_0_53_351 VPWR VGND VPWR VGND sky130_ef_sc_hd__decap_12
X_4511_ _1076_ _1084_ _1085_ VGND VGND VPWR VPWR _1086_ sky130_fd_sc_hd__nand3_1
XFILLER_0_53_384 VGND VGND VPWR VPWR sky130_fd_sc_hd__fill_1
X_5491_ _2051_ _2052_ VGND VGND VPWR VPWR _2053_ sky130_fd_sc_hd__nor2_1
X_4442_ _1008_ _1016_ _1017_ VGND VGND VPWR VPWR _1018_ sky130_fd_sc_hd__nand3_1
Xhold105 u_interface.core_attn_out\[28\] VGND VGND VPWR VPWR net170 sky130_fd_sc_hd__dlygate4sd3_1
Xhold116 u_interface.u_compute_core.mac_accum\[7\] VGND VGND VPWR VPWR net181 sky130_fd_sc_hd__dlygate4sd3_1
Xhold127 u_interface.core_attn_out\[22\] VGND VGND VPWR VPWR net192 sky130_fd_sc_hd__dlygate4sd3_1
Xhold138 u_interface.core_attn_out\[1\] VGND VGND VPWR VPWR net203 sky130_fd_sc_hd__dlygate4sd3_1
Xhold149 u_interface.u_compute_core.u_av.product_reg\[3\] VGND VGND VPWR VPWR net214
+ sky130_fd_sc_hd__dlygate4sd3_1
X_4373_ _0947_ _0948_ _0949_ VGND VGND VPWR VPWR _0950_ sky130_fd_sc_hd__nand3_1
XFILLER_0_0_153 VGND VGND VPWR VPWR sky130_fd_sc_hd__decap_4
XFILLER_0_0_175 VGND VGND VPWR VPWR sky130_fd_sc_hd__decap_3
X_3324_ _2791_ VGND VGND VPWR VPWR _2792_ sky130_fd_sc_hd__inv_2
X_6112_ clknet_leaf_9_clk _0025_ VGND VGND VPWR VPWR u_interface.u_compute_core.relu_data\[25\]
+ sky130_fd_sc_hd__dfxtp_2
X_3255_ u_interface.u_compute_core.scaled_data\[28\] u_interface.u_compute_core.mac_accum\[31\]
+ _2713_ VGND VGND VPWR VPWR _2733_ sky130_fd_sc_hd__mux2_1
X_6043_ _2550_ VGND VGND VPWR VPWR _0188_ sky130_fd_sc_hd__clkbuf_1
XTAP_TAPCELL_ROW_69_858 VGND VPWR sky130_fd_sc_hd__tapvpwrvgnd_1
X_3186_ _2672_ _2685_ VGND VGND VPWR VPWR _2686_ sky130_fd_sc_hd__and2_1
XFILLER_0_14_3 VGND VGND VPWR VPWR sky130_fd_sc_hd__decap_6
XFILLER_0_76_421 VGND VGND VPWR VPWR sky130_fd_sc_hd__decap_4
XTAP_TAPCELL_ROW_24_427 VGND VPWR sky130_fd_sc_hd__tapvpwrvgnd_1
XFILLER_0_76_454 VGND VGND VPWR VPWR sky130_fd_sc_hd__fill_1
XFILLER_0_48_167 VGND VGND VPWR VPWR sky130_fd_sc_hd__decap_6
XFILLER_0_8_253 VPWR VGND VPWR VGND sky130_ef_sc_hd__decap_12
X_5827_ u_interface.core_attn_out\[11\] u_interface.u_compute_core.u_av.product_reg\[14\]
+ VGND VGND VPWR VPWR _2374_ sky130_fd_sc_hd__nor2_1
XFILLER_0_29_370 VPWR VGND VPWR VGND sky130_ef_sc_hd__decap_12
X_5758_ u_interface.core_attn_out\[0\] u_interface.u_compute_core.u_av.product_reg\[3\]
+ _2305_ _2313_ VGND VGND VPWR VPWR _2314_ sky130_fd_sc_hd__a31o_1
X_4709_ u_interface.u_compute_core.relu_data\[12\] net114 net23 _0632_ VGND VGND VPWR
+ VPWR _1281_ sky130_fd_sc_hd__and4_1
XFILLER_0_44_384 VGND VGND VPWR VPWR sky130_fd_sc_hd__fill_2
XFILLER_0_71_192 VGND VGND VPWR VPWR sky130_fd_sc_hd__fill_1
X_5689_ _2242_ _2243_ VGND VGND VPWR VPWR _2248_ sky130_fd_sc_hd__or2_1
XFILLER_0_8_92 VPWR VGND VPWR VGND sky130_ef_sc_hd__decap_12
XFILLER_0_79_281 VGND VGND VPWR VPWR sky130_fd_sc_hd__decap_3
XFILLER_0_39_167 VGND VGND VPWR VPWR sky130_fd_sc_hd__fill_1
XFILLER_0_54_104 VGND VGND VPWR VPWR sky130_fd_sc_hd__decap_8
XFILLER_0_54_137 VGND VGND VPWR VPWR sky130_fd_sc_hd__decap_3
XFILLER_0_49_15 VPWR VGND VPWR VGND sky130_ef_sc_hd__decap_12
XTAP_TAPCELL_ROW_66_828 VGND VPWR sky130_fd_sc_hd__tapvpwrvgnd_1
X_4991_ _0915_ net216 VGND VGND VPWR VPWR _1560_ sky130_fd_sc_hd__or2_1
XFILLER_0_58_421 VPWR VGND VPWR VGND sky130_ef_sc_hd__decap_12
X_3942_ _0526_ _0527_ VGND VGND VPWR VPWR _0528_ sky130_fd_sc_hd__nor2_1
XFILLER_0_58_465 VGND VGND VPWR VPWR sky130_fd_sc_hd__decap_8
XFILLER_0_14_73 VGND VGND VPWR VPWR sky130_fd_sc_hd__decap_3
X_3873_ _0431_ _0434_ _0462_ VGND VGND VPWR VPWR _0464_ sky130_fd_sc_hd__and3_1
XFILLER_0_45_137 VGND VGND VPWR VPWR sky130_fd_sc_hd__decap_4
X_5612_ _2094_ _2101_ VGND VGND VPWR VPWR _2173_ sky130_fd_sc_hd__nor2_1
XFILLER_0_26_362 VGND VGND VPWR VPWR sky130_fd_sc_hd__fill_2
X_5543_ _2101_ _2102_ _2103_ VGND VGND VPWR VPWR _2105_ sky130_fd_sc_hd__o21a_1
XFILLER_0_30_83 VGND VGND VPWR VPWR sky130_fd_sc_hd__fill_1
X_5474_ _1945_ _2033_ _2034_ _1950_ _2035_ VGND VGND VPWR VPWR _2036_ sky130_fd_sc_hd__o221a_1
X_4425_ _0999_ _1000_ VGND VGND VPWR VPWR _1001_ sky130_fd_sc_hd__nor2b_1
X_4356_ _0930_ _0931_ _0932_ VGND VGND VPWR VPWR _0933_ sky130_fd_sc_hd__and3_1
XFILLER_0_1_473 VPWR VGND VPWR VGND sky130_ef_sc_hd__decap_12
X_3307_ u_interface.u_compute_core.u_mac.product_reg\[6\] u_interface.u_compute_core.mac_accum\[6\]
+ VGND VGND VPWR VPWR _2777_ sky130_fd_sc_hd__or2_1
X_4287_ _0862_ _0863_ _0864_ VGND VGND VPWR VPWR _0865_ sky130_fd_sc_hd__nand3_1
X_6026_ _2538_ VGND VGND VPWR VPWR _0183_ sky130_fd_sc_hd__clkbuf_1
X_3238_ _2716_ _2721_ VGND VGND VPWR VPWR _2722_ sky130_fd_sc_hd__and2_1
X_3169_ _2674_ VGND VGND VPWR VPWR _0029_ sky130_fd_sc_hd__clkbuf_1
XTAP_TAPCELL_ROW_37_552 VGND VPWR sky130_fd_sc_hd__tapvpwrvgnd_1
XFILLER_0_76_251 VGND VGND VPWR VPWR sky130_fd_sc_hd__fill_1
XFILLER_0_32_354 VGND VGND VPWR VPWR sky130_fd_sc_hd__decap_4
XFILLER_0_3_3 VPWR VGND VPWR VGND sky130_ef_sc_hd__decap_12
XTAP_TAPCELL_ROW_9_288 VGND VPWR sky130_fd_sc_hd__tapvpwrvgnd_1
XFILLER_0_35_28 VGND VGND VPWR VPWR sky130_fd_sc_hd__fill_1
XFILLER_0_87_505 VPWR VGND VPWR VGND sky130_ef_sc_hd__decap_12
XFILLER_0_51_27 VPWR VGND VPWR VGND sky130_ef_sc_hd__decap_12
XTAP_TAPCELL_ROW_71_875 VGND VPWR sky130_fd_sc_hd__tapvpwrvgnd_1
XFILLER_0_67_295 VGND VGND VPWR VPWR sky130_fd_sc_hd__decap_8
XFILLER_0_55_424 VGND VGND VPWR VPWR sky130_fd_sc_hd__decap_4
XFILLER_0_70_427 VGND VGND VPWR VPWR sky130_fd_sc_hd__fill_1
XFILLER_0_55_479 VPWR VGND VPWR VGND sky130_ef_sc_hd__decap_12
XFILLER_0_2_204 VPWR VGND VPWR VGND sky130_ef_sc_hd__decap_12
Xclkload14 clknet_leaf_12_clk VGND VGND VPWR VPWR clkload14/Y sky130_fd_sc_hd__bufinv_16
XFILLER_0_42_129 VGND VGND VPWR VPWR sky130_fd_sc_hd__decap_8
XFILLER_0_23_365 VPWR VGND VPWR VGND sky130_ef_sc_hd__decap_12
XFILLER_0_23_387 VGND VGND VPWR VPWR sky130_fd_sc_hd__decap_4
X_4210_ _0788_ _0789_ VGND VGND VPWR VPWR _0790_ sky130_fd_sc_hd__or2b_1
XFILLER_0_50_195 VGND VGND VPWR VPWR sky130_fd_sc_hd__fill_1
X_5190_ _1752_ _1753_ _1754_ VGND VGND VPWR VPWR _1756_ sky130_fd_sc_hd__a21o_1
XTAP_TAPCELL_ROW_79_953 VGND VPWR sky130_fd_sc_hd__tapvpwrvgnd_1
XFILLER_0_76_79 VGND VGND VPWR VPWR sky130_fd_sc_hd__decap_4
X_4141_ _0620_ _0673_ _0672_ VGND VGND VPWR VPWR _0722_ sky130_fd_sc_hd__a21bo_1
X_4072_ _0652_ _0653_ VGND VGND VPWR VPWR _0654_ sky130_fd_sc_hd__nor2_1
X_4974_ _1501_ _1541_ _1542_ VGND VGND VPWR VPWR _1543_ sky130_fd_sc_hd__nor3_4
XTAP_TAPCELL_ROW_34_522 VGND VPWR sky130_fd_sc_hd__tapvpwrvgnd_1
XFILLER_0_58_240 VPWR VGND VPWR VGND sky130_ef_sc_hd__decap_12
XFILLER_0_46_413 VGND VGND VPWR VPWR sky130_fd_sc_hd__decap_6
X_3925_ _0487_ _0491_ _0511_ VGND VGND VPWR VPWR _0512_ sky130_fd_sc_hd__and3_1
XFILLER_0_18_148 VGND VGND VPWR VPWR sky130_fd_sc_hd__decap_4
X_3856_ _0380_ _0417_ _0447_ VGND VGND VPWR VPWR _0448_ sky130_fd_sc_hd__a21oi_1
Xclkload8 clknet_leaf_8_clk VGND VGND VPWR VPWR clkload8/Y sky130_fd_sc_hd__inv_8
X_3787_ _0269_ _0379_ VGND VGND VPWR VPWR _0381_ sky130_fd_sc_hd__and2_1
XFILLER_0_26_170 VGND VGND VPWR VPWR sky130_fd_sc_hd__decap_6
XFILLER_0_14_365 VGND VGND VPWR VPWR sky130_fd_sc_hd__fill_1
X_5526_ _2080_ _2081_ _2086_ VGND VGND VPWR VPWR _2088_ sky130_fd_sc_hd__nand3_1
X_5457_ _1935_ _1929_ VGND VGND VPWR VPWR _2020_ sky130_fd_sc_hd__or2_1
X_4408_ _2631_ _0493_ _0547_ _2629_ VGND VGND VPWR VPWR _0984_ sky130_fd_sc_hd__o2bb2a_1
XFILLER_0_1_281 VPWR VGND VPWR VGND sky130_ef_sc_hd__decap_12
X_5388_ _1947_ _1951_ VGND VGND VPWR VPWR _1952_ sky130_fd_sc_hd__xor2_1
XTAP_TAPCELL_ROW_6_258 VGND VPWR sky130_fd_sc_hd__tapvpwrvgnd_1
X_4339_ _2736_ _0914_ _0916_ net61 VGND VGND VPWR VPWR _0118_ sky130_fd_sc_hd__o211a_1
XFILLER_0_5_82 VPWR VGND VPWR VGND sky130_ef_sc_hd__decap_12
X_6009_ net56 u_interface.core_attn_out\[6\] _2521_ VGND VGND VPWR VPWR _2527_ sky130_fd_sc_hd__mux2_1
XFILLER_0_69_516 VPWR VGND VPWR VGND sky130_ef_sc_hd__decap_12
XFILLER_0_69_505 VGND VGND VPWR VPWR sky130_fd_sc_hd__decap_6
XFILLER_0_24_107 VGND VGND VPWR VPWR sky130_fd_sc_hd__decap_3
XFILLER_0_52_449 VPWR VGND VPWR VGND sky130_ef_sc_hd__decap_12
XTAP_TAPCELL_ROW_76_923 VGND VPWR sky130_fd_sc_hd__tapvpwrvgnd_1
XFILLER_0_87_302 VGND VGND VPWR VPWR sky130_fd_sc_hd__fill_1
XTAP_TAPCELL_ROW_48_658 VGND VPWR sky130_fd_sc_hd__tapvpwrvgnd_1
XFILLER_0_62_15 VPWR VGND VPWR VGND sky130_ef_sc_hd__decap_12
XFILLER_0_62_59 VGND VGND VPWR VPWR sky130_fd_sc_hd__decap_4
XFILLER_0_83_541 VGND VGND VPWR VPWR sky130_fd_sc_hd__decap_6
X_3710_ _0299_ _0305_ VGND VGND VPWR VPWR _0306_ sky130_fd_sc_hd__xor2_1
XFILLER_0_28_435 VGND VGND VPWR VPWR sky130_fd_sc_hd__decap_8
X_4690_ _1167_ _1242_ VGND VGND VPWR VPWR _1262_ sky130_fd_sc_hd__or2_1
XFILLER_0_28_468 VGND VGND VPWR VPWR sky130_fd_sc_hd__fill_1
X_3641_ _3025_ _3031_ _3030_ VGND VGND VPWR VPWR _0239_ sky130_fd_sc_hd__a21oi_1
XFILLER_0_43_449 VGND VGND VPWR VPWR sky130_fd_sc_hd__decap_3
X_3572_ net164 _2805_ _3010_ _2741_ VGND VGND VPWR VPWR _0096_ sky130_fd_sc_hd__a22o_1
X_5311_ u_interface.u_compute_core.relu_data\[24\] u_interface.u_compute_core.relu_data\[23\]
+ _0525_ _0816_ VGND VGND VPWR VPWR _1875_ sky130_fd_sc_hd__and4_1
X_5242_ _1509_ _0587_ _0702_ _1209_ VGND VGND VPWR VPWR _1807_ sky130_fd_sc_hd__a22oi_2
X_5173_ _2650_ _0587_ _0558_ _2647_ VGND VGND VPWR VPWR _1739_ sky130_fd_sc_hd__a22o_1
X_4124_ u_interface.u_compute_core.relu_data\[3\] _0594_ _0632_ u_interface.u_compute_core.relu_data\[2\]
+ VGND VGND VPWR VPWR _0705_ sky130_fd_sc_hd__a22o_1
Xinput1 m_tready VGND VGND VPWR VPWR net1 sky130_fd_sc_hd__clkbuf_1
XTAP_TAPCELL_ROW_3_228 VGND VPWR sky130_fd_sc_hd__tapvpwrvgnd_1
X_4055_ _0637_ _0600_ VGND VGND VPWR VPWR _0638_ sky130_fd_sc_hd__xor2_1
XTAP_TAPCELL_ROW_19_382 VGND VPWR sky130_fd_sc_hd__tapvpwrvgnd_1
XFILLER_0_86_390 VPWR VGND VPWR VGND sky130_ef_sc_hd__decap_12
X_4957_ _1523_ _1524_ _1447_ VGND VGND VPWR VPWR _1526_ sky130_fd_sc_hd__o21ai_1
XFILLER_0_19_457 VGND VGND VPWR VPWR sky130_fd_sc_hd__decap_6
X_4888_ _1445_ _1456_ _1457_ VGND VGND VPWR VPWR _1458_ sky130_fd_sc_hd__nand3_4
X_3908_ net14 VGND VGND VPWR VPWR _0495_ sky130_fd_sc_hd__clkbuf_4
X_3839_ _0397_ _0401_ _0430_ VGND VGND VPWR VPWR _0431_ sky130_fd_sc_hd__o21ai_1
XFILLER_0_14_162 VGND VGND VPWR VPWR sky130_fd_sc_hd__decap_4
XFILLER_0_14_195 VGND VGND VPWR VPWR sky130_fd_sc_hd__fill_1
X_5509_ _1981_ _2070_ VGND VGND VPWR VPWR _2071_ sky130_fd_sc_hd__xnor2_1
XTAP_TAPCELL_ROW_45_628 VGND VPWR sky130_fd_sc_hd__tapvpwrvgnd_1
XFILLER_0_84_338 VPWR VGND VPWR VGND sky130_ef_sc_hd__decap_12
XFILLER_0_32_29 VGND VGND VPWR VPWR sky130_fd_sc_hd__decap_4
XTAP_TAPCELL_ROW_81_970 VGND VPWR sky130_fd_sc_hd__tapvpwrvgnd_1
XFILLER_0_37_210 VGND VGND VPWR VPWR sky130_fd_sc_hd__decap_3
XFILLER_0_92_393 VPWR VGND VPWR VGND sky130_ef_sc_hd__decap_12
XFILLER_0_80_533 VPWR VGND VPWR VGND sky130_ef_sc_hd__decap_12
XFILLER_0_25_427 VGND VGND VPWR VPWR sky130_fd_sc_hd__decap_6
XPHY_EDGE_ROW_2_Left_95 VGND VGND VPWR VPWR sky130_fd_sc_hd__decap_3
XFILLER_0_52_279 VPWR VGND VPWR VGND sky130_ef_sc_hd__decap_12
XFILLER_0_0_505 VPWR VGND VPWR VGND sky130_ef_sc_hd__decap_12
XFILLER_0_57_15 VPWR VGND VPWR VGND sky130_ef_sc_hd__decap_12
XFILLER_0_87_110 VGND VGND VPWR VPWR sky130_fd_sc_hd__fill_2
XFILLER_0_73_47 VGND VGND VPWR VPWR sky130_fd_sc_hd__decap_8
X_5860_ _2401_ _2402_ VGND VGND VPWR VPWR _2403_ sky130_fd_sc_hd__and2b_1
XFILLER_0_87_165 VGND VGND VPWR VPWR sky130_fd_sc_hd__decap_3
X_4811_ _1378_ _1379_ _1380_ VGND VGND VPWR VPWR _1382_ sky130_fd_sc_hd__a21oi_1
X_5791_ _2341_ _2342_ VGND VGND VPWR VPWR _2343_ sky130_fd_sc_hd__nand2_1
XFILLER_0_7_104 VGND VGND VPWR VPWR sky130_fd_sc_hd__fill_2
XTAP_TAPCELL_ROW_16_352 VGND VPWR sky130_fd_sc_hd__tapvpwrvgnd_1
X_4742_ _1312_ _1302_ _1303_ VGND VGND VPWR VPWR _1314_ sky130_fd_sc_hd__or3_4
X_4673_ _1245_ _1244_ _1170_ VGND VGND VPWR VPWR _1246_ sky130_fd_sc_hd__and3_1
XFILLER_0_7_159 VGND VGND VPWR VPWR sky130_fd_sc_hd__decap_8
X_3624_ _0220_ _0221_ VGND VGND VPWR VPWR _0222_ sky130_fd_sc_hd__and2_1
XFILLER_0_43_246 VPWR VGND VPWR VGND sky130_ef_sc_hd__decap_12
XFILLER_0_24_471 VGND VGND VPWR VPWR sky130_fd_sc_hd__decap_4
XFILLER_0_43_279 VGND VGND VPWR VPWR sky130_fd_sc_hd__fill_1
X_3555_ _2930_ _2961_ _2992_ net24 VGND VGND VPWR VPWR _2994_ sky130_fd_sc_hd__a22o_1
X_3486_ _2928_ _2929_ _2741_ _2867_ net210 VGND VGND VPWR VPWR _0091_ sky130_fd_sc_hd__a32o_1
X_6274_ clknet_leaf_18_clk _0187_ VGND VGND VPWR VPWR net34 sky130_fd_sc_hd__dfxtp_1
X_5225_ u_interface.u_compute_core.relu_data\[25\] _0494_ VGND VGND VPWR VPWR _1790_
+ sky130_fd_sc_hd__nand2_1
XFILLER_0_44_3 VPWR VGND VPWR VGND sky130_ef_sc_hd__decap_12
X_5156_ _2658_ _0547_ _1570_ VGND VGND VPWR VPWR _1722_ sky130_fd_sc_hd__or3_1
X_5087_ _1652_ _1653_ VGND VGND VPWR VPWR _1654_ sky130_fd_sc_hd__xor2_1
X_4107_ _0521_ u_interface.u_compute_core.u_av.product_reg\[8\] VGND VGND VPWR VPWR
+ _0689_ sky130_fd_sc_hd__or2_1
XFILLER_0_2_61 VGND VGND VPWR VPWR sky130_fd_sc_hd__fill_1
X_4038_ _0617_ _0618_ _0619_ VGND VGND VPWR VPWR _0621_ sky130_fd_sc_hd__a21o_1
XFILLER_0_78_165 VGND VGND VPWR VPWR sky130_fd_sc_hd__decap_4
X_5989_ _2512_ _2513_ net61 VGND VGND VPWR VPWR _0171_ sky130_fd_sc_hd__o21a_1
XFILLER_0_81_308 VGND VGND VPWR VPWR sky130_fd_sc_hd__fill_2
XFILLER_0_62_500 VGND VGND VPWR VPWR sky130_fd_sc_hd__decap_8
XFILLER_0_19_298 VPWR VGND VPWR VGND sky130_ef_sc_hd__decap_12
XTAP_TAPCELL_ROW_50_675 VGND VPWR sky130_fd_sc_hd__tapvpwrvgnd_1
XFILLER_0_62_533 VPWR VGND VPWR VGND sky130_ef_sc_hd__decap_12
XTAP_TAPCELL_ROW_58_753 VGND VPWR sky130_fd_sc_hd__tapvpwrvgnd_1
Xmax_cap63 _1693_ VGND VGND VPWR VPWR net63 sky130_fd_sc_hd__clkbuf_1
XFILLER_0_69_143 VPWR VGND VPWR VGND sky130_ef_sc_hd__decap_12
XFILLER_0_69_121 VGND VGND VPWR VPWR sky130_fd_sc_hd__fill_1
XFILLER_0_69_176 VGND VGND VPWR VPWR sky130_fd_sc_hd__decap_4
XFILLER_0_57_327 VGND VGND VPWR VPWR sky130_fd_sc_hd__decap_8
XTAP_TAPCELL_ROW_13_322 VGND VPWR sky130_fd_sc_hd__tapvpwrvgnd_1
XFILLER_0_65_393 VGND VGND VPWR VPWR sky130_fd_sc_hd__fill_2
XFILLER_0_53_533 VPWR VGND VPWR VGND sky130_ef_sc_hd__decap_12
XFILLER_0_80_352 VPWR VGND VPWR VGND sky130_ef_sc_hd__decap_12
XFILLER_0_4_129 VGND VGND VPWR VPWR sky130_fd_sc_hd__decap_4
XFILLER_0_25_268 VGND VGND VPWR VPWR sky130_fd_sc_hd__fill_2
XFILLER_0_80_396 VGND VGND VPWR VPWR sky130_fd_sc_hd__fill_1
XFILLER_0_68_47 VGND VGND VPWR VPWR sky130_fd_sc_hd__decap_3
XFILLER_0_0_335 VGND VGND VPWR VPWR sky130_fd_sc_hd__fill_1
X_3340_ _2745_ VGND VGND VPWR VPWR _2805_ sky130_fd_sc_hd__clkbuf_4
XFILLER_0_0_357 VGND VGND VPWR VPWR sky130_fd_sc_hd__decap_3
XTAP_TAPCELL_ROW_90_1059 VGND VPWR sky130_fd_sc_hd__tapvpwrvgnd_1
X_5010_ _2644_ _0535_ VGND VGND VPWR VPWR _1578_ sky130_fd_sc_hd__nand2_1
X_3271_ _2745_ VGND VGND VPWR VPWR _2746_ sky130_fd_sc_hd__clkbuf_4
XFILLER_0_88_441 VPWR VGND VPWR VGND sky130_ef_sc_hd__decap_12
X_5912_ _2446_ _2447_ VGND VGND VPWR VPWR _2448_ sky130_fd_sc_hd__nand2_1
XFILLER_0_75_113 VGND VGND VPWR VPWR sky130_fd_sc_hd__decap_3
X_5843_ u_interface.core_attn_out\[13\] u_interface.u_compute_core.u_av.product_reg\[16\]
+ VGND VGND VPWR VPWR _2388_ sky130_fd_sc_hd__nand2_1
XFILLER_0_33_72 VPWR VGND VPWR VGND sky130_ef_sc_hd__decap_12
XFILLER_0_90_138 VGND VGND VPWR VPWR sky130_fd_sc_hd__fill_2
XFILLER_0_8_457 VPWR VGND VPWR VGND sky130_ef_sc_hd__decap_12
X_5774_ u_interface.core_attn_out\[4\] u_interface.u_compute_core.u_av.product_reg\[7\]
+ VGND VGND VPWR VPWR _2328_ sky130_fd_sc_hd__nand2_1
XFILLER_0_44_511 VGND VGND VPWR VPWR sky130_fd_sc_hd__decap_3
XFILLER_0_44_522 VGND VGND VPWR VPWR sky130_fd_sc_hd__decap_8
XFILLER_0_44_533 VPWR VGND VPWR VGND sky130_ef_sc_hd__decap_12
X_4725_ _1294_ _1295_ _1290_ VGND VGND VPWR VPWR _1297_ sky130_fd_sc_hd__a21o_1
X_4656_ _2628_ _0490_ _1157_ _1156_ VGND VGND VPWR VPWR _1229_ sky130_fd_sc_hd__a31o_1
XFILLER_0_16_279 VGND VGND VPWR VPWR sky130_fd_sc_hd__fill_2
X_4587_ _1051_ _1160_ VGND VGND VPWR VPWR _1161_ sky130_fd_sc_hd__xnor2_1
X_3607_ _0205_ VGND VGND VPWR VPWR _0206_ sky130_fd_sc_hd__inv_2
X_3538_ _2958_ _2977_ VGND VGND VPWR VPWR _2978_ sky130_fd_sc_hd__nor2_1
XFILLER_0_12_474 VGND VGND VPWR VPWR sky130_fd_sc_hd__fill_2
X_3469_ _2909_ _2911_ _2915_ VGND VGND VPWR VPWR _2916_ sky130_fd_sc_hd__a21oi_1
X_6257_ clknet_leaf_18_clk _0170_ VGND VGND VPWR VPWR u_interface.core_valid_out sky130_fd_sc_hd__dfxtp_2
X_5208_ _1771_ _1772_ _1713_ VGND VGND VPWR VPWR _1774_ sky130_fd_sc_hd__o21ai_2
X_6188_ clknet_leaf_22_clk _0101_ VGND VGND VPWR VPWR u_interface.u_compute_core.u_mac.product_reg\[10\]
+ sky130_fd_sc_hd__dfxtp_1
X_5139_ _0571_ _1704_ _1705_ _1337_ VGND VGND VPWR VPWR _0129_ sky130_fd_sc_hd__o211a_1
XTAP_TAPCELL_ROW_55_723 VGND VPWR sky130_fd_sc_hd__tapvpwrvgnd_1
XTAP_TAPCELL_ROW_27_458 VGND VPWR sky130_fd_sc_hd__tapvpwrvgnd_1
XFILLER_0_81_127 VPWR VGND VPWR VGND sky130_ef_sc_hd__decap_12
XFILLER_0_74_190 VGND VGND VPWR VPWR sky130_fd_sc_hd__decap_6
XFILLER_0_50_503 VPWR VGND VPWR VGND sky130_ef_sc_hd__decap_12
XFILLER_0_62_363 VGND VGND VPWR VPWR sky130_fd_sc_hd__fill_1
XFILLER_0_54_27 VGND VGND VPWR VPWR sky130_fd_sc_hd__fill_1
XFILLER_0_70_15 VPWR VGND VPWR VGND sky130_ef_sc_hd__decap_12
XFILLER_0_45_308 VGND VGND VPWR VPWR sky130_fd_sc_hd__decap_4
XFILLER_0_57_157 VGND VGND VPWR VPWR sky130_fd_sc_hd__fill_1
XFILLER_0_72_105 VGND VGND VPWR VPWR sky130_fd_sc_hd__fill_1
XFILLER_0_5_405 VPWR VGND VPWR VGND sky130_ef_sc_hd__decap_12
XFILLER_0_26_533 VPWR VGND VPWR VGND sky130_ef_sc_hd__decap_12
X_4510_ _1082_ _1083_ _1077_ VGND VGND VPWR VPWR _1085_ sky130_fd_sc_hd__a21o_1
XFILLER_0_5_449 VPWR VGND VPWR VGND sky130_ef_sc_hd__decap_12
XFILLER_0_41_525 VPWR VGND VPWR VGND sky130_ef_sc_hd__decap_12
XFILLER_0_53_363 VPWR VGND VPWR VGND sky130_ef_sc_hd__decap_12
X_5490_ _2049_ _2050_ _2655_ _0597_ VGND VGND VPWR VPWR _2052_ sky130_fd_sc_hd__and4bb_1
XFILLER_0_80_171 VPWR VGND VPWR VGND sky130_ef_sc_hd__decap_12
X_4441_ _1014_ _1015_ _1009_ VGND VGND VPWR VPWR _1017_ sky130_fd_sc_hd__a21o_1
Xhold106 u_interface.u_compute_core.mac_accum\[12\] VGND VGND VPWR VPWR net171 sky130_fd_sc_hd__dlygate4sd3_1
Xhold117 u_interface.u_compute_core.mac_accum\[15\] VGND VGND VPWR VPWR net182 sky130_fd_sc_hd__dlygate4sd3_1
XPHY_EDGE_ROW_9_Right_9 VGND VGND VPWR VPWR sky130_fd_sc_hd__decap_3
Xhold139 u_interface.core_attn_out\[13\] VGND VGND VPWR VPWR net204 sky130_fd_sc_hd__dlygate4sd3_1
Xhold128 u_interface.u_compute_core.mac_accum\[16\] VGND VGND VPWR VPWR net193 sky130_fd_sc_hd__dlygate4sd3_1
X_4372_ _0612_ _0558_ _0859_ _0858_ VGND VGND VPWR VPWR _0949_ sky130_fd_sc_hd__a31o_1
XFILLER_0_0_132 VGND VGND VPWR VPWR sky130_fd_sc_hd__decap_4
X_6111_ clknet_leaf_9_clk _0024_ VGND VGND VPWR VPWR u_interface.u_compute_core.relu_data\[24\]
+ sky130_fd_sc_hd__dfxtp_1
X_3323_ _2788_ _2789_ _2790_ VGND VGND VPWR VPWR _2791_ sky130_fd_sc_hd__and3_1
X_6042_ _2539_ _2549_ VGND VGND VPWR VPWR _2550_ sky130_fd_sc_hd__and2_1
X_3254_ _2732_ VGND VGND VPWR VPWR _0056_ sky130_fd_sc_hd__clkbuf_1
XTAP_TAPCELL_ROW_69_859 VGND VPWR sky130_fd_sc_hd__tapvpwrvgnd_1
X_3185_ u_interface.u_compute_core.scaled_data\[6\] u_interface.u_compute_core.mac_accum\[9\]
+ _2669_ VGND VGND VPWR VPWR _2685_ sky130_fd_sc_hd__mux2_1
XTAP_TAPCELL_ROW_24_428 VGND VPWR sky130_fd_sc_hd__tapvpwrvgnd_1
X_5826_ _2320_ _2372_ _2373_ _2327_ VGND VGND VPWR VPWR _0148_ sky130_fd_sc_hd__o211a_1
XFILLER_0_29_382 VGND VGND VPWR VPWR sky130_fd_sc_hd__decap_8
XFILLER_0_91_447 VGND VGND VPWR VPWR sky130_fd_sc_hd__fill_1
XFILLER_0_8_265 VPWR VGND VPWR VGND sky130_ef_sc_hd__decap_12
X_5757_ u_interface.core_attn_out\[1\] u_interface.u_compute_core.u_av.product_reg\[4\]
+ VGND VGND VPWR VPWR _2313_ sky130_fd_sc_hd__and2_1
XFILLER_0_29_393 VGND VGND VPWR VPWR sky130_fd_sc_hd__decap_8
XTAP_TAPCELL_ROW_60_770 VGND VPWR sky130_fd_sc_hd__tapvpwrvgnd_1
X_4708_ _1222_ _1219_ _1218_ VGND VGND VPWR VPWR _1280_ sky130_fd_sc_hd__a21o_1
XFILLER_0_44_374 VGND VGND VPWR VPWR sky130_fd_sc_hd__fill_1
X_5688_ _0571_ _2246_ _2247_ _1337_ VGND VGND VPWR VPWR _0136_ sky130_fd_sc_hd__o211a_1
X_4639_ _2641_ _0547_ VGND VGND VPWR VPWR _1212_ sky130_fd_sc_hd__nor2_1
XFILLER_0_39_113 VPWR VGND VPWR VGND sky130_ef_sc_hd__decap_12
XFILLER_0_67_466 VGND VGND VPWR VPWR sky130_fd_sc_hd__fill_2
XFILLER_0_67_455 VGND VGND VPWR VPWR sky130_fd_sc_hd__fill_1
XFILLER_0_27_319 VGND VGND VPWR VPWR sky130_fd_sc_hd__decap_4
XFILLER_0_54_127 VGND VGND VPWR VPWR sky130_fd_sc_hd__fill_2
XFILLER_0_82_458 VPWR VGND VPWR VGND sky130_ef_sc_hd__decap_12
XFILLER_0_2_419 VGND VGND VPWR VPWR sky130_fd_sc_hd__fill_1
XFILLER_0_50_322 VGND VGND VPWR VPWR sky130_fd_sc_hd__decap_8
XFILLER_0_49_27 VPWR VGND VPWR VGND sky130_ef_sc_hd__decap_12
XFILLER_0_65_15 VPWR VGND VPWR VGND sky130_ef_sc_hd__decap_12
XFILLER_0_4_29 VPWR VGND VPWR VGND sky130_ef_sc_hd__decap_12
XTAP_TAPCELL_ROW_66_829 VGND VPWR sky130_fd_sc_hd__tapvpwrvgnd_1
X_4990_ _1556_ _1558_ VGND VGND VPWR VPWR _1559_ sky130_fd_sc_hd__xnor2_1
XFILLER_0_58_433 VPWR VGND VPWR VGND sky130_ef_sc_hd__decap_12
XFILLER_0_58_477 VPWR VGND VPWR VGND sky130_ef_sc_hd__decap_12
X_3941_ _2595_ _0496_ _0500_ _2592_ VGND VGND VPWR VPWR _0527_ sky130_fd_sc_hd__a22oi_1
XFILLER_0_85_263 VPWR VGND VPWR VGND sky130_ef_sc_hd__decap_12
X_3872_ _0431_ _0434_ _0462_ VGND VGND VPWR VPWR _0463_ sky130_fd_sc_hd__a21oi_1
XFILLER_0_45_105 VGND VGND VPWR VPWR sky130_fd_sc_hd__decap_6
XFILLER_0_73_469 VGND VGND VPWR VPWR sky130_fd_sc_hd__fill_1
XFILLER_0_73_447 VGND VGND VPWR VPWR sky130_fd_sc_hd__fill_1
XFILLER_0_26_330 VPWR VGND VPWR VGND sky130_ef_sc_hd__decap_12
X_5611_ _2166_ _2171_ VGND VGND VPWR VPWR _2172_ sky130_fd_sc_hd__xnor2_1
XFILLER_0_14_514 VPWR VGND VPWR VGND sky130_ef_sc_hd__decap_12
X_5542_ _2101_ _2102_ _2103_ VGND VGND VPWR VPWR _2104_ sky130_fd_sc_hd__nor3_1
XFILLER_0_5_279 VGND VGND VPWR VPWR sky130_fd_sc_hd__fill_1
XFILLER_0_30_73 VGND VGND VPWR VPWR sky130_fd_sc_hd__fill_2
X_5473_ _2025_ _2028_ VGND VGND VPWR VPWR _2035_ sky130_fd_sc_hd__or2b_1
X_4424_ _0996_ _0997_ _0998_ VGND VGND VPWR VPWR _1000_ sky130_fd_sc_hd__a21o_1
XFILLER_0_1_441 VGND VGND VPWR VPWR sky130_fd_sc_hd__decap_6
XFILLER_0_41_399 VGND VGND VPWR VPWR sky130_fd_sc_hd__fill_1
X_4355_ _0862_ _0864_ _0863_ VGND VGND VPWR VPWR _0932_ sky130_fd_sc_hd__a21bo_1
XFILLER_0_1_485 VPWR VGND VPWR VGND sky130_ef_sc_hd__decap_12
X_3306_ u_interface.u_compute_core.u_mac.product_reg\[6\] u_interface.u_compute_core.mac_accum\[6\]
+ VGND VGND VPWR VPWR _2776_ sky130_fd_sc_hd__and2_1
X_4286_ _2625_ _0492_ _0495_ _2622_ VGND VGND VPWR VPWR _0864_ sky130_fd_sc_hd__a22o_1
X_6025_ _2516_ _2537_ VGND VGND VPWR VPWR _2538_ sky130_fd_sc_hd__and2_1
X_3237_ u_interface.u_compute_core.scaled_data\[22\] u_interface.u_compute_core.mac_accum\[25\]
+ _2713_ VGND VGND VPWR VPWR _2721_ sky130_fd_sc_hd__mux2_1
X_3168_ _2672_ _2673_ VGND VGND VPWR VPWR _2674_ sky130_fd_sc_hd__and2_1
X_3099_ _2622_ VGND VGND VPWR VPWR _2623_ sky130_fd_sc_hd__inv_2
XTAP_TAPCELL_ROW_37_553 VGND VPWR sky130_fd_sc_hd__tapvpwrvgnd_1
XFILLER_0_49_444 VGND VGND VPWR VPWR sky130_fd_sc_hd__fill_1
XFILLER_0_9_541 VGND VGND VPWR VPWR sky130_fd_sc_hd__decap_6
X_5809_ u_interface.core_attn_out\[8\] _2301_ VGND VGND VPWR VPWR _2359_ sky130_fd_sc_hd__or2_1
XFILLER_0_91_266 VGND VGND VPWR VPWR sky130_fd_sc_hd__fill_2
XPHY_EDGE_ROW_8_Left_101 VGND VGND VPWR VPWR sky130_fd_sc_hd__decap_3
XTAP_TAPCELL_ROW_9_289 VGND VPWR sky130_fd_sc_hd__tapvpwrvgnd_1
XFILLER_0_87_517 VPWR VGND VPWR VGND sky130_ef_sc_hd__decap_12
XTAP_TAPCELL_ROW_71_876 VGND VPWR sky130_fd_sc_hd__tapvpwrvgnd_1
XFILLER_0_67_285 VGND VGND VPWR VPWR sky130_fd_sc_hd__fill_1
XFILLER_0_51_39 VPWR VGND VPWR VGND sky130_ef_sc_hd__decap_12
XFILLER_0_55_414 VGND VGND VPWR VPWR sky130_fd_sc_hd__decap_3
Xclkload15 clknet_leaf_13_clk VGND VGND VPWR VPWR clkload15/Y sky130_fd_sc_hd__clkinvlp_2
XFILLER_0_2_216 VPWR VGND VPWR VGND sky130_ef_sc_hd__decap_12
XFILLER_0_50_141 VPWR VGND VPWR VGND sky130_ef_sc_hd__decap_12
XFILLER_0_23_377 VGND VGND VPWR VPWR sky130_fd_sc_hd__decap_6
X_4140_ _0720_ _0712_ VGND VGND VPWR VPWR _0721_ sky130_fd_sc_hd__xor2_2
XTAP_TAPCELL_ROW_79_954 VGND VPWR sky130_fd_sc_hd__tapvpwrvgnd_1
X_4071_ _2610_ u_interface.u_compute_core.relu_data\[7\] _0492_ _0503_ VGND VGND VPWR
+ VPWR _0653_ sky130_fd_sc_hd__and4_1
XFILLER_0_92_57 VPWR VGND VPWR VGND sky130_ef_sc_hd__decap_12
X_4973_ _1539_ _1540_ net74 VGND VGND VPWR VPWR _1542_ sky130_fd_sc_hd__a21oi_1
XTAP_TAPCELL_ROW_34_523 VGND VPWR sky130_fd_sc_hd__tapvpwrvgnd_1
X_3924_ _0509_ _0510_ VGND VGND VPWR VPWR _0511_ sky130_fd_sc_hd__nor2_1
XFILLER_0_6_533 VPWR VGND VPWR VGND sky130_ef_sc_hd__decap_12
X_3855_ _0416_ _0415_ VGND VGND VPWR VPWR _0447_ sky130_fd_sc_hd__and2b_1
Xclkload9 clknet_leaf_20_clk VGND VGND VPWR VPWR clkload9/Y sky130_fd_sc_hd__clkinv_4
XFILLER_0_41_83 VGND VGND VPWR VPWR sky130_fd_sc_hd__fill_2
XFILLER_0_46_469 VGND VGND VPWR VPWR sky130_fd_sc_hd__fill_1
X_3786_ _0269_ _0379_ VGND VGND VPWR VPWR _0380_ sky130_fd_sc_hd__nor2_1
XFILLER_0_26_160 VGND VGND VPWR VPWR sky130_fd_sc_hd__decap_4
XFILLER_0_54_491 VGND VGND VPWR VPWR sky130_fd_sc_hd__decap_8
X_5525_ _2080_ _2081_ _2086_ VGND VGND VPWR VPWR _2087_ sky130_fd_sc_hd__a21o_1
X_5456_ _2017_ _2018_ VGND VGND VPWR VPWR _2019_ sky130_fd_sc_hd__nor2b_1
X_4407_ _0982_ _0970_ _0971_ VGND VGND VPWR VPWR _0983_ sky130_fd_sc_hd__nor3_1
XFILLER_0_1_293 VPWR VGND VPWR VGND sky130_ef_sc_hd__decap_12
X_5387_ _1712_ _1948_ _1950_ VGND VGND VPWR VPWR _1951_ sky130_fd_sc_hd__o21a_1
XTAP_TAPCELL_ROW_6_259 VGND VPWR sky130_fd_sc_hd__tapvpwrvgnd_1
X_4338_ _0915_ u_interface.u_compute_core.u_av.product_reg\[12\] VGND VGND VPWR VPWR
+ _0916_ sky130_fd_sc_hd__or2_1
XFILLER_0_5_94 VGND VGND VPWR VPWR sky130_fd_sc_hd__decap_6
X_4269_ net92 _0846_ _0796_ VGND VGND VPWR VPWR _0848_ sky130_fd_sc_hd__a21o_1
X_6008_ _2512_ net136 _2526_ VGND VGND VPWR VPWR _0177_ sky130_fd_sc_hd__o21a_1
XFILLER_0_69_528 VPWR VGND VPWR VGND sky130_ef_sc_hd__decap_12
XFILLER_0_49_241 VGND VGND VPWR VPWR sky130_fd_sc_hd__fill_1
XFILLER_0_64_299 VGND VGND VPWR VPWR sky130_fd_sc_hd__decap_8
XFILLER_0_32_141 VGND VGND VPWR VPWR sky130_fd_sc_hd__fill_1
XFILLER_0_60_450 VGND VGND VPWR VPWR sky130_fd_sc_hd__fill_2
XFILLER_0_32_163 VPWR VGND VPWR VGND sky130_ef_sc_hd__decap_12
XFILLER_0_60_494 VGND VGND VPWR VPWR sky130_fd_sc_hd__fill_1
XTAP_TAPCELL_ROW_76_924 VGND VPWR sky130_fd_sc_hd__tapvpwrvgnd_1
XTAP_TAPCELL_ROW_86_1020 VGND VPWR sky130_fd_sc_hd__tapvpwrvgnd_1
XTAP_TAPCELL_ROW_48_659 VGND VPWR sky130_fd_sc_hd__tapvpwrvgnd_1
XFILLER_0_62_27 VGND VGND VPWR VPWR sky130_fd_sc_hd__fill_1
XFILLER_0_70_225 VGND VGND VPWR VPWR sky130_fd_sc_hd__decap_4
XFILLER_0_11_20 VPWR VGND VPWR VGND sky130_ef_sc_hd__decap_12
X_3640_ _0236_ _0237_ VGND VGND VPWR VPWR _0238_ sky130_fd_sc_hd__or2_1
XFILLER_0_3_503 VGND VGND VPWR VPWR sky130_fd_sc_hd__fill_1
X_3571_ _3008_ _3009_ VGND VGND VPWR VPWR _3010_ sky130_fd_sc_hd__xor2_1
X_6290_ clknet_leaf_15_clk _0203_ VGND VGND VPWR VPWR net52 sky130_fd_sc_hd__dfxtp_1
XFILLER_0_51_461 VGND VGND VPWR VPWR sky130_fd_sc_hd__decap_3
X_5310_ _2660_ _0500_ _0490_ u_interface.u_compute_core.relu_data\[23\] VGND VGND
+ VPWR VPWR _1874_ sky130_fd_sc_hd__a22oi_1
XFILLER_0_87_57 VGND VGND VPWR VPWR sky130_fd_sc_hd__decap_6
X_5241_ u_interface.u_compute_core.relu_data\[18\] _0633_ VGND VGND VPWR VPWR _1806_
+ sky130_fd_sc_hd__nand2_2
XFILLER_0_11_369 VGND VGND VPWR VPWR sky130_fd_sc_hd__fill_1
X_5172_ _2650_ u_interface.u_compute_core.relu_data\[19\] _0587_ _0557_ VGND VGND
+ VPWR VPWR _1738_ sky130_fd_sc_hd__and4_1
X_4123_ u_interface.u_compute_core.relu_data\[3\] _0632_ VGND VGND VPWR VPWR _0704_
+ sky130_fd_sc_hd__nand2_1
Xinput2 rst VGND VGND VPWR VPWR net2 sky130_fd_sc_hd__buf_2
XTAP_TAPCELL_ROW_3_229 VGND VPWR sky130_fd_sc_hd__tapvpwrvgnd_1
X_4054_ _0623_ _0636_ VGND VGND VPWR VPWR _0637_ sky130_fd_sc_hd__xnor2_1
XFILLER_0_78_325 VGND VGND VPWR VPWR sky130_fd_sc_hd__fill_1
XFILLER_0_78_369 VGND VGND VPWR VPWR sky130_fd_sc_hd__fill_1
XTAP_TAPCELL_ROW_19_383 VGND VPWR sky130_fd_sc_hd__tapvpwrvgnd_1
XFILLER_0_86_380 VGND VGND VPWR VPWR sky130_fd_sc_hd__fill_1
X_4956_ _1447_ _1523_ _1524_ VGND VGND VPWR VPWR _1525_ sky130_fd_sc_hd__or3_4
XFILLER_0_74_531 VGND VGND VPWR VPWR sky130_fd_sc_hd__fill_1
XFILLER_0_52_93 VGND VGND VPWR VPWR sky130_fd_sc_hd__fill_2
X_4887_ _1454_ _1455_ _1381_ VGND VGND VPWR VPWR _1457_ sky130_fd_sc_hd__a21o_1
X_3907_ _0493_ VGND VGND VPWR VPWR _0494_ sky130_fd_sc_hd__clkbuf_4
X_3838_ _0398_ _0429_ VGND VGND VPWR VPWR _0430_ sky130_fd_sc_hd__xnor2_1
XFILLER_0_61_225 VGND VGND VPWR VPWR sky130_fd_sc_hd__fill_2
XFILLER_0_14_141 VGND VGND VPWR VPWR sky130_fd_sc_hd__fill_2
XFILLER_0_42_450 VGND VGND VPWR VPWR sky130_fd_sc_hd__fill_1
X_3769_ _2992_ _3014_ _0361_ VGND VGND VPWR VPWR _0363_ sky130_fd_sc_hd__and3_1
X_5508_ _2068_ _2069_ VGND VGND VPWR VPWR _2070_ sky130_fd_sc_hd__nand2_1
X_5439_ _1998_ _2001_ VGND VGND VPWR VPWR _2002_ sky130_fd_sc_hd__xnor2_1
XTAP_TAPCELL_ROW_45_629 VGND VPWR sky130_fd_sc_hd__tapvpwrvgnd_1
XTAP_TAPCELL_ROW_81_971 VGND VPWR sky130_fd_sc_hd__tapvpwrvgnd_1
XFILLER_0_92_361 VGND VGND VPWR VPWR sky130_fd_sc_hd__decap_3
XFILLER_0_25_439 VGND VGND VPWR VPWR sky130_fd_sc_hd__fill_2
XFILLER_0_80_545 VGND VGND VPWR VPWR sky130_fd_sc_hd__fill_2
XFILLER_0_0_517 VPWR VGND VPWR VGND sky130_ef_sc_hd__decap_12
XFILLER_0_60_280 VGND VGND VPWR VPWR sky130_fd_sc_hd__decap_4
XFILLER_0_57_27 VPWR VGND VPWR VGND sky130_ef_sc_hd__decap_12
XFILLER_0_73_15 VPWR VGND VPWR VGND sky130_ef_sc_hd__decap_12
XFILLER_0_87_133 VPWR VGND VPWR VGND sky130_ef_sc_hd__decap_12
XFILLER_0_48_509 VGND VGND VPWR VPWR sky130_fd_sc_hd__fill_1
X_4810_ _1379_ _1378_ _1380_ VGND VGND VPWR VPWR _1381_ sky130_fd_sc_hd__and3_1
XFILLER_0_75_306 VGND VGND VPWR VPWR sky130_fd_sc_hd__decap_8
XFILLER_0_68_391 VGND VGND VPWR VPWR sky130_fd_sc_hd__fill_2
X_5790_ u_interface.core_attn_out\[6\] u_interface.u_compute_core.u_av.product_reg\[9\]
+ VGND VGND VPWR VPWR _2342_ sky130_fd_sc_hd__or2_1
XTAP_TAPCELL_ROW_16_353 VGND VPWR sky130_fd_sc_hd__tapvpwrvgnd_1
XFILLER_0_56_520 VPWR VGND VPWR VGND sky130_ef_sc_hd__decap_12
XFILLER_0_90_309 VGND VGND VPWR VPWR sky130_fd_sc_hd__fill_1
X_4741_ _1302_ _1303_ _1312_ VGND VGND VPWR VPWR _1313_ sky130_fd_sc_hd__o21a_1
X_4672_ _1207_ _1208_ _1243_ VGND VGND VPWR VPWR _1245_ sky130_fd_sc_hd__a21o_1
XFILLER_0_28_299 VGND VGND VPWR VPWR sky130_fd_sc_hd__fill_1
X_3623_ _0215_ _0219_ VGND VGND VPWR VPWR _0221_ sky130_fd_sc_hd__or2_1
XFILLER_0_31_409 VGND VGND VPWR VPWR sky130_fd_sc_hd__fill_1
XFILLER_0_43_258 VGND VGND VPWR VPWR sky130_fd_sc_hd__decap_6
X_3554_ net25 _2992_ VGND VGND VPWR VPWR _2993_ sky130_fd_sc_hd__nand2_1
XFILLER_0_11_155 VPWR VGND VPWR VGND sky130_ef_sc_hd__decap_12
X_3485_ net10 VGND VGND VPWR VPWR _2929_ sky130_fd_sc_hd__buf_2
X_6273_ clknet_leaf_17_clk _0186_ VGND VGND VPWR VPWR net33 sky130_fd_sc_hd__dfxtp_1
X_5224_ _1730_ _1744_ VGND VGND VPWR VPWR _1789_ sky130_fd_sc_hd__or2_1
X_5155_ _1645_ _1646_ _1664_ VGND VGND VPWR VPWR _1721_ sky130_fd_sc_hd__or3_1
XFILLER_0_37_3 VGND VGND VPWR VPWR sky130_fd_sc_hd__decap_6
X_5086_ _2644_ _0536_ _1576_ _1575_ VGND VGND VPWR VPWR _1653_ sky130_fd_sc_hd__a31o_1
X_4106_ _0645_ net70 VGND VGND VPWR VPWR _0688_ sky130_fd_sc_hd__xor2_1
X_4037_ _0617_ _0618_ _0619_ VGND VGND VPWR VPWR _0620_ sky130_fd_sc_hd__and3_1
XFILLER_0_63_81 VGND VGND VPWR VPWR sky130_fd_sc_hd__fill_1
X_5988_ net1 net222 VGND VGND VPWR VPWR _2513_ sky130_fd_sc_hd__and2b_1
XFILLER_0_19_222 VGND VGND VPWR VPWR sky130_fd_sc_hd__fill_2
X_4939_ u_interface.u_compute_core.relu_data\[21\] _2640_ _0502_ _0587_ VGND VGND
+ VPWR VPWR _1508_ sky130_fd_sc_hd__and4_1
XFILLER_0_74_350 VPWR VGND VPWR VGND sky130_ef_sc_hd__decap_12
XFILLER_0_19_255 VGND VGND VPWR VPWR sky130_fd_sc_hd__fill_2
XFILLER_0_74_394 VGND VGND VPWR VPWR sky130_fd_sc_hd__fill_1
XTAP_TAPCELL_ROW_50_676 VGND VPWR sky130_fd_sc_hd__tapvpwrvgnd_1
XFILLER_0_6_160 VGND VGND VPWR VPWR sky130_fd_sc_hd__fill_1
XFILLER_0_62_545 VGND VGND VPWR VPWR sky130_fd_sc_hd__fill_2
XFILLER_0_34_269 VGND VGND VPWR VPWR sky130_fd_sc_hd__decap_4
XFILLER_0_15_483 VGND VGND VPWR VPWR sky130_fd_sc_hd__fill_2
XFILLER_0_30_475 VGND VGND VPWR VPWR sky130_fd_sc_hd__fill_1
XFILLER_0_69_111 VGND VGND VPWR VPWR sky130_fd_sc_hd__fill_1
XTAP_TAPCELL_ROW_58_754 VGND VPWR sky130_fd_sc_hd__tapvpwrvgnd_1
Xmax_cap64 _0564_ VGND VGND VPWR VPWR net64 sky130_fd_sc_hd__clkbuf_1
XFILLER_0_84_103 VPWR VGND VPWR VGND sky130_ef_sc_hd__decap_12
XFILLER_0_69_155 VGND VGND VPWR VPWR sky130_fd_sc_hd__fill_1
XFILLER_0_38_520 VPWR VGND VPWR VGND sky130_ef_sc_hd__decap_12
XFILLER_0_84_169 VGND VGND VPWR VPWR sky130_fd_sc_hd__decap_4
XFILLER_0_72_309 VPWR VGND VPWR VGND sky130_ef_sc_hd__decap_12
XTAP_TAPCELL_ROW_13_323 VGND VPWR sky130_fd_sc_hd__tapvpwrvgnd_1
XFILLER_0_65_361 VPWR VGND VPWR VGND sky130_ef_sc_hd__decap_12
XFILLER_0_25_225 VGND VGND VPWR VPWR sky130_fd_sc_hd__fill_1
XFILLER_0_25_236 VPWR VGND VPWR VGND sky130_ef_sc_hd__decap_12
XFILLER_0_53_545 VGND VGND VPWR VPWR sky130_fd_sc_hd__fill_2
XFILLER_0_68_15 VPWR VGND VPWR VGND sky130_ef_sc_hd__decap_12
X_3270_ net2 net27 VGND VGND VPWR VPWR _2745_ sky130_fd_sc_hd__nor2_2
XFILLER_0_17_41 VGND VGND VPWR VPWR sky130_fd_sc_hd__decap_8
XFILLER_0_88_453 VPWR VGND VPWR VGND sky130_ef_sc_hd__decap_12
X_5911_ u_interface.core_attn_out\[22\] u_interface.u_compute_core.u_av.product_reg\[25\]
+ VGND VGND VPWR VPWR _2447_ sky130_fd_sc_hd__nand2_1
X_5842_ u_interface.core_attn_out\[13\] u_interface.u_compute_core.u_av.product_reg\[16\]
+ VGND VGND VPWR VPWR _2387_ sky130_fd_sc_hd__nor2_1
X_5773_ _2320_ _2325_ _2326_ _2327_ VGND VGND VPWR VPWR _0141_ sky130_fd_sc_hd__o211a_1
XFILLER_0_29_542 VGND VGND VPWR VPWR sky130_fd_sc_hd__fill_1
XFILLER_0_33_84 VGND VGND VPWR VPWR sky130_fd_sc_hd__decap_3
X_4724_ _1290_ _1294_ _1295_ VGND VGND VPWR VPWR _1296_ sky130_fd_sc_hd__nand3_1
XFILLER_0_8_469 VGND VGND VPWR VPWR sky130_fd_sc_hd__decap_6
XFILLER_0_44_545 VGND VGND VPWR VPWR sky130_fd_sc_hd__fill_2
X_4655_ _1154_ _1159_ VGND VGND VPWR VPWR _1228_ sky130_fd_sc_hd__and2_1
X_4586_ _1154_ _1159_ VGND VGND VPWR VPWR _1160_ sky130_fd_sc_hd__xor2_1
X_3606_ _3008_ _3009_ _3042_ _0204_ VGND VGND VPWR VPWR _0205_ sky130_fd_sc_hd__and4_1
XFILLER_0_31_239 VGND VGND VPWR VPWR sky130_fd_sc_hd__decap_8
XFILLER_0_12_442 VPWR VGND VPWR VGND sky130_ef_sc_hd__decap_12
XFILLER_0_3_196 VGND VGND VPWR VPWR sky130_fd_sc_hd__decap_6
X_3537_ _2975_ _2976_ VGND VGND VPWR VPWR _2977_ sky130_fd_sc_hd__xnor2_1
X_6256_ clknet_leaf_14_clk _0169_ VGND VGND VPWR VPWR u_interface.core_attn_out\[31\]
+ sky130_fd_sc_hd__dfxtp_1
X_3468_ _2913_ _2914_ VGND VGND VPWR VPWR _2915_ sky130_fd_sc_hd__nand2_1
X_5207_ _1713_ _1771_ _1772_ VGND VGND VPWR VPWR _1773_ sky130_fd_sc_hd__or3_1
X_6187_ clknet_leaf_22_clk _0100_ VGND VGND VPWR VPWR u_interface.u_compute_core.u_mac.product_reg\[9\]
+ sky130_fd_sc_hd__dfxtp_1
X_3399_ _2851_ _2853_ _2855_ VGND VGND VPWR VPWR _2856_ sky130_fd_sc_hd__a21oi_1
X_5138_ _0915_ net218 VGND VGND VPWR VPWR _1705_ sky130_fd_sc_hd__or2_1
X_5069_ _1625_ _1626_ VGND VGND VPWR VPWR _1636_ sky130_fd_sc_hd__nor2_1
XFILLER_0_74_80 VGND VGND VPWR VPWR sky130_fd_sc_hd__decap_4
XTAP_TAPCELL_ROW_55_724 VGND VPWR sky130_fd_sc_hd__tapvpwrvgnd_1
XTAP_TAPCELL_ROW_27_459 VGND VPWR sky130_fd_sc_hd__tapvpwrvgnd_1
XFILLER_0_47_361 VPWR VGND VPWR VGND sky130_ef_sc_hd__decap_12
XFILLER_0_81_139 VPWR VGND VPWR VGND sky130_ef_sc_hd__decap_12
XFILLER_0_35_545 VGND VGND VPWR VPWR sky130_fd_sc_hd__fill_2
XFILLER_0_62_331 VPWR VGND VPWR VGND sky130_ef_sc_hd__decap_12
XFILLER_0_50_515 VGND VGND VPWR VPWR sky130_fd_sc_hd__decap_8
XPHY_EDGE_ROW_26_Left_119 VGND VGND VPWR VPWR sky130_fd_sc_hd__decap_3
XFILLER_0_89_206 VGND VGND VPWR VPWR sky130_fd_sc_hd__decap_4
XPHY_EDGE_ROW_35_Left_128 VGND VGND VPWR VPWR sky130_fd_sc_hd__decap_3
XFILLER_0_70_27 VGND VGND VPWR VPWR sky130_fd_sc_hd__fill_1
XFILLER_0_72_128 VPWR VGND VPWR VGND sky130_ef_sc_hd__decap_12
XFILLER_0_38_361 VGND VGND VPWR VPWR sky130_fd_sc_hd__decap_3
XFILLER_0_38_372 VGND VGND VPWR VPWR sky130_fd_sc_hd__decap_8
XFILLER_0_5_417 VPWR VGND VPWR VGND sky130_ef_sc_hd__decap_12
XFILLER_0_26_545 VGND VGND VPWR VPWR sky130_fd_sc_hd__fill_2
XFILLER_0_53_342 VGND VGND VPWR VPWR sky130_fd_sc_hd__fill_2
XFILLER_0_80_183 VPWR VGND VPWR VGND sky130_ef_sc_hd__decap_12
X_4440_ _1009_ _1014_ _1015_ VGND VGND VPWR VPWR _1016_ sky130_fd_sc_hd__nand3_1
Xhold107 u_interface.u_compute_core.mac_accum\[28\] VGND VGND VPWR VPWR net172 sky130_fd_sc_hd__dlygate4sd3_1
XFILLER_0_41_537 VGND VGND VPWR VPWR sky130_fd_sc_hd__decap_8
XPHY_EDGE_ROW_44_Left_137 VGND VGND VPWR VPWR sky130_fd_sc_hd__decap_3
XFILLER_0_0_111 VGND VGND VPWR VPWR sky130_fd_sc_hd__fill_1
Xhold118 u_interface.core_attn_out\[17\] VGND VGND VPWR VPWR net183 sky130_fd_sc_hd__dlygate4sd3_1
Xhold129 u_interface.u_compute_core.mac_accum\[21\] VGND VGND VPWR VPWR net194 sky130_fd_sc_hd__dlygate4sd3_1
X_4371_ _0702_ _0944_ _0945_ _0818_ VGND VGND VPWR VPWR _0948_ sky130_fd_sc_hd__a31o_4
X_6110_ clknet_leaf_9_clk _0023_ VGND VGND VPWR VPWR u_interface.u_compute_core.relu_data\[23\]
+ sky130_fd_sc_hd__dfxtp_2
X_3322_ _2783_ _2784_ _2782_ VGND VGND VPWR VPWR _2790_ sky130_fd_sc_hd__a21bo_1
X_3253_ _2716_ _2731_ VGND VGND VPWR VPWR _2732_ sky130_fd_sc_hd__and2_1
X_6041_ net35 u_interface.core_attn_out\[16\] _2544_ VGND VGND VPWR VPWR _2549_ sky130_fd_sc_hd__mux2_1
X_3184_ _2684_ VGND VGND VPWR VPWR _0034_ sky130_fd_sc_hd__clkbuf_1
XPHY_EDGE_ROW_53_Left_146 VGND VGND VPWR VPWR sky130_fd_sc_hd__decap_3
XFILLER_0_88_261 VGND VGND VPWR VPWR sky130_fd_sc_hd__fill_2
XFILLER_0_76_434 VPWR VGND VPWR VGND sky130_ef_sc_hd__decap_12
XFILLER_0_48_103 VGND VGND VPWR VPWR sky130_fd_sc_hd__fill_2
X_5825_ u_interface.core_attn_out\[10\] _2301_ VGND VGND VPWR VPWR _2373_ sky130_fd_sc_hd__or2_1
XTAP_TAPCELL_ROW_24_429 VGND VPWR sky130_fd_sc_hd__tapvpwrvgnd_1
XFILLER_0_63_128 VGND VGND VPWR VPWR sky130_fd_sc_hd__fill_1
XFILLER_0_8_277 VPWR VGND VPWR VGND sky130_ef_sc_hd__decap_12
X_5756_ u_interface.core_attn_out\[2\] u_interface.u_compute_core.u_av.product_reg\[5\]
+ VGND VGND VPWR VPWR _2312_ sky130_fd_sc_hd__or2_1
XTAP_TAPCELL_ROW_60_771 VGND VPWR sky130_fd_sc_hd__tapvpwrvgnd_1
X_4707_ _1228_ _1235_ VGND VGND VPWR VPWR _1279_ sky130_fd_sc_hd__nand2_1
XFILLER_0_71_161 VGND VGND VPWR VPWR sky130_fd_sc_hd__fill_1
X_5687_ u_interface.u_compute_core.relu_valid u_interface.u_compute_core.u_av.product_reg\[30\]
+ VGND VGND VPWR VPWR _2247_ sky130_fd_sc_hd__or2_1
XPHY_EDGE_ROW_62_Left_155 VGND VGND VPWR VPWR sky130_fd_sc_hd__decap_3
X_4638_ _2637_ _0496_ VGND VGND VPWR VPWR _1211_ sky130_fd_sc_hd__nand2_1
XFILLER_0_71_172 VGND VGND VPWR VPWR sky130_fd_sc_hd__fill_1
XFILLER_0_8_72 VGND VGND VPWR VPWR sky130_fd_sc_hd__fill_2
X_4569_ _1142_ VGND VGND VPWR VPWR _1143_ sky130_fd_sc_hd__buf_12
X_6239_ clknet_leaf_15_clk _0152_ VGND VGND VPWR VPWR u_interface.core_attn_out\[14\]
+ sky130_fd_sc_hd__dfxtp_1
XPHY_EDGE_ROW_71_Left_164 VGND VGND VPWR VPWR sky130_fd_sc_hd__decap_3
XFILLER_0_79_294 VGND VGND VPWR VPWR sky130_fd_sc_hd__fill_1
XFILLER_0_39_125 VGND VGND VPWR VPWR sky130_fd_sc_hd__decap_6
XFILLER_0_39_147 VPWR VGND VPWR VGND sky130_ef_sc_hd__decap_12
XFILLER_0_39_169 VGND VGND VPWR VPWR sky130_fd_sc_hd__decap_3
XPHY_EDGE_ROW_80_Left_173 VGND VGND VPWR VPWR sky130_fd_sc_hd__decap_3
XFILLER_0_47_180 VPWR VGND VPWR VGND sky130_ef_sc_hd__decap_12
XFILLER_0_35_353 VGND VGND VPWR VPWR sky130_fd_sc_hd__fill_1
Xclone30 u_interface.u_compute_core.relu_data\[5\] VGND VGND VPWR VPWR net95 sky130_fd_sc_hd__clkbuf_16
XFILLER_0_50_312 VGND VGND VPWR VPWR sky130_fd_sc_hd__fill_1
XFILLER_0_10_209 VGND VGND VPWR VPWR sky130_fd_sc_hd__fill_1
XFILLER_0_49_39 VPWR VGND VPWR VGND sky130_ef_sc_hd__decap_12
XFILLER_0_65_27 VPWR VGND VPWR VGND sky130_ef_sc_hd__decap_12
X_3940_ _2595_ _2592_ _0504_ _0525_ VGND VGND VPWR VPWR _0526_ sky130_fd_sc_hd__and4_1
XFILLER_0_85_231 VPWR VGND VPWR VGND sky130_ef_sc_hd__decap_12
XFILLER_0_14_53 VPWR VGND VPWR VGND sky130_ef_sc_hd__decap_12
XFILLER_0_58_445 VGND VGND VPWR VPWR sky130_fd_sc_hd__decap_6
XFILLER_0_85_275 VGND VGND VPWR VPWR sky130_fd_sc_hd__decap_4
X_3871_ _0460_ _0461_ VGND VGND VPWR VPWR _0462_ sky130_fd_sc_hd__nand2_1
XFILLER_0_58_489 VGND VGND VPWR VPWR sky130_fd_sc_hd__fill_1
X_5610_ _1935_ _2170_ VGND VGND VPWR VPWR _2171_ sky130_fd_sc_hd__xnor2_1
X_5541_ _2009_ _2014_ VGND VGND VPWR VPWR _2103_ sky130_fd_sc_hd__and2b_1
XFILLER_0_5_225 VPWR VGND VPWR VGND sky130_ef_sc_hd__decap_12
XFILLER_0_26_342 VGND VGND VPWR VPWR sky130_fd_sc_hd__decap_8
XFILLER_0_53_150 VPWR VGND VPWR VGND sky130_ef_sc_hd__decap_12
XFILLER_0_14_526 VGND VGND VPWR VPWR sky130_fd_sc_hd__decap_6
XFILLER_0_26_375 VGND VGND VPWR VPWR sky130_fd_sc_hd__decap_8
XFILLER_0_41_301 VGND VGND VPWR VPWR sky130_fd_sc_hd__decap_8
XFILLER_0_41_323 VPWR VGND VPWR VGND sky130_ef_sc_hd__decap_12
XFILLER_0_76_7 VPWR VGND VPWR VGND sky130_ef_sc_hd__decap_12
XFILLER_0_30_85 VGND VGND VPWR VPWR sky130_fd_sc_hd__decap_8
X_5472_ _1947_ _2029_ VGND VGND VPWR VPWR _2034_ sky130_fd_sc_hd__or2b_1
XFILLER_0_53_194 VGND VGND VPWR VPWR sky130_fd_sc_hd__decap_4
X_4423_ _0996_ _0997_ _0998_ VGND VGND VPWR VPWR _0999_ sky130_fd_sc_hd__and3_1
X_4354_ _0928_ _0929_ _0926_ VGND VGND VPWR VPWR _0931_ sky130_fd_sc_hd__o21ai_1
XFILLER_0_1_497 VGND VGND VPWR VPWR sky130_fd_sc_hd__decap_6
X_3305_ u_interface.u_compute_core.u_mac.product_reg\[5\] u_interface.u_compute_core.mac_accum\[5\]
+ _2764_ _2765_ _2774_ VGND VGND VPWR VPWR _2775_ sky130_fd_sc_hd__a221o_1
X_4285_ _2625_ _2622_ _0492_ _0495_ VGND VGND VPWR VPWR _0863_ sky130_fd_sc_hd__nand4_1
X_6024_ net30 u_interface.core_attn_out\[11\] _2521_ VGND VGND VPWR VPWR _2537_ sky130_fd_sc_hd__mux2_1
X_3236_ _2720_ VGND VGND VPWR VPWR _0050_ sky130_fd_sc_hd__clkbuf_1
X_3167_ u_interface.u_compute_core.scaled_data\[0\] u_interface.u_compute_core.mac_accum\[3\]
+ _2669_ VGND VGND VPWR VPWR _2673_ sky130_fd_sc_hd__mux2_1
X_3098_ u_interface.u_compute_core.relu_data\[11\] VGND VGND VPWR VPWR _2622_ sky130_fd_sc_hd__clkbuf_4
XTAP_TAPCELL_ROW_37_554 VGND VPWR sky130_fd_sc_hd__tapvpwrvgnd_1
XFILLER_0_76_253 VGND VGND VPWR VPWR sky130_fd_sc_hd__decap_4
XFILLER_0_91_201 VGND VGND VPWR VPWR sky130_fd_sc_hd__decap_3
XFILLER_0_71_81 VGND VGND VPWR VPWR sky130_fd_sc_hd__decap_8
XFILLER_0_36_106 VGND VGND VPWR VPWR sky130_fd_sc_hd__decap_3
XFILLER_0_91_223 VGND VGND VPWR VPWR sky130_fd_sc_hd__fill_1
X_5808_ _2356_ _2357_ VGND VGND VPWR VPWR _2358_ sky130_fd_sc_hd__xor2_1
X_5739_ _2251_ _2297_ VGND VGND VPWR VPWR _2298_ sky130_fd_sc_hd__xnor2_1
XFILLER_0_72_481 VPWR VGND VPWR VGND sky130_ef_sc_hd__decap_12
XFILLER_0_87_529 VPWR VGND VPWR VGND sky130_ef_sc_hd__decap_12
XTAP_TAPCELL_ROW_0_190 VGND VPWR sky130_fd_sc_hd__tapvpwrvgnd_1
XTAP_TAPCELL_ROW_71_877 VGND VPWR sky130_fd_sc_hd__tapvpwrvgnd_1
Xclkload16 clknet_leaf_14_clk VGND VGND VPWR VPWR clkload16/Y sky130_fd_sc_hd__clkinv_4
XFILLER_0_2_228 VPWR VGND VPWR VGND sky130_ef_sc_hd__decap_12
XFILLER_0_50_120 VGND VGND VPWR VPWR sky130_fd_sc_hd__decap_8
XFILLER_0_50_153 VGND VGND VPWR VPWR sky130_fd_sc_hd__decap_4
XFILLER_0_50_186 VGND VGND VPWR VPWR sky130_fd_sc_hd__fill_1
X_4070_ _2611_ _0515_ _0547_ _2607_ VGND VGND VPWR VPWR _0652_ sky130_fd_sc_hd__o2bb2a_1
XFILLER_0_92_69 VPWR VGND VPWR VGND sky130_ef_sc_hd__decap_12
X_4972_ _1539_ net74 _1540_ VGND VGND VPWR VPWR _1541_ sky130_fd_sc_hd__and3_4
XTAP_TAPCELL_ROW_34_524 VGND VPWR sky130_fd_sc_hd__tapvpwrvgnd_1
X_3923_ _0494_ _0497_ _0508_ VGND VGND VPWR VPWR _0510_ sky130_fd_sc_hd__a21oi_1
XFILLER_0_73_223 VGND VGND VPWR VPWR sky130_fd_sc_hd__fill_1
XFILLER_0_6_501 VPWR VGND VPWR VGND sky130_ef_sc_hd__decap_12
X_3854_ _0444_ _0445_ VGND VGND VPWR VPWR _0446_ sky130_fd_sc_hd__nor2_1
XFILLER_0_6_545 VGND VGND VPWR VPWR sky130_fd_sc_hd__fill_2
XFILLER_0_41_73 VGND VGND VPWR VPWR sky130_fd_sc_hd__fill_1
X_3785_ _0300_ _0337_ _0338_ _0304_ VGND VGND VPWR VPWR _0379_ sky130_fd_sc_hd__o2bb2a_1
X_5524_ _1593_ _2085_ VGND VGND VPWR VPWR _2086_ sky130_fd_sc_hd__xnor2_1
XFILLER_0_41_131 VGND VGND VPWR VPWR sky130_fd_sc_hd__decap_4
X_5455_ _2014_ _2015_ _2016_ VGND VGND VPWR VPWR _2018_ sky130_fd_sc_hd__a21o_1
XFILLER_0_67_3 VPWR VGND VPWR VGND sky130_ef_sc_hd__decap_12
XFILLER_0_1_261 VPWR VGND VPWR VGND sky130_ef_sc_hd__decap_12
XFILLER_0_41_186 VPWR VGND VPWR VGND sky130_ef_sc_hd__decap_12
X_4406_ _0918_ VGND VGND VPWR VPWR _0982_ sky130_fd_sc_hd__clkbuf_4
X_5386_ _1859_ _1861_ _1949_ VGND VGND VPWR VPWR _1950_ sky130_fd_sc_hd__a21oi_1
X_4337_ u_interface.u_compute_core.relu_valid VGND VGND VPWR VPWR _0915_ sky130_fd_sc_hd__clkbuf_2
X_4268_ _0796_ net97 _0846_ VGND VGND VPWR VPWR _0847_ sky130_fd_sc_hd__nand3_4
X_6007_ _2512_ _2334_ _2581_ VGND VGND VPWR VPWR _2526_ sky130_fd_sc_hd__a21oi_1
X_3219_ _2708_ VGND VGND VPWR VPWR _0045_ sky130_fd_sc_hd__clkbuf_1
X_4199_ _0738_ _0777_ _0778_ VGND VGND VPWR VPWR _0779_ sky130_fd_sc_hd__nand3b_2
XFILLER_0_9_361 VGND VGND VPWR VPWR sky130_fd_sc_hd__fill_2
XFILLER_0_17_150 VPWR VGND VPWR VGND sky130_ef_sc_hd__decap_12
XFILLER_0_17_183 VPWR VGND VPWR VGND sky130_ef_sc_hd__decap_12
XFILLER_0_20_315 VGND VGND VPWR VPWR sky130_fd_sc_hd__fill_1
XFILLER_0_32_197 VPWR VGND VPWR VGND sky130_ef_sc_hd__decap_12
XTAP_TAPCELL_ROW_76_925 VGND VPWR sky130_fd_sc_hd__tapvpwrvgnd_1
XTAP_TAPCELL_ROW_86_1021 VGND VPWR sky130_fd_sc_hd__tapvpwrvgnd_1
XFILLER_0_87_337 VGND VGND VPWR VPWR sky130_fd_sc_hd__decap_3
XFILLER_0_55_212 VGND VGND VPWR VPWR sky130_fd_sc_hd__fill_1
XFILLER_0_43_407 VGND VGND VPWR VPWR sky130_fd_sc_hd__decap_8
XFILLER_0_11_32 VPWR VGND VPWR VGND sky130_ef_sc_hd__decap_12
XFILLER_0_70_237 VGND VGND VPWR VPWR sky130_fd_sc_hd__fill_1
X_3570_ _2975_ _2976_ _2978_ VGND VGND VPWR VPWR _3009_ sky130_fd_sc_hd__a21o_1
XFILLER_0_23_153 VGND VGND VPWR VPWR sky130_fd_sc_hd__fill_1
X_5240_ _1655_ _1804_ VGND VGND VPWR VPWR _1805_ sky130_fd_sc_hd__xnor2_1
XFILLER_0_11_337 VPWR VGND VPWR VGND sky130_ef_sc_hd__decap_12
X_5171_ _1735_ _1736_ VGND VGND VPWR VPWR _1737_ sky130_fd_sc_hd__xnor2_1
XPHY_EDGE_ROW_18_Right_18 VGND VGND VPWR VPWR sky130_fd_sc_hd__decap_3
X_4122_ u_interface.u_compute_core.relu_data\[1\] _0702_ _0661_ _0660_ VGND VGND VPWR
+ VPWR _0703_ sky130_fd_sc_hd__a31o_1
X_4053_ _0631_ _0635_ VGND VGND VPWR VPWR _0636_ sky130_fd_sc_hd__xnor2_1
Xinput3 s_tdata[0] VGND VGND VPWR VPWR net3 sky130_fd_sc_hd__buf_1
X_4955_ _2634_ _2631_ _0819_ _0656_ VGND VGND VPWR VPWR _1524_ sky130_fd_sc_hd__and4_1
XTAP_TAPCELL_ROW_19_384 VGND VPWR sky130_fd_sc_hd__tapvpwrvgnd_1
XPHY_EDGE_ROW_27_Right_27 VGND VGND VPWR VPWR sky130_fd_sc_hd__decap_3
X_3906_ _0492_ VGND VGND VPWR VPWR _0493_ sky130_fd_sc_hd__clkbuf_4
X_4886_ _1381_ _1454_ _1455_ VGND VGND VPWR VPWR _1456_ sky130_fd_sc_hd__nand3_1
X_3837_ _0427_ _0428_ VGND VGND VPWR VPWR _0429_ sky130_fd_sc_hd__xnor2_1
X_3768_ _2992_ _3014_ _0361_ VGND VGND VPWR VPWR _0362_ sky130_fd_sc_hd__a21oi_1
XFILLER_0_61_248 VGND VGND VPWR VPWR sky130_fd_sc_hd__decap_8
XFILLER_0_14_153 VGND VGND VPWR VPWR sky130_fd_sc_hd__fill_2
X_5507_ _1984_ _2064_ _2067_ VGND VGND VPWR VPWR _2069_ sky130_fd_sc_hd__or3_1
XFILLER_0_14_197 VGND VGND VPWR VPWR sky130_fd_sc_hd__decap_8
X_3699_ _3013_ _2961_ VGND VGND VPWR VPWR _0295_ sky130_fd_sc_hd__nand2_1
X_5438_ _1999_ _2000_ VGND VGND VPWR VPWR _2001_ sky130_fd_sc_hd__or2b_1
XPHY_EDGE_ROW_36_Right_36 VGND VGND VPWR VPWR sky130_fd_sc_hd__decap_3
X_5369_ net88 _1868_ _1931_ _1932_ VGND VGND VPWR VPWR _1933_ sky130_fd_sc_hd__o211a_1
XFILLER_0_77_91 VPWR VGND VPWR VGND sky130_ef_sc_hd__decap_12
XPHY_EDGE_ROW_45_Right_45 VGND VGND VPWR VPWR sky130_fd_sc_hd__decap_3
XTAP_TAPCELL_ROW_81_972 VGND VPWR sky130_fd_sc_hd__tapvpwrvgnd_1
XFILLER_0_37_223 VGND VGND VPWR VPWR sky130_fd_sc_hd__fill_1
XFILLER_0_9_180 VPWR VGND VPWR VGND sky130_ef_sc_hd__decap_12
XFILLER_0_52_215 VGND VGND VPWR VPWR sky130_fd_sc_hd__fill_1
XFILLER_0_52_248 VGND VGND VPWR VPWR sky130_fd_sc_hd__fill_1
XFILLER_0_33_462 VPWR VGND VPWR VGND sky130_ef_sc_hd__decap_12
XFILLER_0_0_529 VGND VGND VPWR VPWR sky130_fd_sc_hd__decap_3
XPHY_EDGE_ROW_54_Right_54 VGND VGND VPWR VPWR sky130_fd_sc_hd__decap_3
XTAP_TAPCELL_ROW_92_1080 VGND VPWR sky130_fd_sc_hd__tapvpwrvgnd_1
XFILLER_0_73_27 VGND VGND VPWR VPWR sky130_fd_sc_hd__decap_3
XPHY_EDGE_ROW_63_Right_63 VGND VGND VPWR VPWR sky130_fd_sc_hd__decap_3
XFILLER_0_87_145 VGND VGND VPWR VPWR sky130_fd_sc_hd__decap_6
XTAP_TAPCELL_ROW_16_354 VGND VPWR sky130_fd_sc_hd__tapvpwrvgnd_1
X_4740_ _1310_ _1311_ VGND VGND VPWR VPWR _1312_ sky130_fd_sc_hd__or2_1
XFILLER_0_7_139 VPWR VGND VPWR VGND sky130_ef_sc_hd__decap_12
X_4671_ _1243_ _1208_ _1207_ VGND VGND VPWR VPWR _1244_ sky130_fd_sc_hd__nand3_2
X_3622_ _0215_ _0219_ VGND VGND VPWR VPWR _0220_ sky130_fd_sc_hd__nand2_1
XPHY_EDGE_ROW_72_Right_72 VGND VGND VPWR VPWR sky130_fd_sc_hd__decap_3
X_3553_ net16 VGND VGND VPWR VPWR _2992_ sky130_fd_sc_hd__buf_2
XFILLER_0_51_281 VGND VGND VPWR VPWR sky130_fd_sc_hd__decap_4
X_3484_ net24 VGND VGND VPWR VPWR _2928_ sky130_fd_sc_hd__buf_2
X_6272_ clknet_leaf_15_clk _0185_ VGND VGND VPWR VPWR net32 sky130_fd_sc_hd__dfxtp_1
X_5223_ _1746_ _1761_ _1762_ VGND VGND VPWR VPWR _1788_ sky130_fd_sc_hd__and3_1
XFILLER_0_11_167 VGND VGND VPWR VPWR sky130_fd_sc_hd__fill_1
X_5154_ _1666_ _1682_ _1683_ VGND VGND VPWR VPWR _1720_ sky130_fd_sc_hd__and3_1
X_4105_ _0684_ _0686_ VGND VGND VPWR VPWR _0687_ sky130_fd_sc_hd__xor2_1
XPHY_EDGE_ROW_81_Right_81 VGND VGND VPWR VPWR sky130_fd_sc_hd__decap_3
X_5085_ _1650_ _1651_ VGND VGND VPWR VPWR _1652_ sky130_fd_sc_hd__xnor2_1
XFILLER_0_2_41 VPWR VGND VPWR VGND sky130_ef_sc_hd__decap_12
X_4036_ _2598_ _0525_ _0578_ _0577_ VGND VGND VPWR VPWR _0619_ sky130_fd_sc_hd__a31o_1
XFILLER_0_78_178 VPWR VGND VPWR VGND sky130_ef_sc_hd__decap_12
X_5987_ u_interface.core_valid_out VGND VGND VPWR VPWR _2512_ sky130_fd_sc_hd__clkbuf_4
XFILLER_0_47_532 VPWR VGND VPWR VGND sky130_ef_sc_hd__decap_12
X_4938_ u_interface.u_compute_core.relu_data\[18\] _0490_ _1358_ VGND VGND VPWR VPWR
+ _1507_ sky130_fd_sc_hd__and3_1
X_4869_ _1437_ _1438_ VGND VGND VPWR VPWR _1439_ sky130_fd_sc_hd__xnor2_1
XFILLER_0_74_362 VGND VGND VPWR VPWR sky130_fd_sc_hd__fill_2
XPHY_EDGE_ROW_90_Right_90 VGND VGND VPWR VPWR sky130_fd_sc_hd__decap_3
XFILLER_0_34_237 VGND VGND VPWR VPWR sky130_fd_sc_hd__fill_2
XTAP_TAPCELL_ROW_50_677 VGND VPWR sky130_fd_sc_hd__tapvpwrvgnd_1
XFILLER_0_6_183 VGND VGND VPWR VPWR sky130_fd_sc_hd__fill_1
XTAP_TAPCELL_ROW_58_755 VGND VPWR sky130_fd_sc_hd__tapvpwrvgnd_1
Xmax_cap65 _0582_ VGND VGND VPWR VPWR net65 sky130_fd_sc_hd__clkbuf_2
XFILLER_0_84_115 VPWR VGND VPWR VGND sky130_ef_sc_hd__decap_12
XFILLER_0_65_340 VGND VGND VPWR VPWR sky130_fd_sc_hd__decap_6
XTAP_TAPCELL_ROW_13_324 VGND VPWR sky130_fd_sc_hd__tapvpwrvgnd_1
XFILLER_0_65_373 VGND VGND VPWR VPWR sky130_fd_sc_hd__decap_8
XFILLER_0_25_204 VGND VGND VPWR VPWR sky130_fd_sc_hd__decap_4
XFILLER_0_92_181 VPWR VGND VPWR VGND sky130_ef_sc_hd__decap_12
XFILLER_0_25_248 VPWR VGND VPWR VGND sky130_ef_sc_hd__decap_12
XFILLER_0_80_365 VGND VGND VPWR VPWR sky130_fd_sc_hd__decap_6
XFILLER_0_80_387 VGND VGND VPWR VPWR sky130_fd_sc_hd__fill_2
XFILLER_0_33_281 VGND VGND VPWR VPWR sky130_fd_sc_hd__decap_3
XFILLER_0_68_27 VGND VGND VPWR VPWR sky130_fd_sc_hd__fill_1
XFILLER_0_0_315 VGND VGND VPWR VPWR sky130_fd_sc_hd__decap_3
XFILLER_0_0_337 VGND VGND VPWR VPWR sky130_fd_sc_hd__decap_8
XFILLER_0_21_465 VGND VGND VPWR VPWR sky130_fd_sc_hd__fill_2
XFILLER_0_21_476 VPWR VGND VPWR VGND sky130_ef_sc_hd__decap_12
XFILLER_0_84_15 VPWR VGND VPWR VGND sky130_ef_sc_hd__decap_12
X_5910_ u_interface.core_attn_out\[22\] u_interface.u_compute_core.u_av.product_reg\[25\]
+ VGND VGND VPWR VPWR _2446_ sky130_fd_sc_hd__or2_1
XFILLER_0_88_465 VGND VGND VPWR VPWR sky130_fd_sc_hd__decap_8
XFILLER_0_48_307 VGND VGND VPWR VPWR sky130_fd_sc_hd__fill_1
X_5841_ _2320_ _2385_ _2386_ _2327_ VGND VGND VPWR VPWR _0150_ sky130_fd_sc_hd__o211a_1
XFILLER_0_48_329 VGND VGND VPWR VPWR sky130_fd_sc_hd__fill_1
XFILLER_0_8_404 VPWR VGND VPWR VGND sky130_ef_sc_hd__decap_12
X_5772_ _2580_ VGND VGND VPWR VPWR _2327_ sky130_fd_sc_hd__clkbuf_4
X_4723_ _1292_ _1293_ _1291_ VGND VGND VPWR VPWR _1295_ sky130_fd_sc_hd__o21ai_1
XFILLER_0_16_226 VPWR VGND VPWR VGND sky130_ef_sc_hd__decap_12
X_4654_ _1226_ net120 VGND VGND VPWR VPWR _1227_ sky130_fd_sc_hd__xnor2_2
X_4585_ _1155_ _1158_ VGND VGND VPWR VPWR _1159_ sky130_fd_sc_hd__xnor2_1
X_3605_ _3040_ _3041_ _3003_ _3006_ VGND VGND VPWR VPWR _0204_ sky130_fd_sc_hd__a211o_1
XFILLER_0_12_421 VGND VGND VPWR VPWR sky130_fd_sc_hd__decap_8
XFILLER_0_12_454 VPWR VGND VPWR VGND sky130_ef_sc_hd__decap_12
X_3536_ _2952_ _2955_ VGND VGND VPWR VPWR _2976_ sky130_fd_sc_hd__nand2_1
X_6255_ clknet_leaf_15_clk _0168_ VGND VGND VPWR VPWR u_interface.core_attn_out\[30\]
+ sky130_fd_sc_hd__dfxtp_1
X_5206_ _1769_ _1770_ _1715_ VGND VGND VPWR VPWR _1772_ sky130_fd_sc_hd__o21a_1
X_3467_ _2834_ u_interface.u_compute_core.mac_accum\[29\] VGND VGND VPWR VPWR _2914_
+ sky130_fd_sc_hd__nand2_1
X_6186_ clknet_leaf_22_clk _0099_ VGND VGND VPWR VPWR u_interface.u_compute_core.u_mac.product_reg\[8\]
+ sky130_fd_sc_hd__dfxtp_1
X_3398_ _2832_ u_interface.u_compute_core.mac_accum\[19\] VGND VGND VPWR VPWR _2855_
+ sky130_fd_sc_hd__xor2_1
XFILLER_0_58_93 VGND VGND VPWR VPWR sky130_fd_sc_hd__decap_3
X_5137_ net67 _1703_ VGND VGND VPWR VPWR _1704_ sky130_fd_sc_hd__xnor2_1
X_5068_ _0485_ net154 _0486_ _1635_ VGND VGND VPWR VPWR _0128_ sky130_fd_sc_hd__o211a_1
X_4019_ _0562_ net64 VGND VGND VPWR VPWR _0603_ sky130_fd_sc_hd__or2_1
XTAP_TAPCELL_ROW_55_725 VGND VPWR sky130_fd_sc_hd__tapvpwrvgnd_1
XPHY_EDGE_ROW_0_Right_0 VGND VGND VPWR VPWR sky130_fd_sc_hd__decap_3
XFILLER_0_35_513 VPWR VGND VPWR VGND sky130_ef_sc_hd__decap_12
XFILLER_0_47_373 VPWR VGND VPWR VGND sky130_ef_sc_hd__decap_12
XFILLER_0_62_321 VGND VGND VPWR VPWR sky130_fd_sc_hd__decap_6
XFILLER_0_62_343 VPWR VGND VPWR VGND sky130_ef_sc_hd__decap_12
XFILLER_0_62_365 VGND VGND VPWR VPWR sky130_fd_sc_hd__decap_6
XFILLER_0_54_29 VPWR VGND VPWR VGND sky130_ef_sc_hd__decap_12
XFILLER_0_38_340 VPWR VGND VPWR VGND sky130_ef_sc_hd__decap_12
XFILLER_0_65_181 VPWR VGND VPWR VGND sky130_ef_sc_hd__decap_12
XFILLER_0_5_429 VPWR VGND VPWR VGND sky130_ef_sc_hd__decap_12
XFILLER_0_80_195 VGND VGND VPWR VPWR sky130_fd_sc_hd__fill_1
XFILLER_0_80_162 VGND VGND VPWR VPWR sky130_fd_sc_hd__fill_1
Xhold108 u_interface.u_compute_core.u_av.product_reg\[15\] VGND VGND VPWR VPWR net173
+ sky130_fd_sc_hd__dlygate4sd3_1
X_4370_ _0946_ VGND VGND VPWR VPWR _0947_ sky130_fd_sc_hd__buf_4
XFILLER_0_21_240 VPWR VGND VPWR VGND sky130_ef_sc_hd__decap_12
Xhold119 u_interface.u_compute_core.u_av.product_reg\[17\] VGND VGND VPWR VPWR net184
+ sky130_fd_sc_hd__dlygate4sd3_1
XFILLER_0_21_262 VGND VGND VPWR VPWR sky130_fd_sc_hd__fill_2
X_3321_ u_interface.u_compute_core.u_mac.product_reg\[8\] u_interface.u_compute_core.mac_accum\[8\]
+ VGND VGND VPWR VPWR _2789_ sky130_fd_sc_hd__or2_1
XFILLER_0_0_189 VGND VGND VPWR VPWR sky130_fd_sc_hd__decap_6
X_3252_ u_interface.u_compute_core.scaled_data\[27\] u_interface.u_compute_core.mac_accum\[30\]
+ _2713_ VGND VGND VPWR VPWR _2731_ sky130_fd_sc_hd__mux2_1
XFILLER_0_28_41 VGND VGND VPWR VPWR sky130_fd_sc_hd__decap_6
X_6040_ _2548_ VGND VGND VPWR VPWR _0187_ sky130_fd_sc_hd__clkbuf_1
X_3183_ _2672_ _2683_ VGND VGND VPWR VPWR _2684_ sky130_fd_sc_hd__and2_1
XFILLER_0_44_95 VPWR VGND VPWR VGND sky130_ef_sc_hd__decap_12
XFILLER_0_76_446 VGND VGND VPWR VPWR sky130_fd_sc_hd__decap_4
X_5824_ _2368_ _2371_ VGND VGND VPWR VPWR _2372_ sky130_fd_sc_hd__xor2_1
XFILLER_0_91_405 VPWR VGND VPWR VGND sky130_ef_sc_hd__decap_12
XFILLER_0_17_502 VGND VGND VPWR VPWR sky130_fd_sc_hd__fill_2
XFILLER_0_91_449 VPWR VGND VPWR VGND sky130_ef_sc_hd__decap_12
X_5755_ u_interface.core_attn_out\[2\] u_interface.u_compute_core.u_av.product_reg\[5\]
+ VGND VGND VPWR VPWR _2311_ sky130_fd_sc_hd__nand2_1
XFILLER_0_56_170 VPWR VGND VPWR VGND sky130_ef_sc_hd__decap_12
XFILLER_0_60_83 VGND VGND VPWR VPWR sky130_fd_sc_hd__fill_1
XTAP_TAPCELL_ROW_60_772 VGND VPWR sky130_fd_sc_hd__tapvpwrvgnd_1
X_4706_ _1276_ _1275_ _1263_ VGND VGND VPWR VPWR _1278_ sky130_fd_sc_hd__a21o_1
XFILLER_0_8_289 VGND VGND VPWR VPWR sky130_fd_sc_hd__fill_1
X_5686_ _2244_ _2245_ VGND VGND VPWR VPWR _2246_ sky130_fd_sc_hd__xor2_1
XFILLER_0_44_354 VGND VGND VPWR VPWR sky130_fd_sc_hd__fill_1
X_4637_ _1209_ _0502_ VGND VGND VPWR VPWR _1210_ sky130_fd_sc_hd__nand2_1
X_4568_ _0988_ _2607_ _1141_ VGND VGND VPWR VPWR _1142_ sky130_fd_sc_hd__mux2_4
X_4499_ _1021_ _1023_ VGND VGND VPWR VPWR _1074_ sky130_fd_sc_hd__nand2_1
X_3519_ _2890_ _2958_ _2959_ _2867_ net141 VGND VGND VPWR VPWR _0094_ sky130_fd_sc_hd__a32o_1
X_6238_ clknet_leaf_15_clk _0151_ VGND VGND VPWR VPWR u_interface.core_attn_out\[13\]
+ sky130_fd_sc_hd__dfxtp_1
X_6169_ clknet_leaf_2_clk _0082_ VGND VGND VPWR VPWR u_interface.u_compute_core.mac_accum\[23\]
+ sky130_fd_sc_hd__dfxtp_1
XTAP_TAPCELL_ROW_68_850 VGND VPWR sky130_fd_sc_hd__tapvpwrvgnd_1
XFILLER_0_79_240 VPWR VGND VPWR VGND sky130_ef_sc_hd__decap_12
XFILLER_0_39_104 VGND VGND VPWR VPWR sky130_fd_sc_hd__decap_8
XFILLER_0_39_159 VGND VGND VPWR VPWR sky130_fd_sc_hd__decap_8
XFILLER_0_82_405 VPWR VGND VPWR VGND sky130_ef_sc_hd__decap_12
XFILLER_0_82_449 VGND VGND VPWR VPWR sky130_fd_sc_hd__decap_3
XFILLER_0_47_192 VGND VGND VPWR VPWR sky130_fd_sc_hd__decap_4
XFILLER_0_90_460 VPWR VGND VPWR VGND sky130_ef_sc_hd__decap_12
Xclone53 _1598_ VGND VGND VPWR VPWR net118 sky130_fd_sc_hd__buf_2
XFILLER_0_23_505 VPWR VGND VPWR VGND sky130_ef_sc_hd__decap_12
Xclkbuf_leaf_20_clk clknet_1_0__leaf_clk VGND VGND VPWR VPWR clknet_leaf_20_clk sky130_fd_sc_hd__clkbuf_8
XFILLER_0_62_173 VGND VGND VPWR VPWR sky130_fd_sc_hd__decap_4
XFILLER_0_50_346 VGND VGND VPWR VPWR sky130_fd_sc_hd__fill_1
XFILLER_0_62_195 VGND VGND VPWR VPWR sky130_fd_sc_hd__fill_1
XFILLER_0_65_39 VPWR VGND VPWR VGND sky130_ef_sc_hd__decap_12
XTAP_TAPCELL_ROW_89_1041 VGND VPWR sky130_fd_sc_hd__tapvpwrvgnd_1
XFILLER_0_85_243 VPWR VGND VPWR VGND sky130_ef_sc_hd__decap_12
XFILLER_0_58_457 VGND VGND VPWR VPWR sky130_fd_sc_hd__fill_1
XFILLER_0_73_405 VGND VGND VPWR VPWR sky130_fd_sc_hd__decap_4
XFILLER_0_14_65 VGND VGND VPWR VPWR sky130_fd_sc_hd__decap_8
X_3870_ _0371_ _0459_ VGND VGND VPWR VPWR _0461_ sky130_fd_sc_hd__nand2_1
XFILLER_0_73_449 VPWR VGND VPWR VGND sky130_ef_sc_hd__decap_12
XFILLER_0_5_204 VGND VGND VPWR VPWR sky130_fd_sc_hd__fill_1
XFILLER_0_5_237 VPWR VGND VPWR VGND sky130_ef_sc_hd__decap_12
XFILLER_0_26_354 VGND VGND VPWR VPWR sky130_fd_sc_hd__decap_4
Xclkbuf_leaf_11_clk clknet_1_1__leaf_clk VGND VGND VPWR VPWR clknet_leaf_11_clk sky130_fd_sc_hd__clkbuf_8
X_5540_ _2094_ _2095_ _2100_ VGND VGND VPWR VPWR _2102_ sky130_fd_sc_hd__o21a_1
X_5471_ _2026_ _2027_ _2025_ VGND VGND VPWR VPWR _2033_ sky130_fd_sc_hd__and3_1
XFILLER_0_53_162 VGND VGND VPWR VPWR sky130_fd_sc_hd__fill_1
XFILLER_0_53_173 VPWR VGND VPWR VGND sky130_ef_sc_hd__decap_12
X_4422_ _0926_ _0929_ _0928_ VGND VGND VPWR VPWR _0998_ sky130_fd_sc_hd__o21bai_1
XFILLER_0_41_335 VGND VGND VPWR VPWR sky130_fd_sc_hd__fill_1
X_4353_ _0926_ _0928_ _0929_ VGND VGND VPWR VPWR _0930_ sky130_fd_sc_hd__or3_4
X_4284_ _2619_ _0498_ VGND VGND VPWR VPWR _0862_ sky130_fd_sc_hd__and2_1
X_3304_ _2763_ VGND VGND VPWR VPWR _2774_ sky130_fd_sc_hd__inv_2
X_6023_ _2536_ VGND VGND VPWR VPWR _0182_ sky130_fd_sc_hd__clkbuf_1
X_3235_ _2716_ _2719_ VGND VGND VPWR VPWR _2720_ sky130_fd_sc_hd__and2_1
X_3166_ _2580_ VGND VGND VPWR VPWR _2672_ sky130_fd_sc_hd__clkbuf_2
X_3097_ _2609_ _2621_ VGND VGND VPWR VPWR _0010_ sky130_fd_sc_hd__nor2_1
XTAP_TAPCELL_ROW_65_820 VGND VPWR sky130_fd_sc_hd__tapvpwrvgnd_1
XFILLER_0_12_3 VGND VGND VPWR VPWR sky130_fd_sc_hd__decap_8
XTAP_TAPCELL_ROW_37_555 VGND VPWR sky130_fd_sc_hd__tapvpwrvgnd_1
XFILLER_0_76_243 VGND VGND VPWR VPWR sky130_fd_sc_hd__decap_8
XFILLER_0_64_405 VPWR VGND VPWR VGND sky130_ef_sc_hd__decap_12
X_5807_ _2349_ _2350_ _2348_ VGND VGND VPWR VPWR _2357_ sky130_fd_sc_hd__a21bo_1
XFILLER_0_17_310 VGND VGND VPWR VPWR sky130_fd_sc_hd__fill_1
X_3999_ _0579_ _0581_ _0548_ VGND VGND VPWR VPWR _0583_ sky130_fd_sc_hd__o21a_1
XFILLER_0_91_279 VGND VGND VPWR VPWR sky130_fd_sc_hd__fill_1
X_5738_ _2254_ _2296_ VGND VGND VPWR VPWR _2297_ sky130_fd_sc_hd__xnor2_1
XFILLER_0_72_493 VPWR VGND VPWR VGND sky130_ef_sc_hd__decap_12
XFILLER_0_44_195 VGND VGND VPWR VPWR sky130_fd_sc_hd__fill_1
X_5669_ _2159_ _2161_ VGND VGND VPWR VPWR _2229_ sky130_fd_sc_hd__nand2_1
XTAP_TAPCELL_ROW_0_191 VGND VPWR sky130_fd_sc_hd__tapvpwrvgnd_1
XFILLER_0_55_405 VGND VGND VPWR VPWR sky130_fd_sc_hd__fill_2
XFILLER_0_82_224 VGND VGND VPWR VPWR sky130_fd_sc_hd__fill_1
XTAP_TAPCELL_ROW_71_878 VGND VPWR sky130_fd_sc_hd__tapvpwrvgnd_1
XFILLER_0_55_449 VGND VGND VPWR VPWR sky130_fd_sc_hd__decap_4
XFILLER_0_70_408 VPWR VGND VPWR VGND sky130_ef_sc_hd__decap_12
XFILLER_0_63_471 VGND VGND VPWR VPWR sky130_fd_sc_hd__decap_4
Xclkload17 clknet_leaf_16_clk VGND VGND VPWR VPWR clkload17/Y sky130_fd_sc_hd__clkinvlp_2
XFILLER_0_76_27 VGND VGND VPWR VPWR sky130_fd_sc_hd__fill_1
XTAP_TAPCELL_ROW_8_280 VGND VPWR sky130_fd_sc_hd__tapvpwrvgnd_1
XFILLER_0_92_15 VPWR VGND VPWR VGND sky130_ef_sc_hd__decap_12
Xclkbuf_leaf_0_clk clknet_1_0__leaf_clk VGND VGND VPWR VPWR clknet_leaf_0_clk sky130_fd_sc_hd__clkbuf_8
XFILLER_0_78_508 VPWR VGND VPWR VGND sky130_ef_sc_hd__decap_12
X_4971_ _1537_ _1538_ _1517_ VGND VGND VPWR VPWR _1540_ sky130_fd_sc_hd__o21ai_1
XTAP_TAPCELL_ROW_34_525 VGND VPWR sky130_fd_sc_hd__tapvpwrvgnd_1
X_3922_ _0494_ _0497_ _0508_ VGND VGND VPWR VPWR _0509_ sky130_fd_sc_hd__and3_1
X_3853_ _0412_ _0443_ VGND VGND VPWR VPWR _0445_ sky130_fd_sc_hd__nor2_1
XFILLER_0_46_449 VGND VGND VPWR VPWR sky130_fd_sc_hd__fill_1
XFILLER_0_58_298 VGND VGND VPWR VPWR sky130_fd_sc_hd__decap_8
XFILLER_0_73_268 VGND VGND VPWR VPWR sky130_fd_sc_hd__fill_1
XFILLER_0_6_513 VPWR VGND VPWR VGND sky130_ef_sc_hd__decap_12
X_3784_ _0376_ _0377_ VGND VGND VPWR VPWR _0378_ sky130_fd_sc_hd__nor2_1
XFILLER_0_81_6 VPWR VGND VPWR VGND sky130_ef_sc_hd__decap_12
X_5523_ _2083_ _2084_ VGND VGND VPWR VPWR _2085_ sky130_fd_sc_hd__and2_1
X_5454_ _2014_ _2015_ _2016_ VGND VGND VPWR VPWR _2017_ sky130_fd_sc_hd__and3_1
X_4405_ _0571_ _0978_ _0979_ _0980_ _0981_ VGND VGND VPWR VPWR _0119_ sky130_fd_sc_hd__o311a_1
XFILLER_0_41_198 VGND VGND VPWR VPWR sky130_fd_sc_hd__decap_4
X_5385_ _1859_ _1861_ _1863_ VGND VGND VPWR VPWR _1949_ sky130_fd_sc_hd__o21ba_1
XFILLER_0_1_273 VGND VGND VPWR VPWR sky130_fd_sc_hd__decap_6
X_4336_ _0911_ _0913_ VGND VGND VPWR VPWR _0914_ sky130_fd_sc_hd__and2_1
X_4267_ _0843_ _0844_ _0777_ _0779_ VGND VGND VPWR VPWR _0846_ sky130_fd_sc_hd__o211ai_2
X_6006_ _2525_ VGND VGND VPWR VPWR _0176_ sky130_fd_sc_hd__clkbuf_1
X_3218_ _2694_ _2707_ VGND VGND VPWR VPWR _2708_ sky130_fd_sc_hd__and2_1
X_4198_ _0775_ _0776_ _0739_ VGND VGND VPWR VPWR _0778_ sky130_fd_sc_hd__a21bo_1
X_3149_ u_interface.u_compute_core.relu_data\[24\] VGND VGND VPWR VPWR _2660_ sky130_fd_sc_hd__buf_2
XFILLER_0_37_405 VPWR VGND VPWR VGND sky130_ef_sc_hd__decap_12
XFILLER_0_92_533 VPWR VGND VPWR VGND sky130_ef_sc_hd__decap_12
XFILLER_0_37_449 VGND VGND VPWR VPWR sky130_fd_sc_hd__fill_1
XFILLER_0_49_298 VPWR VGND VPWR VGND sky130_ef_sc_hd__decap_12
XFILLER_0_64_257 VGND VGND VPWR VPWR sky130_fd_sc_hd__decap_6
XFILLER_0_17_162 VGND VGND VPWR VPWR sky130_fd_sc_hd__fill_2
XFILLER_0_45_471 VGND VGND VPWR VPWR sky130_fd_sc_hd__fill_1
XFILLER_0_52_419 VGND VGND VPWR VPWR sky130_fd_sc_hd__fill_1
XFILLER_0_17_195 VGND VGND VPWR VPWR sky130_fd_sc_hd__fill_2
XFILLER_0_32_132 VGND VGND VPWR VPWR sky130_fd_sc_hd__decap_3
XFILLER_0_60_430 VPWR VGND VPWR VGND sky130_ef_sc_hd__decap_12
XFILLER_0_1_3 VPWR VGND VPWR VGND sky130_ef_sc_hd__decap_12
XTAP_TAPCELL_ROW_76_926 VGND VPWR sky130_fd_sc_hd__tapvpwrvgnd_1
XTAP_TAPCELL_ROW_5_250 VGND VPWR sky130_fd_sc_hd__tapvpwrvgnd_1
XFILLER_0_87_316 VPWR VGND VPWR VGND sky130_ef_sc_hd__decap_12
XFILLER_0_68_530 VGND VGND VPWR VPWR sky130_fd_sc_hd__fill_2
XFILLER_0_62_29 VGND VGND VPWR VPWR sky130_fd_sc_hd__decap_6
XFILLER_0_11_44 VPWR VGND VPWR VGND sky130_ef_sc_hd__decap_12
XFILLER_0_3_505 VPWR VGND VPWR VGND sky130_ef_sc_hd__decap_12
XFILLER_0_36_493 VGND VGND VPWR VPWR sky130_fd_sc_hd__decap_4
XFILLER_0_87_15 VPWR VGND VPWR VGND sky130_ef_sc_hd__decap_12
XFILLER_0_51_474 VGND VGND VPWR VPWR sky130_fd_sc_hd__decap_4
XFILLER_0_11_349 VPWR VGND VPWR VGND sky130_ef_sc_hd__decap_12
X_5170_ _2644_ _0559_ _1649_ _1648_ VGND VGND VPWR VPWR _1736_ sky130_fd_sc_hd__a31oi_2
X_4121_ _0656_ VGND VGND VPWR VPWR _0702_ sky130_fd_sc_hd__buf_4
X_4052_ u_interface.u_compute_core.relu_data\[0\] _0634_ VGND VGND VPWR VPWR _0635_
+ sky130_fd_sc_hd__nand2_2
Xinput4 s_tdata[10] VGND VGND VPWR VPWR net4 sky130_fd_sc_hd__buf_1
XTAP_TAPCELL_ROW_47_650 VGND VPWR sky130_fd_sc_hd__tapvpwrvgnd_1
X_4954_ net123 _0819_ _0633_ _2631_ VGND VGND VPWR VPWR _1523_ sky130_fd_sc_hd__a22oi_2
XFILLER_0_74_533 VPWR VGND VPWR VGND sky130_ef_sc_hd__decap_12
X_3905_ net3 VGND VGND VPWR VPWR _0492_ sky130_fd_sc_hd__buf_6
X_4885_ _1452_ _1453_ _1446_ VGND VGND VPWR VPWR _1455_ sky130_fd_sc_hd__a21o_1
X_3836_ _0300_ _0217_ VGND VGND VPWR VPWR _0428_ sky130_fd_sc_hd__nor2_1
XFILLER_0_61_205 VGND VGND VPWR VPWR sky130_fd_sc_hd__decap_3
XFILLER_0_6_365 VGND VGND VPWR VPWR sky130_fd_sc_hd__fill_1
X_3767_ _2961_ _0217_ VGND VGND VPWR VPWR _0361_ sky130_fd_sc_hd__nor2_1
X_5506_ _1984_ _2064_ _2067_ VGND VGND VPWR VPWR _2068_ sky130_fd_sc_hd__o21ai_2
X_3698_ _0292_ _0293_ VGND VGND VPWR VPWR _0294_ sky130_fd_sc_hd__nor2_1
X_5437_ _1447_ _1597_ VGND VGND VPWR VPWR _2000_ sky130_fd_sc_hd__nand2_1
X_5368_ _1926_ _1927_ _1930_ VGND VGND VPWR VPWR _1932_ sky130_fd_sc_hd__o21ai_1
X_5299_ _1712_ _1780_ _1863_ VGND VGND VPWR VPWR _1864_ sky130_fd_sc_hd__o21a_1
X_4319_ _0856_ _0896_ VGND VGND VPWR VPWR _0897_ sky130_fd_sc_hd__or2_1
XTAP_TAPCELL_ROW_2_220 VGND VPWR sky130_fd_sc_hd__tapvpwrvgnd_1
XTAP_TAPCELL_ROW_81_973 VGND VPWR sky130_fd_sc_hd__tapvpwrvgnd_1
XFILLER_0_37_202 VGND VGND VPWR VPWR sky130_fd_sc_hd__decap_8
XFILLER_0_9_192 VGND VGND VPWR VPWR sky130_fd_sc_hd__fill_1
XFILLER_0_37_279 VGND VGND VPWR VPWR sky130_fd_sc_hd__fill_1
XFILLER_0_33_474 VGND VGND VPWR VPWR sky130_fd_sc_hd__decap_4
XFILLER_0_33_485 VGND VGND VPWR VPWR sky130_fd_sc_hd__fill_1
XFILLER_0_20_157 VGND VGND VPWR VPWR sky130_fd_sc_hd__fill_1
XTAP_TAPCELL_ROW_92_1070 VGND VPWR sky130_fd_sc_hd__tapvpwrvgnd_1
XTAP_TAPCELL_ROW_92_1081 VGND VPWR sky130_fd_sc_hd__tapvpwrvgnd_1
XTAP_TAPCELL_ROW_44_620 VGND VPWR sky130_fd_sc_hd__tapvpwrvgnd_1
XTAP_TAPCELL_ROW_16_355 VGND VPWR sky130_fd_sc_hd__tapvpwrvgnd_1
XFILLER_0_56_533 VPWR VGND VPWR VGND sky130_ef_sc_hd__decap_12
XFILLER_0_22_32 VPWR VGND VPWR VGND sky130_ef_sc_hd__decap_12
XFILLER_0_83_363 VGND VGND VPWR VPWR sky130_fd_sc_hd__fill_1
X_4670_ _1242_ _1167_ VGND VGND VPWR VPWR _1243_ sky130_fd_sc_hd__xor2_1
XFILLER_0_71_503 VGND VGND VPWR VPWR sky130_fd_sc_hd__fill_1
XFILLER_0_16_419 VGND VGND VPWR VPWR sky130_fd_sc_hd__fill_1
X_3621_ _0216_ _0218_ VGND VGND VPWR VPWR _0219_ sky130_fd_sc_hd__and2_1
X_3552_ _2969_ _2973_ _2971_ VGND VGND VPWR VPWR _2991_ sky130_fd_sc_hd__o21ai_1
XFILLER_0_3_335 VGND VGND VPWR VPWR sky130_fd_sc_hd__fill_1
XFILLER_0_11_113 VGND VGND VPWR VPWR sky130_fd_sc_hd__fill_2
XFILLER_0_51_260 VPWR VGND VPWR VGND sky130_ef_sc_hd__decap_12
XFILLER_0_11_124 VPWR VGND VPWR VGND sky130_ef_sc_hd__decap_12
X_6271_ clknet_leaf_15_clk _0184_ VGND VGND VPWR VPWR net31 sky130_fd_sc_hd__dfxtp_1
X_3483_ net163 _2805_ _2926_ _2927_ VGND VGND VPWR VPWR _0090_ sky130_fd_sc_hd__a22o_1
X_5222_ _1786_ VGND VGND VPWR VPWR _1787_ sky130_fd_sc_hd__inv_2
X_5153_ _1643_ _1665_ VGND VGND VPWR VPWR _1719_ sky130_fd_sc_hd__nor2_1
X_4104_ _0641_ _0643_ _0685_ VGND VGND VPWR VPWR _0686_ sky130_fd_sc_hd__o21a_1
X_5084_ _2644_ _0558_ VGND VGND VPWR VPWR _1651_ sky130_fd_sc_hd__nand2_1
X_4035_ _0615_ _0616_ _0614_ VGND VGND VPWR VPWR _0618_ sky130_fd_sc_hd__o21ai_1
XFILLER_0_2_53 VGND VGND VPWR VPWR sky130_fd_sc_hd__decap_8
XFILLER_0_2_75 VGND VGND VPWR VPWR sky130_fd_sc_hd__decap_4
X_5986_ _2320_ _2582_ VGND VGND VPWR VPWR _0170_ sky130_fd_sc_hd__nor2_1
X_4937_ _1502_ _1505_ VGND VGND VPWR VPWR _1506_ sky130_fd_sc_hd__xnor2_1
XFILLER_0_47_544 VGND VGND VPWR VPWR sky130_fd_sc_hd__decap_3
XFILLER_0_59_393 VGND VGND VPWR VPWR sky130_fd_sc_hd__fill_1
X_4868_ _1306_ _1359_ _1360_ _1363_ VGND VGND VPWR VPWR _1438_ sky130_fd_sc_hd__o22a_1
XFILLER_0_19_279 VGND VGND VPWR VPWR sky130_fd_sc_hd__fill_1
X_3819_ _0409_ _0410_ VGND VGND VPWR VPWR _0412_ sky130_fd_sc_hd__nand2_1
XTAP_TAPCELL_ROW_50_678 VGND VPWR sky130_fd_sc_hd__tapvpwrvgnd_1
X_4799_ _2625_ _2622_ _0702_ VGND VGND VPWR VPWR _1370_ sky130_fd_sc_hd__o21ai_1
XFILLER_0_6_195 VGND VGND VPWR VPWR sky130_fd_sc_hd__fill_1
XFILLER_0_42_282 VGND VGND VPWR VPWR sky130_fd_sc_hd__fill_1
XFILLER_0_88_91 VGND VGND VPWR VPWR sky130_fd_sc_hd__fill_1
XFILLER_0_30_477 VGND VGND VPWR VPWR sky130_fd_sc_hd__decap_6
XFILLER_0_69_113 VGND VGND VPWR VPWR sky130_fd_sc_hd__decap_8
XPHY_EDGE_ROW_6_Left_99 VGND VGND VPWR VPWR sky130_fd_sc_hd__decap_3
XFILLER_0_84_127 VGND VGND VPWR VPWR sky130_fd_sc_hd__decap_3
XFILLER_0_38_533 VPWR VGND VPWR VGND sky130_ef_sc_hd__decap_12
XTAP_TAPCELL_ROW_13_325 VGND VPWR sky130_fd_sc_hd__tapvpwrvgnd_1
XFILLER_0_53_503 VGND VGND VPWR VPWR sky130_fd_sc_hd__fill_1
XFILLER_0_92_193 VGND VGND VPWR VPWR sky130_fd_sc_hd__decap_3
XFILLER_0_21_488 VGND VGND VPWR VPWR sky130_fd_sc_hd__decap_6
XFILLER_0_84_27 VGND VGND VPWR VPWR sky130_fd_sc_hd__fill_1
XFILLER_0_84_49 VGND VGND VPWR VPWR sky130_fd_sc_hd__fill_1
XFILLER_0_88_477 VPWR VGND VPWR VGND sky130_ef_sc_hd__decap_12
XFILLER_0_75_105 VGND VGND VPWR VPWR sky130_fd_sc_hd__fill_2
X_5840_ u_interface.core_attn_out\[12\] _2301_ VGND VGND VPWR VPWR _2386_ sky130_fd_sc_hd__or2_1
XFILLER_0_75_149 VGND VGND VPWR VPWR sky130_fd_sc_hd__fill_1
XFILLER_0_8_416 VGND VGND VPWR VPWR sky130_fd_sc_hd__decap_4
X_5771_ u_interface.core_attn_out\[3\] _2301_ VGND VGND VPWR VPWR _2326_ sky130_fd_sc_hd__or2_1
X_4722_ _1291_ _1292_ _1293_ VGND VGND VPWR VPWR _1294_ sky130_fd_sc_hd__or3_1
XFILLER_0_44_503 VGND VGND VPWR VPWR sky130_fd_sc_hd__decap_8
XFILLER_0_16_238 VGND VGND VPWR VPWR sky130_fd_sc_hd__decap_6
X_4653_ _1224_ _1225_ VGND VGND VPWR VPWR _1226_ sky130_fd_sc_hd__and2b_1
X_4584_ _1156_ _1157_ VGND VGND VPWR VPWR _1158_ sky130_fd_sc_hd__and2b_1
XFILLER_0_71_388 VGND VGND VPWR VPWR sky130_fd_sc_hd__decap_4
X_3604_ _3003_ _3006_ _3040_ _3041_ VGND VGND VPWR VPWR _3042_ sky130_fd_sc_hd__o211ai_2
X_3535_ _2968_ _2974_ VGND VGND VPWR VPWR _2975_ sky130_fd_sc_hd__xnor2_1
X_6254_ clknet_leaf_14_clk _0167_ VGND VGND VPWR VPWR u_interface.core_attn_out\[29\]
+ sky130_fd_sc_hd__dfxtp_1
XFILLER_0_12_477 VGND VGND VPWR VPWR sky130_fd_sc_hd__fill_1
XFILLER_0_12_466 VGND VGND VPWR VPWR sky130_fd_sc_hd__decap_8
X_3466_ _2834_ u_interface.u_compute_core.mac_accum\[29\] VGND VGND VPWR VPWR _2913_
+ sky130_fd_sc_hd__or2_1
X_5205_ _1715_ _1769_ _1770_ VGND VGND VPWR VPWR _1771_ sky130_fd_sc_hd__nor3_2
X_6185_ clknet_leaf_20_clk _0098_ VGND VGND VPWR VPWR u_interface.u_compute_core.u_mac.product_reg\[7\]
+ sky130_fd_sc_hd__dfxtp_1
X_3397_ _2781_ _2853_ _2854_ _2746_ net166 VGND VGND VPWR VPWR _0077_ sky130_fd_sc_hd__a32o_1
XFILLER_0_42_3 VGND VGND VPWR VPWR sky130_fd_sc_hd__decap_8
X_5136_ _1630_ _1633_ _1702_ VGND VGND VPWR VPWR _1703_ sky130_fd_sc_hd__o21a_1
X_5067_ _0521_ _1634_ VGND VGND VPWR VPWR _1635_ sky130_fd_sc_hd__nand2_1
XFILLER_0_79_433 VGND VGND VPWR VPWR sky130_fd_sc_hd__fill_2
X_4018_ _0600_ _0601_ VGND VGND VPWR VPWR _0602_ sky130_fd_sc_hd__and2_1
XTAP_TAPCELL_ROW_55_726 VGND VPWR sky130_fd_sc_hd__tapvpwrvgnd_1
XFILLER_0_66_138 VGND VGND VPWR VPWR sky130_fd_sc_hd__fill_2
X_5969_ u_interface.core_attn_out\[29\] u_interface.u_compute_core.u_av.product_reg\[31\]
+ VGND VGND VPWR VPWR _2498_ sky130_fd_sc_hd__nand2_1
XFILLER_0_81_119 VGND VGND VPWR VPWR sky130_fd_sc_hd__fill_1
XFILLER_0_35_503 VGND VGND VPWR VPWR sky130_fd_sc_hd__fill_1
XFILLER_0_35_525 VPWR VGND VPWR VGND sky130_ef_sc_hd__decap_12
XFILLER_0_47_385 VGND VGND VPWR VPWR sky130_fd_sc_hd__decap_6
XFILLER_0_62_355 VGND VGND VPWR VPWR sky130_fd_sc_hd__decap_8
XFILLER_0_50_528 VGND VGND VPWR VPWR sky130_fd_sc_hd__decap_4
XFILLER_0_30_241 VGND VGND VPWR VPWR sky130_fd_sc_hd__decap_8
XTAP_TAPCELL_ROW_26_450 VGND VPWR sky130_fd_sc_hd__tapvpwrvgnd_1
XFILLER_0_38_352 VGND VGND VPWR VPWR sky130_fd_sc_hd__fill_1
XFILLER_0_65_193 VPWR VGND VPWR VGND sky130_ef_sc_hd__decap_12
XFILLER_0_38_396 VGND VGND VPWR VPWR sky130_fd_sc_hd__decap_8
XFILLER_0_79_49 VGND VGND VPWR VPWR sky130_fd_sc_hd__fill_1
XFILLER_0_13_208 VGND VGND VPWR VPWR sky130_fd_sc_hd__decap_4
Xhold109 u_interface.core_attn_out\[2\] VGND VGND VPWR VPWR net174 sky130_fd_sc_hd__dlygate4sd3_1
XFILLER_0_0_113 VGND VGND VPWR VPWR sky130_fd_sc_hd__fill_2
XFILLER_0_21_252 VGND VGND VPWR VPWR sky130_fd_sc_hd__fill_1
X_3320_ u_interface.u_compute_core.u_mac.product_reg\[8\] u_interface.u_compute_core.mac_accum\[8\]
+ VGND VGND VPWR VPWR _2788_ sky130_fd_sc_hd__nand2_1
XFILLER_0_0_146 VGND VGND VPWR VPWR sky130_fd_sc_hd__decap_4
X_3251_ _2730_ VGND VGND VPWR VPWR _0055_ sky130_fd_sc_hd__clkbuf_1
X_3182_ u_interface.u_compute_core.scaled_data\[5\] u_interface.u_compute_core.mac_accum\[8\]
+ _2669_ VGND VGND VPWR VPWR _2683_ sky130_fd_sc_hd__mux2_1
XFILLER_0_44_52 VGND VGND VPWR VPWR sky130_fd_sc_hd__decap_4
XFILLER_0_88_285 VGND VGND VPWR VPWR sky130_fd_sc_hd__decap_4
XFILLER_0_76_425 VGND VGND VPWR VPWR sky130_fd_sc_hd__fill_1
XFILLER_0_76_414 VGND VGND VPWR VPWR sky130_fd_sc_hd__decap_6
XFILLER_0_44_85 VGND VGND VPWR VPWR sky130_fd_sc_hd__fill_1
X_5823_ _2361_ _2370_ VGND VGND VPWR VPWR _2371_ sky130_fd_sc_hd__or2_1
XFILLER_0_8_202 VPWR VGND VPWR VGND sky130_ef_sc_hd__decap_12
XFILLER_0_29_330 VGND VGND VPWR VPWR sky130_fd_sc_hd__decap_3
XFILLER_0_91_417 VPWR VGND VPWR VGND sky130_ef_sc_hd__decap_12
X_5754_ net203 _2304_ _0981_ _2310_ VGND VGND VPWR VPWR _0139_ sky130_fd_sc_hd__o211a_1
XFILLER_0_44_333 VGND VGND VPWR VPWR sky130_fd_sc_hd__fill_1
XFILLER_0_56_182 VGND VGND VPWR VPWR sky130_fd_sc_hd__decap_6
XFILLER_0_60_62 VGND VGND VPWR VPWR sky130_fd_sc_hd__decap_3
XTAP_TAPCELL_ROW_60_773 VGND VPWR sky130_fd_sc_hd__tapvpwrvgnd_1
X_4705_ _1263_ _1275_ _1276_ VGND VGND VPWR VPWR _1277_ sky130_fd_sc_hd__nand3_4
X_5685_ _2115_ _2118_ _2186_ _2185_ VGND VGND VPWR VPWR _2245_ sky130_fd_sc_hd__a31o_1
X_4636_ u_interface.u_compute_core.relu_data\[17\] VGND VGND VPWR VPWR _1209_ sky130_fd_sc_hd__buf_2
XFILLER_0_44_399 VPWR VGND VPWR VGND sky130_ef_sc_hd__decap_12
X_4567_ _1139_ _1140_ _0656_ VGND VGND VPWR VPWR _1141_ sky130_fd_sc_hd__and3b_1
X_4498_ _1071_ _1072_ VGND VGND VPWR VPWR _1073_ sky130_fd_sc_hd__nor2_1
X_3518_ _2955_ _2956_ _2944_ _2942_ VGND VGND VPWR VPWR _2959_ sky130_fd_sc_hd__a211o_1
X_6237_ clknet_leaf_15_clk _0150_ VGND VGND VPWR VPWR u_interface.core_attn_out\[12\]
+ sky130_fd_sc_hd__dfxtp_1
X_3449_ _2897_ _2898_ VGND VGND VPWR VPWR _2899_ sky130_fd_sc_hd__nand2_1
X_6168_ clknet_leaf_2_clk _0081_ VGND VGND VPWR VPWR u_interface.u_compute_core.mac_accum\[22\]
+ sky130_fd_sc_hd__dfxtp_1
X_5119_ _1615_ _1684_ _1685_ VGND VGND VPWR VPWR _1686_ sky130_fd_sc_hd__and3_1
X_6099_ clknet_leaf_6_clk _0012_ VGND VGND VPWR VPWR u_interface.u_compute_core.relu_data\[12\]
+ sky130_fd_sc_hd__dfxtp_2
XFILLER_0_79_252 VPWR VGND VPWR VGND sky130_ef_sc_hd__decap_12
XFILLER_0_67_447 VGND VGND VPWR VPWR sky130_fd_sc_hd__fill_1
XFILLER_0_82_417 VGND VGND VPWR VPWR sky130_fd_sc_hd__decap_3
XTAP_TAPCELL_ROW_23_420 VGND VPWR sky130_fd_sc_hd__tapvpwrvgnd_1
XFILLER_0_54_119 VGND VGND VPWR VPWR sky130_fd_sc_hd__decap_8
XFILLER_0_35_333 VGND VGND VPWR VPWR sky130_fd_sc_hd__decap_3
XFILLER_0_90_472 VGND VGND VPWR VPWR sky130_fd_sc_hd__decap_4
XFILLER_0_23_517 VPWR VGND VPWR VGND sky130_ef_sc_hd__decap_12
XFILLER_0_50_303 VGND VGND VPWR VPWR sky130_fd_sc_hd__decap_4
XTAP_TAPCELL_ROW_89_1042 VGND VPWR sky130_fd_sc_hd__tapvpwrvgnd_1
XTAP_TAPCELL_ROW_74_898 VGND VPWR sky130_fd_sc_hd__tapvpwrvgnd_1
XFILLER_0_14_22 VGND VGND VPWR VPWR sky130_fd_sc_hd__decap_6
XFILLER_0_85_255 VGND VGND VPWR VPWR sky130_fd_sc_hd__decap_3
XFILLER_0_66_480 VGND VGND VPWR VPWR sky130_fd_sc_hd__fill_2
XFILLER_0_26_322 VGND VGND VPWR VPWR sky130_fd_sc_hd__fill_2
XFILLER_0_5_249 VPWR VGND VPWR VGND sky130_ef_sc_hd__decap_12
X_5470_ _0571_ _2031_ _2032_ _1337_ VGND VGND VPWR VPWR _0133_ sky130_fd_sc_hd__o211a_1
X_4421_ _0994_ _0995_ _0993_ VGND VGND VPWR VPWR _0997_ sky130_fd_sc_hd__o21ai_1
XFILLER_0_53_185 VGND VGND VPWR VPWR sky130_fd_sc_hd__fill_1
X_4352_ _2625_ _0503_ _0498_ _2622_ VGND VGND VPWR VPWR _0929_ sky130_fd_sc_hd__a22oi_2
X_4283_ _0857_ _0860_ VGND VGND VPWR VPWR _0861_ sky130_fd_sc_hd__xnor2_2
X_3303_ net195 _2756_ _2772_ _2773_ VGND VGND VPWR VPWR _0064_ sky130_fd_sc_hd__a22o_1
X_6022_ _2516_ _2535_ VGND VGND VPWR VPWR _2536_ sky130_fd_sc_hd__and2_1
X_3234_ u_interface.u_compute_core.scaled_data\[21\] u_interface.u_compute_core.mac_accum\[24\]
+ _2713_ VGND VGND VPWR VPWR _2719_ sky130_fd_sc_hd__mux2_1
X_3165_ _2671_ VGND VGND VPWR VPWR _0028_ sky130_fd_sc_hd__clkbuf_1
XFILLER_0_55_51 VGND VGND VPWR VPWR sky130_fd_sc_hd__fill_1
X_3096_ u_interface.u_compute_core.scaled_data\[10\] _2618_ _2620_ _2613_ VGND VGND
+ VPWR VPWR _2621_ sky130_fd_sc_hd__o2bb2a_1
XTAP_TAPCELL_ROW_65_821 VGND VPWR sky130_fd_sc_hd__tapvpwrvgnd_1
XFILLER_0_64_417 VGND VGND VPWR VPWR sky130_fd_sc_hd__decap_3
XFILLER_0_91_225 VGND VGND VPWR VPWR sky130_fd_sc_hd__decap_4
X_5806_ _2354_ _2355_ VGND VGND VPWR VPWR _2356_ sky130_fd_sc_hd__and2_1
XFILLER_0_17_300 VGND VGND VPWR VPWR sky130_fd_sc_hd__fill_2
X_3998_ _0548_ _0579_ _0581_ VGND VGND VPWR VPWR _0582_ sky130_fd_sc_hd__nor3_2
XFILLER_0_72_450 VGND VGND VPWR VPWR sky130_fd_sc_hd__decap_3
XFILLER_0_44_141 VGND VGND VPWR VPWR sky130_fd_sc_hd__decap_3
X_5737_ _2289_ _2295_ VGND VGND VPWR VPWR _2296_ sky130_fd_sc_hd__xnor2_1
XFILLER_0_32_314 VPWR VGND VPWR VGND sky130_ef_sc_hd__decap_12
XFILLER_0_32_358 VGND VGND VPWR VPWR sky130_fd_sc_hd__fill_1
X_5668_ _2225_ _2227_ VGND VGND VPWR VPWR _2228_ sky130_fd_sc_hd__xor2_1
X_4619_ _0946_ _0948_ _1190_ VGND VGND VPWR VPWR _1192_ sky130_fd_sc_hd__a21o_1
X_5599_ _2083_ _2156_ VGND VGND VPWR VPWR _2160_ sky130_fd_sc_hd__nand2_1
XTAP_TAPCELL_ROW_0_192 VGND VPWR sky130_fd_sc_hd__tapvpwrvgnd_1
XFILLER_0_63_483 VPWR VGND VPWR VGND sky130_ef_sc_hd__decap_12
Xclkload18 clknet_leaf_17_clk VGND VGND VPWR VPWR clkload18/Y sky130_fd_sc_hd__clkinv_4
XFILLER_0_31_391 VGND VGND VPWR VPWR sky130_fd_sc_hd__fill_1
XTAP_TAPCELL_ROW_79_946 VGND VPWR sky130_fd_sc_hd__tapvpwrvgnd_1
XFILLER_0_92_27 VGND VGND VPWR VPWR sky130_fd_sc_hd__fill_1
X_4970_ _1517_ _1537_ _1538_ VGND VGND VPWR VPWR _1539_ sky130_fd_sc_hd__or3_4
XFILLER_0_25_65 VPWR VGND VPWR VGND sky130_ef_sc_hd__decap_12
XTAP_TAPCELL_ROW_34_526 VGND VPWR sky130_fd_sc_hd__tapvpwrvgnd_1
X_3921_ _0501_ _0507_ VGND VGND VPWR VPWR _0508_ sky130_fd_sc_hd__xor2_1
X_3852_ _0412_ _0443_ VGND VGND VPWR VPWR _0444_ sky130_fd_sc_hd__and2_1
XFILLER_0_6_525 VGND VGND VPWR VPWR sky130_fd_sc_hd__decap_6
XFILLER_0_26_130 VGND VGND VPWR VPWR sky130_fd_sc_hd__decap_4
X_5522_ _1977_ _1979_ _2082_ VGND VGND VPWR VPWR _2084_ sky130_fd_sc_hd__o21ai_1
X_3783_ _0374_ _0375_ VGND VGND VPWR VPWR _0377_ sky130_fd_sc_hd__and2_1
XFILLER_0_26_141 VPWR VGND VPWR VGND sky130_ef_sc_hd__decap_12
X_5453_ _1926_ _1931_ VGND VGND VPWR VPWR _2016_ sky130_fd_sc_hd__or2b_1
X_4404_ _2580_ VGND VGND VPWR VPWR _0981_ sky130_fd_sc_hd__clkbuf_4
X_5384_ _1780_ _1862_ VGND VGND VPWR VPWR _1948_ sky130_fd_sc_hd__or2_1
X_4335_ _0908_ net96 _0912_ _0910_ VGND VGND VPWR VPWR _0913_ sky130_fd_sc_hd__a22o_1
X_4266_ _0777_ _0779_ _0844_ _0843_ VGND VGND VPWR VPWR _0845_ sky130_fd_sc_hd__a211o_1
X_6005_ _2516_ _2524_ VGND VGND VPWR VPWR _2525_ sky130_fd_sc_hd__and2_1
X_3217_ u_interface.u_compute_core.scaled_data\[16\] u_interface.u_compute_core.mac_accum\[19\]
+ _2691_ VGND VGND VPWR VPWR _2707_ sky130_fd_sc_hd__mux2_1
X_4197_ _0739_ _0775_ _0776_ VGND VGND VPWR VPWR _0777_ sky130_fd_sc_hd__nand3b_2
X_3148_ _2643_ _2659_ VGND VGND VPWR VPWR _0023_ sky130_fd_sc_hd__nor2_1
XFILLER_0_89_391 VGND VGND VPWR VPWR sky130_fd_sc_hd__fill_1
XFILLER_0_82_82 VGND VGND VPWR VPWR sky130_fd_sc_hd__fill_2
XFILLER_0_82_60 VGND VGND VPWR VPWR sky130_fd_sc_hd__decap_8
X_3079_ u_interface.u_compute_core.relu_data\[7\] VGND VGND VPWR VPWR _2607_ sky130_fd_sc_hd__inv_2
XFILLER_0_92_501 VGND VGND VPWR VPWR sky130_fd_sc_hd__decap_3
XPHY_EDGE_ROW_59_Left_152 VGND VGND VPWR VPWR sky130_fd_sc_hd__decap_3
XFILLER_0_64_214 VGND VGND VPWR VPWR sky130_fd_sc_hd__decap_6
XFILLER_0_37_417 VPWR VGND VPWR VGND sky130_ef_sc_hd__decap_12
XFILLER_0_92_545 VGND VGND VPWR VPWR sky130_fd_sc_hd__fill_2
XFILLER_0_45_494 VGND VGND VPWR VPWR sky130_fd_sc_hd__decap_8
XFILLER_0_60_442 VGND VGND VPWR VPWR sky130_fd_sc_hd__decap_8
XFILLER_0_60_464 VGND VGND VPWR VPWR sky130_fd_sc_hd__fill_1
XFILLER_0_60_475 VGND VGND VPWR VPWR sky130_fd_sc_hd__fill_1
XPHY_EDGE_ROW_68_Left_161 VGND VGND VPWR VPWR sky130_fd_sc_hd__decap_3
XFILLER_0_20_328 VPWR VGND VPWR VGND sky130_ef_sc_hd__decap_12
XFILLER_0_32_188 VGND VGND VPWR VPWR sky130_fd_sc_hd__decap_3
XTAP_TAPCELL_ROW_5_251 VGND VPWR sky130_fd_sc_hd__tapvpwrvgnd_1
XTAP_TAPCELL_ROW_86_1012 VGND VPWR sky130_fd_sc_hd__tapvpwrvgnd_1
XFILLER_0_87_328 VGND VGND VPWR VPWR sky130_fd_sc_hd__decap_3
XPHY_EDGE_ROW_77_Left_170 VGND VGND VPWR VPWR sky130_fd_sc_hd__decap_3
XTAP_TAPCELL_ROW_84_993 VGND VPWR sky130_fd_sc_hd__tapvpwrvgnd_1
XFILLER_0_70_217 VGND VGND VPWR VPWR sky130_fd_sc_hd__decap_3
XFILLER_0_3_517 VPWR VGND VPWR VGND sky130_ef_sc_hd__decap_12
XFILLER_0_23_111 VGND VGND VPWR VPWR sky130_fd_sc_hd__fill_1
XFILLER_0_23_144 VGND VGND VPWR VPWR sky130_fd_sc_hd__fill_1
XFILLER_0_51_453 VGND VGND VPWR VPWR sky130_fd_sc_hd__decap_8
XFILLER_0_87_27 VPWR VGND VPWR VGND sky130_ef_sc_hd__decap_12
XFILLER_0_23_177 VGND VGND VPWR VPWR sky130_fd_sc_hd__decap_8
X_4120_ _0665_ _0676_ _0700_ VGND VGND VPWR VPWR _0701_ sky130_fd_sc_hd__a21o_1
X_4051_ _0633_ VGND VGND VPWR VPWR _0634_ sky130_fd_sc_hd__buf_2
Xinput5 s_tdata[11] VGND VGND VPWR VPWR net5 sky130_fd_sc_hd__clkbuf_2
XFILLER_0_59_531 VPWR VGND VPWR VGND sky130_ef_sc_hd__decap_12
X_4953_ u_interface.u_compute_core.relu_data\[16\] _0535_ _1434_ _1433_ VGND VGND
+ VPWR VPWR _1522_ sky130_fd_sc_hd__a31o_1
XFILLER_0_52_41 VGND VGND VPWR VPWR sky130_fd_sc_hd__decap_8
XFILLER_0_74_523 VGND VGND VPWR VPWR sky130_fd_sc_hd__decap_8
XFILLER_0_74_501 VGND VGND VPWR VPWR sky130_fd_sc_hd__fill_2
X_3904_ _0490_ VGND VGND VPWR VPWR _0491_ sky130_fd_sc_hd__buf_2
X_4884_ _1446_ _1452_ _1453_ VGND VGND VPWR VPWR _1454_ sky130_fd_sc_hd__nand3_1
XFILLER_0_74_545 VGND VGND VPWR VPWR sky130_fd_sc_hd__fill_2
XFILLER_0_52_85 VGND VGND VPWR VPWR sky130_fd_sc_hd__fill_2
XFILLER_0_6_333 VGND VGND VPWR VPWR sky130_fd_sc_hd__decap_3
X_3835_ _3014_ _0265_ VGND VGND VPWR VPWR _0427_ sky130_fd_sc_hd__nand2_1
X_3766_ _2890_ _0359_ _0360_ _2745_ net143 VGND VGND VPWR VPWR _0101_ sky130_fd_sc_hd__a32o_1
XFILLER_0_54_280 VGND VGND VPWR VPWR sky130_fd_sc_hd__decap_8
X_5505_ _1806_ _2066_ VGND VGND VPWR VPWR _2067_ sky130_fd_sc_hd__xnor2_1
X_5436_ _2628_ _1596_ VGND VGND VPWR VPWR _1999_ sky130_fd_sc_hd__and2_1
XFILLER_0_72_3 VPWR VGND VPWR VGND sky130_ef_sc_hd__decap_12
XFILLER_0_14_188 VGND VGND VPWR VPWR sky130_fd_sc_hd__fill_2
XFILLER_0_14_166 VGND VGND VPWR VPWR sky130_fd_sc_hd__fill_1
X_3697_ _2949_ net8 _0291_ VGND VGND VPWR VPWR _0293_ sky130_fd_sc_hd__and3_1
XFILLER_0_42_475 VGND VGND VPWR VPWR sky130_fd_sc_hd__fill_1
X_5367_ _1926_ _1927_ _1930_ VGND VGND VPWR VPWR _1931_ sky130_fd_sc_hd__or3_1
X_5298_ _1777_ _1778_ _1776_ VGND VGND VPWR VPWR _1863_ sky130_fd_sc_hd__o21ai_1
X_4318_ _0894_ _0895_ VGND VGND VPWR VPWR _0896_ sky130_fd_sc_hd__nand2_1
X_4249_ _0745_ _0826_ _0827_ VGND VGND VPWR VPWR _0828_ sky130_fd_sc_hd__nand3_2
XTAP_TAPCELL_ROW_2_221 VGND VPWR sky130_fd_sc_hd__tapvpwrvgnd_1
XFILLER_0_84_309 VGND VGND VPWR VPWR sky130_fd_sc_hd__decap_6
XFILLER_0_77_372 VPWR VGND VPWR VGND sky130_ef_sc_hd__decap_12
XFILLER_0_65_512 VGND VGND VPWR VPWR sky130_fd_sc_hd__decap_6
XFILLER_0_37_225 VGND VGND VPWR VPWR sky130_fd_sc_hd__decap_4
XFILLER_0_9_160 VGND VGND VPWR VPWR sky130_fd_sc_hd__fill_1
XTAP_TAPCELL_ROW_92_1071 VGND VPWR sky130_fd_sc_hd__tapvpwrvgnd_1
XTAP_TAPCELL_ROW_92_1082 VGND VPWR sky130_fd_sc_hd__tapvpwrvgnd_1
XTAP_TAPCELL_ROW_44_621 VGND VPWR sky130_fd_sc_hd__tapvpwrvgnd_1
XTAP_TAPCELL_ROW_16_356 VGND VPWR sky130_fd_sc_hd__tapvpwrvgnd_1
XFILLER_0_7_119 VPWR VGND VPWR VGND sky130_ef_sc_hd__decap_12
XFILLER_0_56_545 VGND VGND VPWR VPWR sky130_fd_sc_hd__fill_2
XFILLER_0_22_44 VPWR VGND VPWR VGND sky130_ef_sc_hd__decap_12
XFILLER_0_28_269 VGND VGND VPWR VPWR sky130_fd_sc_hd__fill_1
X_3620_ _3013_ _0217_ _3012_ net10 VGND VGND VPWR VPWR _0218_ sky130_fd_sc_hd__or4b_1
X_3551_ _2988_ _2989_ VGND VGND VPWR VPWR _2990_ sky130_fd_sc_hd__nand2_1
XFILLER_0_24_475 VGND VGND VPWR VPWR sky130_fd_sc_hd__fill_1
XFILLER_0_51_272 VGND VGND VPWR VPWR sky130_fd_sc_hd__fill_2
XFILLER_0_11_136 VGND VGND VPWR VPWR sky130_fd_sc_hd__decap_8
X_6270_ clknet_leaf_16_clk _0183_ VGND VGND VPWR VPWR net30 sky130_fd_sc_hd__dfxtp_1
X_3482_ _2924_ _2925_ _2754_ VGND VGND VPWR VPWR _2927_ sky130_fd_sc_hd__a21oi_1
X_5221_ _1721_ _1745_ VGND VGND VPWR VPWR _1786_ sky130_fd_sc_hd__or2_1
XFILLER_0_11_169 VPWR VGND VPWR VGND sky130_ef_sc_hd__decap_12
X_5152_ _1689_ _1717_ VGND VGND VPWR VPWR _1718_ sky130_fd_sc_hd__xnor2_1
X_4103_ _0610_ _0640_ VGND VGND VPWR VPWR _0685_ sky130_fd_sc_hd__or2_1
X_5083_ _1648_ _1649_ VGND VGND VPWR VPWR _1650_ sky130_fd_sc_hd__and2b_1
X_4034_ _0614_ _0615_ _0616_ VGND VGND VPWR VPWR _0617_ sky130_fd_sc_hd__or3_1
XFILLER_0_63_73 VGND VGND VPWR VPWR sky130_fd_sc_hd__decap_8
X_5985_ _2511_ VGND VGND VPWR VPWR _0169_ sky130_fd_sc_hd__clkbuf_1
X_4936_ _1503_ _1504_ VGND VGND VPWR VPWR _1505_ sky130_fd_sc_hd__and2b_1
XFILLER_0_74_320 VGND VGND VPWR VPWR sky130_fd_sc_hd__fill_1
XFILLER_0_19_225 VGND VGND VPWR VPWR sky130_fd_sc_hd__decap_3
X_4867_ _1431_ _1436_ VGND VGND VPWR VPWR _1437_ sky130_fd_sc_hd__xnor2_1
X_3818_ _0409_ _0410_ VGND VGND VPWR VPWR _0411_ sky130_fd_sc_hd__or2_1
XFILLER_0_34_217 VPWR VGND VPWR VGND sky130_ef_sc_hd__decap_12
XTAP_TAPCELL_ROW_50_679 VGND VPWR sky130_fd_sc_hd__tapvpwrvgnd_1
X_4798_ _2625_ _2622_ _0633_ VGND VGND VPWR VPWR _1369_ sky130_fd_sc_hd__and3_1
X_3749_ _0342_ _0343_ VGND VGND VPWR VPWR _0344_ sky130_fd_sc_hd__nor2_1
XFILLER_0_30_434 VPWR VGND VPWR VGND sky130_ef_sc_hd__decap_12
X_5419_ _1890_ _1891_ VGND VGND VPWR VPWR _1982_ sky130_fd_sc_hd__and2b_1
XTAP_TAPCELL_ROW_58_746 VGND VPWR sky130_fd_sc_hd__tapvpwrvgnd_1
XFILLER_0_38_545 VGND VGND VPWR VPWR sky130_fd_sc_hd__fill_2
XTAP_TAPCELL_ROW_13_326 VGND VPWR sky130_fd_sc_hd__tapvpwrvgnd_1
XFILLER_0_18_291 VGND VGND VPWR VPWR sky130_fd_sc_hd__fill_1
XFILLER_0_21_401 VGND VGND VPWR VPWR sky130_fd_sc_hd__fill_2
XFILLER_0_68_29 VPWR VGND VPWR VGND sky130_ef_sc_hd__decap_12
XFILLER_0_17_22 VGND VGND VPWR VPWR sky130_fd_sc_hd__fill_2
XFILLER_0_48_309 VPWR VGND VPWR VGND sky130_ef_sc_hd__decap_12
XFILLER_0_88_489 VPWR VGND VPWR VGND sky130_ef_sc_hd__decap_12
XFILLER_0_33_43 VPWR VGND VPWR VGND sky130_ef_sc_hd__decap_12
X_5770_ _2323_ _2324_ VGND VGND VPWR VPWR _2325_ sky130_fd_sc_hd__xnor2_1
XFILLER_0_90_109 VPWR VGND VPWR VGND sky130_ef_sc_hd__decap_12
X_4721_ _2634_ _0488_ _0586_ net119 VGND VGND VPWR VPWR _1293_ sky130_fd_sc_hd__a22oi_2
XFILLER_0_71_301 VPWR VGND VPWR VGND sky130_ef_sc_hd__decap_12
X_4652_ _1223_ _1220_ _1146_ _1216_ VGND VGND VPWR VPWR _1225_ sky130_fd_sc_hd__a211o_1
XFILLER_0_71_334 VGND VGND VPWR VPWR sky130_fd_sc_hd__fill_2
X_3603_ _3011_ _2998_ _3039_ VGND VGND VPWR VPWR _3041_ sky130_fd_sc_hd__nand3_1
X_4583_ net124 net14 net19 net119 VGND VGND VPWR VPWR _1157_ sky130_fd_sc_hd__a22o_1
XFILLER_0_24_261 VGND VGND VPWR VPWR sky130_fd_sc_hd__decap_3
X_3534_ _2969_ _2973_ VGND VGND VPWR VPWR _2974_ sky130_fd_sc_hd__xor2_1
XFILLER_0_3_177 VGND VGND VPWR VPWR sky130_fd_sc_hd__decap_4
X_6253_ clknet_leaf_14_clk _0166_ VGND VGND VPWR VPWR u_interface.core_attn_out\[28\]
+ sky130_fd_sc_hd__dfxtp_1
X_3465_ _2890_ _2911_ _2912_ _2867_ net172 VGND VGND VPWR VPWR _0087_ sky130_fd_sc_hd__a32o_1
X_5204_ _1767_ _1768_ _1686_ net63 VGND VGND VPWR VPWR _1770_ sky130_fd_sc_hd__a211oi_2
X_6184_ clknet_leaf_20_clk _0097_ VGND VGND VPWR VPWR u_interface.u_compute_core.u_mac.product_reg\[6\]
+ sky130_fd_sc_hd__dfxtp_1
X_3396_ _2852_ _2848_ _2849_ VGND VGND VPWR VPWR _2854_ sky130_fd_sc_hd__nand3_1
XFILLER_0_35_3 VPWR VGND VPWR VGND sky130_ef_sc_hd__decap_12
X_5135_ _1628_ _1629_ VGND VGND VPWR VPWR _1702_ sky130_fd_sc_hd__or2_1
X_5066_ net68 _1633_ VGND VGND VPWR VPWR _1634_ sky130_fd_sc_hd__xnor2_1
X_4017_ _0584_ _0599_ VGND VGND VPWR VPWR _0601_ sky130_fd_sc_hd__nand2_1
XFILLER_0_66_106 VPWR VGND VPWR VGND sky130_ef_sc_hd__decap_12
X_5968_ u_interface.core_attn_out\[29\] u_interface.u_compute_core.u_av.product_reg\[31\]
+ VGND VGND VPWR VPWR _2497_ sky130_fd_sc_hd__or2_1
X_4919_ _1423_ _1410_ VGND VGND VPWR VPWR _1488_ sky130_fd_sc_hd__or2b_1
X_5899_ _2435_ _2436_ VGND VGND VPWR VPWR _2437_ sky130_fd_sc_hd__nand2_1
XFILLER_0_35_537 VGND VGND VPWR VPWR sky130_fd_sc_hd__decap_8
XFILLER_0_7_461 VPWR VGND VPWR VGND sky130_ef_sc_hd__decap_12
XFILLER_0_30_231 VGND VGND VPWR VPWR sky130_fd_sc_hd__fill_1
XFILLER_0_30_253 VPWR VGND VPWR VGND sky130_ef_sc_hd__decap_12
XFILLER_0_30_286 VPWR VGND VPWR VGND sky130_ef_sc_hd__decap_12
XTAP_TAPCELL_ROW_26_451 VGND VPWR sky130_fd_sc_hd__tapvpwrvgnd_1
XFILLER_0_57_139 VGND VGND VPWR VPWR sky130_fd_sc_hd__decap_3
XFILLER_0_65_161 VGND VGND VPWR VPWR sky130_fd_sc_hd__decap_6
XFILLER_0_53_334 VGND VGND VPWR VPWR sky130_fd_sc_hd__fill_2
XFILLER_0_53_378 VGND VGND VPWR VPWR sky130_fd_sc_hd__decap_6
XFILLER_0_80_197 VGND VGND VPWR VPWR sky130_fd_sc_hd__decap_8
XFILLER_0_21_231 VGND VGND VPWR VPWR sky130_fd_sc_hd__fill_1
XFILLER_0_0_169 VGND VGND VPWR VPWR sky130_fd_sc_hd__fill_2
XPHY_EDGE_ROW_13_Left_106 VGND VGND VPWR VPWR sky130_fd_sc_hd__decap_3
X_3250_ _2716_ _2729_ VGND VGND VPWR VPWR _2730_ sky130_fd_sc_hd__and2_1
X_3181_ _2682_ VGND VGND VPWR VPWR _0033_ sky130_fd_sc_hd__clkbuf_1
XFILLER_0_28_76 VGND VGND VPWR VPWR sky130_fd_sc_hd__fill_1
XFILLER_0_88_253 VGND VGND VPWR VPWR sky130_fd_sc_hd__fill_1
XFILLER_0_76_459 VGND VGND VPWR VPWR sky130_fd_sc_hd__decap_6
X_5822_ _2356_ _2357_ _2369_ VGND VGND VPWR VPWR _2370_ sky130_fd_sc_hd__a21oi_1
XPHY_EDGE_ROW_22_Left_115 VGND VGND VPWR VPWR sky130_fd_sc_hd__decap_3
XFILLER_0_48_139 VGND VGND VPWR VPWR sky130_fd_sc_hd__fill_1
X_5753_ _2306_ _2307_ _2309_ VGND VGND VPWR VPWR _2310_ sky130_fd_sc_hd__o21ai_1
XFILLER_0_91_429 VPWR VGND VPWR VGND sky130_ef_sc_hd__decap_12
X_4704_ _1274_ _1273_ _1239_ VGND VGND VPWR VPWR _1276_ sky130_fd_sc_hd__a21o_1
XFILLER_0_84_492 VPWR VGND VPWR VGND sky130_ef_sc_hd__decap_12
XTAP_TAPCELL_ROW_60_774 VGND VPWR sky130_fd_sc_hd__tapvpwrvgnd_1
XFILLER_0_71_131 VPWR VGND VPWR VGND sky130_ef_sc_hd__decap_12
X_5684_ _2242_ _2243_ VGND VGND VPWR VPWR _2244_ sky130_fd_sc_hd__xnor2_1
XFILLER_0_60_85 VGND VGND VPWR VPWR sky130_fd_sc_hd__decap_4
X_4635_ _1205_ _1206_ _1188_ VGND VGND VPWR VPWR _1208_ sky130_fd_sc_hd__a21o_1
X_4566_ u_interface.u_compute_core.relu_data\[9\] u_interface.u_compute_core.relu_data\[8\]
+ VGND VGND VPWR VPWR _1140_ sky130_fd_sc_hd__or2_1
XFILLER_0_8_64 VGND VGND VPWR VPWR sky130_fd_sc_hd__decap_8
XFILLER_0_4_475 VGND VGND VPWR VPWR sky130_fd_sc_hd__fill_1
XFILLER_0_12_253 VPWR VGND VPWR VGND sky130_ef_sc_hd__decap_12
X_3517_ _2957_ VGND VGND VPWR VPWR _2958_ sky130_fd_sc_hd__inv_2
XPHY_EDGE_ROW_31_Left_124 VGND VGND VPWR VPWR sky130_fd_sc_hd__decap_3
X_4497_ _1003_ _1070_ VGND VGND VPWR VPWR _1072_ sky130_fd_sc_hd__and2_1
X_6236_ clknet_leaf_15_clk _0149_ VGND VGND VPWR VPWR u_interface.core_attn_out\[11\]
+ sky130_fd_sc_hd__dfxtp_1
X_3448_ _2833_ u_interface.u_compute_core.mac_accum\[26\] VGND VGND VPWR VPWR _2898_
+ sky130_fd_sc_hd__nand2_1
X_3379_ u_interface.u_compute_core.u_mac.product_reg\[15\] u_interface.u_compute_core.mac_accum\[16\]
+ VGND VGND VPWR VPWR _2839_ sky130_fd_sc_hd__nand2_1
X_6167_ clknet_leaf_2_clk _0080_ VGND VGND VPWR VPWR u_interface.u_compute_core.mac_accum\[21\]
+ sky130_fd_sc_hd__dfxtp_1
X_5118_ _1682_ _1683_ _1666_ VGND VGND VPWR VPWR _1685_ sky130_fd_sc_hd__a21o_1
XTAP_TAPCELL_ROW_68_841 VGND VPWR sky130_fd_sc_hd__tapvpwrvgnd_1
X_6098_ clknet_leaf_6_clk _0011_ VGND VGND VPWR VPWR u_interface.u_compute_core.relu_data\[11\]
+ sky130_fd_sc_hd__dfxtp_2
X_5049_ _1539_ _1615_ _1616_ VGND VGND VPWR VPWR _1617_ sky130_fd_sc_hd__nor3_1
XFILLER_0_79_264 VGND VGND VPWR VPWR sky130_fd_sc_hd__decap_4
XPHY_EDGE_ROW_40_Left_133 VGND VGND VPWR VPWR sky130_fd_sc_hd__decap_3
XTAP_TAPCELL_ROW_23_421 VGND VPWR sky130_fd_sc_hd__tapvpwrvgnd_1
XFILLER_0_35_301 VGND VGND VPWR VPWR sky130_fd_sc_hd__fill_2
XFILLER_0_35_323 VGND VGND VPWR VPWR sky130_fd_sc_hd__fill_1
XFILLER_0_47_161 VGND VGND VPWR VPWR sky130_fd_sc_hd__decap_6
XFILLER_0_62_131 VGND VGND VPWR VPWR sky130_fd_sc_hd__decap_4
Xclone55 _1142_ VGND VGND VPWR VPWR net120 sky130_fd_sc_hd__clkbuf_16
XFILLER_0_23_529 VPWR VGND VPWR VGND sky130_ef_sc_hd__decap_12
XFILLER_0_62_197 VGND VGND VPWR VPWR sky130_fd_sc_hd__decap_6
XTAP_TAPCELL_ROW_89_1043 VGND VPWR sky130_fd_sc_hd__tapvpwrvgnd_1
XFILLER_0_81_18 VPWR VGND VPWR VGND sky130_ef_sc_hd__decap_12
XFILLER_0_85_223 VGND VGND VPWR VPWR sky130_fd_sc_hd__fill_1
XTAP_TAPCELL_ROW_74_899 VGND VPWR sky130_fd_sc_hd__tapvpwrvgnd_1
XFILLER_0_66_470 VGND VGND VPWR VPWR sky130_fd_sc_hd__decap_6
XFILLER_0_38_161 VGND VGND VPWR VPWR sky130_fd_sc_hd__fill_2
XFILLER_0_38_194 VGND VGND VPWR VPWR sky130_fd_sc_hd__fill_2
XFILLER_0_30_55 VGND VGND VPWR VPWR sky130_fd_sc_hd__fill_2
X_4420_ _0993_ _0994_ _0995_ VGND VGND VPWR VPWR _0996_ sky130_fd_sc_hd__or3_4
XFILLER_0_41_337 VGND VGND VPWR VPWR sky130_fd_sc_hd__fill_1
X_4351_ u_interface.u_compute_core.relu_data\[12\] net114 net14 net19 VGND VGND VPWR
+ VPWR _0928_ sky130_fd_sc_hd__and4_1
XFILLER_0_39_31 VPWR VGND VPWR VGND sky130_ef_sc_hd__decap_12
X_4282_ _0858_ _0859_ VGND VGND VPWR VPWR _0860_ sky130_fd_sc_hd__and2b_1
X_3302_ _2768_ _2771_ _2754_ VGND VGND VPWR VPWR _2773_ sky130_fd_sc_hd__a21oi_1
X_6021_ net29 u_interface.core_attn_out\[10\] _2521_ VGND VGND VPWR VPWR _2535_ sky130_fd_sc_hd__mux2_1
X_3233_ _2718_ VGND VGND VPWR VPWR _0049_ sky130_fd_sc_hd__clkbuf_1
X_3164_ _2669_ _2670_ VGND VGND VPWR VPWR _2671_ sky130_fd_sc_hd__and2_1
X_3095_ _2619_ VGND VGND VPWR VPWR _2620_ sky130_fd_sc_hd__inv_2
XFILLER_0_55_85 VPWR VGND VPWR VGND sky130_ef_sc_hd__decap_12
XFILLER_0_76_278 VPWR VGND VPWR VGND sky130_ef_sc_hd__decap_12
X_5805_ u_interface.core_attn_out\[8\] u_interface.u_compute_core.u_av.product_reg\[11\]
+ VGND VGND VPWR VPWR _2355_ sky130_fd_sc_hd__nand2_1
X_3997_ _2598_ _0500_ _0577_ _0580_ VGND VGND VPWR VPWR _0581_ sky130_fd_sc_hd__o2bb2a_1
XFILLER_0_17_323 VPWR VGND VPWR VGND sky130_ef_sc_hd__decap_12
XFILLER_0_17_345 VPWR VGND VPWR VGND sky130_ef_sc_hd__decap_12
X_5736_ _2291_ _2294_ VGND VGND VPWR VPWR _2295_ sky130_fd_sc_hd__xnor2_1
XFILLER_0_57_492 VGND VGND VPWR VPWR sky130_fd_sc_hd__decap_3
X_5667_ _2155_ _2163_ _2226_ VGND VGND VPWR VPWR _2227_ sky130_fd_sc_hd__o21ba_1
X_4618_ _0947_ _0948_ _1190_ VGND VGND VPWR VPWR _1191_ sky130_fd_sc_hd__nand3_2
XFILLER_0_32_326 VGND VGND VPWR VPWR sky130_fd_sc_hd__decap_8
XFILLER_0_44_197 VGND VGND VPWR VPWR sky130_fd_sc_hd__decap_8
X_5598_ _2063_ _2071_ _2158_ VGND VGND VPWR VPWR _2159_ sky130_fd_sc_hd__a21bo_1
X_4549_ _1010_ _1121_ _1122_ VGND VGND VPWR VPWR _1123_ sky130_fd_sc_hd__nand3_1
XFILLER_0_40_392 VPWR VGND VPWR VGND sky130_ef_sc_hd__decap_12
X_6219_ clknet_leaf_11_clk _0132_ VGND VGND VPWR VPWR u_interface.u_compute_core.u_av.product_reg\[26\]
+ sky130_fd_sc_hd__dfxtp_1
XTAP_TAPCELL_ROW_0_193 VGND VPWR sky130_fd_sc_hd__tapvpwrvgnd_1
XFILLER_0_67_278 VGND VGND VPWR VPWR sky130_fd_sc_hd__fill_2
XFILLER_0_27_109 VGND VGND VPWR VPWR sky130_fd_sc_hd__decap_3
XFILLER_0_63_495 VGND VGND VPWR VPWR sky130_fd_sc_hd__decap_8
Xclkload19 clknet_leaf_18_clk VGND VGND VPWR VPWR clkload19/X sky130_fd_sc_hd__clkbuf_4
XFILLER_0_50_101 VGND VGND VPWR VPWR sky130_fd_sc_hd__fill_1
XFILLER_0_50_134 VGND VGND VPWR VPWR sky130_fd_sc_hd__decap_6
XFILLER_0_76_29 VPWR VGND VPWR VGND sky130_ef_sc_hd__decap_12
XTAP_TAPCELL_ROW_8_271 VGND VPWR sky130_fd_sc_hd__tapvpwrvgnd_1
XTAP_TAPCELL_ROW_79_947 VGND VPWR sky130_fd_sc_hd__tapvpwrvgnd_1
XFILLER_0_25_77 VPWR VGND VPWR VGND sky130_ef_sc_hd__decap_12
X_3920_ _0505_ _0506_ VGND VGND VPWR VPWR _0507_ sky130_fd_sc_hd__or2_1
XTAP_TAPCELL_ROW_34_527 VGND VPWR sky130_fd_sc_hd__tapvpwrvgnd_1
X_3851_ _0441_ _0442_ VGND VGND VPWR VPWR _0443_ sky130_fd_sc_hd__or2_1
XFILLER_0_46_429 VGND VGND VPWR VPWR sky130_fd_sc_hd__decap_3
X_3782_ _0374_ _0375_ VGND VGND VPWR VPWR _0376_ sky130_fd_sc_hd__nor2_1
X_5521_ _1977_ _1979_ _2082_ VGND VGND VPWR VPWR _2083_ sky130_fd_sc_hd__or3_1
XFILLER_0_26_153 VGND VGND VPWR VPWR sky130_fd_sc_hd__decap_4
XFILLER_0_54_473 VGND VGND VPWR VPWR sky130_fd_sc_hd__decap_3
XFILLER_0_81_292 VGND VGND VPWR VPWR sky130_fd_sc_hd__fill_1
XFILLER_0_81_281 VGND VGND VPWR VPWR sky130_fd_sc_hd__fill_1
XFILLER_0_41_101 VGND VGND VPWR VPWR sky130_fd_sc_hd__decap_3
X_5452_ _2009_ _2010_ _2013_ VGND VGND VPWR VPWR _2015_ sky130_fd_sc_hd__o21ai_1
X_4403_ u_interface.u_compute_core.relu_valid u_interface.u_compute_core.u_av.product_reg\[13\]
+ VGND VGND VPWR VPWR _0980_ sky130_fd_sc_hd__or2_1
X_5383_ _1945_ _1946_ VGND VGND VPWR VPWR _1947_ sky130_fd_sc_hd__nand2_1
X_4334_ _0852_ _0851_ VGND VGND VPWR VPWR _0912_ sky130_fd_sc_hd__or2_1
X_6004_ net54 u_interface.core_attn_out\[4\] _2521_ VGND VGND VPWR VPWR _2524_ sky130_fd_sc_hd__mux2_1
X_4265_ _0841_ _0842_ _0773_ VGND VGND VPWR VPWR _0844_ sky130_fd_sc_hd__o21ba_4
X_3216_ _2706_ VGND VGND VPWR VPWR _0044_ sky130_fd_sc_hd__clkbuf_1
X_4196_ _0773_ _0774_ _0747_ VGND VGND VPWR VPWR _0776_ sky130_fd_sc_hd__o21ai_1
X_3147_ u_interface.u_compute_core.scaled_data\[23\] _2583_ _2658_ _2586_ VGND VGND
+ VPWR VPWR _2659_ sky130_fd_sc_hd__o2bb2a_1
X_3078_ _2582_ _2606_ VGND VGND VPWR VPWR _0006_ sky130_fd_sc_hd__nor2_1
XFILLER_0_37_429 VPWR VGND VPWR VGND sky130_ef_sc_hd__decap_12
XFILLER_0_49_278 VGND VGND VPWR VPWR sky130_fd_sc_hd__fill_2
XFILLER_0_9_353 VGND VGND VPWR VPWR sky130_fd_sc_hd__decap_8
XFILLER_0_72_292 VGND VGND VPWR VPWR sky130_fd_sc_hd__decap_6
X_5719_ _2215_ VGND VGND VPWR VPWR _2278_ sky130_fd_sc_hd__inv_2
XFILLER_0_60_421 VGND VGND VPWR VPWR sky130_fd_sc_hd__fill_2
XFILLER_0_20_307 VGND VGND VPWR VPWR sky130_fd_sc_hd__fill_1
XTAP_TAPCELL_ROW_76_917 VGND VPWR sky130_fd_sc_hd__tapvpwrvgnd_1
XFILLER_0_87_307 VGND VGND VPWR VPWR sky130_fd_sc_hd__decap_4
XTAP_TAPCELL_ROW_86_1013 VGND VPWR sky130_fd_sc_hd__tapvpwrvgnd_1
XFILLER_0_68_510 VPWR VGND VPWR VGND sky130_ef_sc_hd__decap_12
XTAP_TAPCELL_ROW_84_994 VGND VPWR sky130_fd_sc_hd__tapvpwrvgnd_1
XFILLER_0_63_281 VGND VGND VPWR VPWR sky130_fd_sc_hd__decap_8
XFILLER_0_63_270 VGND VGND VPWR VPWR sky130_fd_sc_hd__decap_8
XFILLER_0_11_57 VGND VGND VPWR VPWR sky130_fd_sc_hd__decap_4
XFILLER_0_3_529 VPWR VGND VPWR VGND sky130_ef_sc_hd__decap_12
XFILLER_0_87_39 VPWR VGND VPWR VGND sky130_ef_sc_hd__decap_12
X_4050_ _0632_ VGND VGND VPWR VPWR _0633_ sky130_fd_sc_hd__clkbuf_4
Xinput6 s_tdata[12] VGND VGND VPWR VPWR net6 sky130_fd_sc_hd__buf_1
XFILLER_0_78_307 VGND VGND VPWR VPWR sky130_fd_sc_hd__fill_1
X_4952_ _1448_ _1450_ VGND VGND VPWR VPWR _1521_ sky130_fd_sc_hd__nand2_1
XTAP_TAPCELL_ROW_19_376 VGND VPWR sky130_fd_sc_hd__tapvpwrvgnd_1
XFILLER_0_59_543 VGND VGND VPWR VPWR sky130_fd_sc_hd__decap_4
X_4883_ _1450_ _1451_ _1362_ VGND VGND VPWR VPWR _1453_ sky130_fd_sc_hd__a21o_1
X_3903_ _0489_ VGND VGND VPWR VPWR _0490_ sky130_fd_sc_hd__clkbuf_4
XFILLER_0_6_301 VGND VGND VPWR VPWR sky130_fd_sc_hd__decap_4
X_3834_ _0425_ _0414_ _0406_ VGND VGND VPWR VPWR _0426_ sky130_fd_sc_hd__a21oi_1
X_3765_ _0321_ _0324_ _0358_ VGND VGND VPWR VPWR _0360_ sky130_fd_sc_hd__nand3_1
X_5504_ _1509_ _1209_ _2065_ VGND VGND VPWR VPWR _2066_ sky130_fd_sc_hd__a21oi_1
X_3696_ _2949_ _3014_ _0291_ VGND VGND VPWR VPWR _0292_ sky130_fd_sc_hd__a21oi_1
X_5435_ _1655_ _1885_ _1886_ VGND VGND VPWR VPWR _1998_ sky130_fd_sc_hd__o21ba_1
XFILLER_0_65_3 VPWR VGND VPWR VGND sky130_ef_sc_hd__decap_12
XFILLER_0_77_61 VGND VGND VPWR VPWR sky130_fd_sc_hd__fill_1
X_5366_ _1689_ _1929_ VGND VGND VPWR VPWR _1930_ sky130_fd_sc_hd__xnor2_1
X_5297_ _1859_ _1861_ VGND VGND VPWR VPWR _1862_ sky130_fd_sc_hd__xnor2_1
X_4317_ _0892_ _0893_ _0870_ VGND VGND VPWR VPWR _0895_ sky130_fd_sc_hd__a21o_1
X_4248_ _0825_ _0824_ _0815_ VGND VGND VPWR VPWR _0827_ sky130_fd_sc_hd__a21o_1
XTAP_TAPCELL_ROW_2_222 VGND VPWR sky130_fd_sc_hd__tapvpwrvgnd_1
X_4179_ net82 u_interface.u_compute_core.relu_data\[5\] _0586_ _0556_ VGND VGND VPWR
+ VPWR _0759_ sky130_fd_sc_hd__nand4_2
XFILLER_0_77_384 VGND VGND VPWR VPWR sky130_fd_sc_hd__decap_8
XFILLER_0_92_321 VPWR VGND VPWR VGND sky130_ef_sc_hd__decap_12
XTAP_TAPCELL_ROW_53_699 VGND VPWR sky130_fd_sc_hd__tapvpwrvgnd_1
XFILLER_0_92_365 VPWR VGND VPWR VGND sky130_ef_sc_hd__decap_12
XPHY_EDGE_ROW_14_Right_14 VGND VGND VPWR VPWR sky130_fd_sc_hd__decap_3
XFILLER_0_45_281 VPWR VGND VPWR VGND sky130_ef_sc_hd__decap_12
XFILLER_0_60_251 VGND VGND VPWR VPWR sky130_fd_sc_hd__fill_1
XTAP_TAPCELL_ROW_92_1083 VGND VPWR sky130_fd_sc_hd__tapvpwrvgnd_1
XTAP_TAPCELL_ROW_92_1072 VGND VPWR sky130_fd_sc_hd__tapvpwrvgnd_1
XPHY_EDGE_ROW_23_Right_23 VGND VGND VPWR VPWR sky130_fd_sc_hd__decap_3
XTAP_TAPCELL_ROW_44_622 VGND VPWR sky130_fd_sc_hd__tapvpwrvgnd_1
XFILLER_0_28_215 VGND VGND VPWR VPWR sky130_fd_sc_hd__decap_8
XPHY_EDGE_ROW_32_Right_32 VGND VGND VPWR VPWR sky130_fd_sc_hd__decap_3
XFILLER_0_71_505 VPWR VGND VPWR VGND sky130_ef_sc_hd__decap_12
XFILLER_0_22_56 VGND VGND VPWR VPWR sky130_fd_sc_hd__decap_8
XFILLER_0_24_421 VPWR VGND VPWR VGND sky130_ef_sc_hd__decap_12
XFILLER_0_36_281 VGND VGND VPWR VPWR sky130_fd_sc_hd__decap_3
X_3550_ _2986_ _2987_ _2982_ VGND VGND VPWR VPWR _2989_ sky130_fd_sc_hd__o21ai_1
XFILLER_0_3_337 VPWR VGND VPWR VGND sky130_ef_sc_hd__decap_12
X_5220_ _1718_ _1765_ _1766_ VGND VGND VPWR VPWR _1785_ sky130_fd_sc_hd__nor3_1
X_3481_ _2924_ _2925_ VGND VGND VPWR VPWR _2926_ sky130_fd_sc_hd__or2_1
XPHY_EDGE_ROW_41_Right_41 VGND VGND VPWR VPWR sky130_fd_sc_hd__decap_3
X_5151_ net126 _1716_ VGND VGND VPWR VPWR _1717_ sky130_fd_sc_hd__xor2_1
X_5082_ u_interface.u_compute_core.relu_data\[21\] _0499_ _0595_ _2640_ VGND VGND
+ VPWR VPWR _1649_ sky130_fd_sc_hd__a22o_1
X_4102_ _0683_ _0650_ VGND VGND VPWR VPWR _0684_ sky130_fd_sc_hd__xor2_1
X_4033_ _2604_ _0503_ _0498_ _2601_ VGND VGND VPWR VPWR _0616_ sky130_fd_sc_hd__a22oi_2
XPHY_EDGE_ROW_50_Right_50 VGND VGND VPWR VPWR sky130_fd_sc_hd__decap_3
X_5984_ _2509_ _2510_ VGND VGND VPWR VPWR _2511_ sky130_fd_sc_hd__and2b_1
XFILLER_0_63_96 VGND VGND VPWR VPWR sky130_fd_sc_hd__decap_3
X_4935_ u_interface.u_compute_core.relu_data\[20\] _0504_ _0525_ u_interface.u_compute_core.relu_data\[19\]
+ VGND VGND VPWR VPWR _1504_ sky130_fd_sc_hd__a22o_1
X_4866_ _1432_ _1435_ VGND VGND VPWR VPWR _1436_ sky130_fd_sc_hd__xnor2_1
XFILLER_0_74_365 VPWR VGND VPWR VGND sky130_ef_sc_hd__decap_12
XFILLER_0_74_343 VGND VGND VPWR VPWR sky130_fd_sc_hd__fill_1
X_4797_ _1289_ _1298_ _1300_ VGND VGND VPWR VPWR _1368_ sky130_fd_sc_hd__a21o_1
X_3817_ _2935_ _0265_ _0369_ _0337_ VGND VGND VPWR VPWR _0410_ sky130_fd_sc_hd__a31o_1
XFILLER_0_6_153 VGND VGND VPWR VPWR sky130_fd_sc_hd__fill_2
XFILLER_0_27_270 VGND VGND VPWR VPWR sky130_fd_sc_hd__fill_1
XFILLER_0_34_229 VGND VGND VPWR VPWR sky130_fd_sc_hd__decap_8
X_3748_ _0341_ _0326_ VGND VGND VPWR VPWR _0343_ sky130_fd_sc_hd__and2b_1
XFILLER_0_6_197 VGND VGND VPWR VPWR sky130_fd_sc_hd__decap_8
X_3679_ _0247_ _0234_ _0275_ VGND VGND VPWR VPWR _0276_ sky130_fd_sc_hd__a21oi_1
XFILLER_0_30_446 VGND VGND VPWR VPWR sky130_fd_sc_hd__fill_2
X_5418_ _1979_ _1980_ VGND VGND VPWR VPWR _1981_ sky130_fd_sc_hd__nor2_2
X_5349_ _1909_ _1911_ _1912_ VGND VGND VPWR VPWR _1913_ sky130_fd_sc_hd__nand3_1
XTAP_TAPCELL_ROW_58_747 VGND VPWR sky130_fd_sc_hd__tapvpwrvgnd_1
XTAP_TAPCELL_ROW_13_327 VGND VPWR sky130_fd_sc_hd__tapvpwrvgnd_1
XFILLER_0_53_505 VPWR VGND VPWR VGND sky130_ef_sc_hd__decap_12
XFILLER_0_80_324 VGND VGND VPWR VPWR sky130_fd_sc_hd__decap_8
XFILLER_0_65_398 VGND VGND VPWR VPWR sky130_fd_sc_hd__fill_2
XFILLER_0_80_379 VGND VGND VPWR VPWR sky130_fd_sc_hd__decap_8
XFILLER_0_21_446 VGND VGND VPWR VPWR sky130_fd_sc_hd__fill_2
XFILLER_0_0_329 VGND VGND VPWR VPWR sky130_fd_sc_hd__decap_6
XFILLER_0_84_29 VPWR VGND VPWR VGND sky130_ef_sc_hd__decap_12
XFILLER_0_17_67 VPWR VGND VPWR VGND sky130_ef_sc_hd__decap_12
XTAP_TAPCELL_ROW_29_471 VGND VPWR sky130_fd_sc_hd__tapvpwrvgnd_1
XFILLER_0_68_170 VGND VGND VPWR VPWR sky130_fd_sc_hd__fill_2
XFILLER_0_33_55 VGND VGND VPWR VPWR sky130_fd_sc_hd__fill_1
X_4720_ u_interface.u_compute_core.relu_data\[15\] u_interface.u_compute_core.relu_data\[14\]
+ net20 _0586_ VGND VGND VPWR VPWR _1292_ sky130_fd_sc_hd__and4_1
X_4651_ _1146_ _1216_ _1220_ _1223_ VGND VGND VPWR VPWR _1224_ sky130_fd_sc_hd__o211a_1
XFILLER_0_71_313 VGND VGND VPWR VPWR sky130_fd_sc_hd__decap_6
Xinput20 s_tdata[3] VGND VGND VPWR VPWR net20 sky130_fd_sc_hd__clkbuf_2
X_3602_ _3011_ _2998_ _3039_ VGND VGND VPWR VPWR _3040_ sky130_fd_sc_hd__a21o_1
X_4582_ u_interface.u_compute_core.relu_data\[15\] u_interface.u_compute_core.relu_data\[14\]
+ net14 net19 VGND VGND VPWR VPWR _1156_ sky130_fd_sc_hd__and4_1
XFILLER_0_24_251 VGND VGND VPWR VPWR sky130_fd_sc_hd__fill_1
X_3533_ _2971_ _2972_ VGND VGND VPWR VPWR _2973_ sky130_fd_sc_hd__nand2_1
X_6252_ clknet_leaf_14_clk _0165_ VGND VGND VPWR VPWR u_interface.core_attn_out\[27\]
+ sky130_fd_sc_hd__dfxtp_1
X_3464_ _2910_ _2909_ _2908_ _2896_ VGND VGND VPWR VPWR _2912_ sky130_fd_sc_hd__a211o_1
X_5203_ _1686_ net63 _1767_ _1768_ VGND VGND VPWR VPWR _1769_ sky130_fd_sc_hd__o211a_1
X_6183_ clknet_leaf_20_clk _0096_ VGND VGND VPWR VPWR u_interface.u_compute_core.u_mac.product_reg\[5\]
+ sky130_fd_sc_hd__dfxtp_1
X_3395_ _2848_ _2849_ _2852_ VGND VGND VPWR VPWR _2853_ sky130_fd_sc_hd__a21o_1
X_5134_ _1637_ _1700_ VGND VGND VPWR VPWR _1701_ sky130_fd_sc_hd__xor2_1
XFILLER_0_58_85 VGND VGND VPWR VPWR sky130_fd_sc_hd__decap_8
X_5065_ _1483_ net113 _1632_ VGND VGND VPWR VPWR _1633_ sky130_fd_sc_hd__o21a_1
XFILLER_0_28_3 VPWR VGND VPWR VGND sky130_ef_sc_hd__decap_12
X_4016_ _0584_ _0599_ VGND VGND VPWR VPWR _0600_ sky130_fd_sc_hd__or2_1
XFILLER_0_79_446 VGND VGND VPWR VPWR sky130_fd_sc_hd__fill_2
XFILLER_0_66_118 VPWR VGND VPWR VGND sky130_ef_sc_hd__decap_12
X_5967_ _2490_ _2493_ VGND VGND VPWR VPWR _2496_ sky130_fd_sc_hd__or2_1
X_4918_ _1413_ _1422_ VGND VGND VPWR VPWR _1487_ sky130_fd_sc_hd__nand2_1
XFILLER_0_90_83 VGND VGND VPWR VPWR sky130_fd_sc_hd__fill_1
XTAP_TAPCELL_ROW_63_794 VGND VPWR sky130_fd_sc_hd__tapvpwrvgnd_1
X_5898_ u_interface.core_attn_out\[20\] u_interface.u_compute_core.u_av.product_reg\[23\]
+ VGND VGND VPWR VPWR _2436_ sky130_fd_sc_hd__nand2_1
X_4849_ _1417_ _1418_ VGND VGND VPWR VPWR _1419_ sky130_fd_sc_hd__and2b_1
XFILLER_0_7_473 VPWR VGND VPWR VGND sky130_ef_sc_hd__decap_12
XFILLER_0_30_298 VGND VGND VPWR VPWR sky130_fd_sc_hd__decap_8
XFILLER_0_85_405 VPWR VGND VPWR VGND sky130_ef_sc_hd__decap_12
XFILLER_0_80_132 VGND VGND VPWR VPWR sky130_fd_sc_hd__decap_8
XFILLER_0_0_104 VGND VGND VPWR VPWR sky130_fd_sc_hd__decap_4
X_3180_ _2672_ _2681_ VGND VGND VPWR VPWR _2682_ sky130_fd_sc_hd__and2_1
XFILLER_0_88_232 VGND VGND VPWR VPWR sky130_fd_sc_hd__fill_1
X_5821_ u_interface.core_attn_out\[8\] u_interface.u_compute_core.u_av.product_reg\[11\]
+ _2362_ VGND VGND VPWR VPWR _2369_ sky130_fd_sc_hd__a21o_1
X_5752_ _2308_ VGND VGND VPWR VPWR _2309_ sky130_fd_sc_hd__clkbuf_4
XFILLER_0_17_505 VGND VGND VPWR VPWR sky130_fd_sc_hd__fill_2
X_4703_ _1239_ _1273_ _1274_ VGND VGND VPWR VPWR _1275_ sky130_fd_sc_hd__nand3_4
Xclkbuf_leaf_14_clk clknet_1_1__leaf_clk VGND VGND VPWR VPWR clknet_leaf_14_clk sky130_fd_sc_hd__clkbuf_8
XFILLER_0_17_516 VPWR VGND VPWR VGND sky130_ef_sc_hd__decap_12
XFILLER_0_44_302 VGND VGND VPWR VPWR sky130_fd_sc_hd__decap_6
XFILLER_0_60_42 VPWR VGND VPWR VGND sky130_ef_sc_hd__decap_12
XFILLER_0_71_143 VPWR VGND VPWR VGND sky130_ef_sc_hd__decap_12
XTAP_TAPCELL_ROW_32_499 VGND VPWR sky130_fd_sc_hd__tapvpwrvgnd_1
X_5683_ _2177_ _2178_ _2180_ _2182_ VGND VGND VPWR VPWR _2243_ sky130_fd_sc_hd__o31a_1
X_4634_ _1188_ _1205_ _1206_ VGND VGND VPWR VPWR _1207_ sky130_fd_sc_hd__nand3_2
XFILLER_0_4_421 VPWR VGND VPWR VGND sky130_ef_sc_hd__decap_12
XFILLER_0_32_519 VPWR VGND VPWR VGND sky130_ef_sc_hd__decap_12
X_4565_ u_interface.u_compute_core.relu_data\[9\] _2610_ _0632_ VGND VGND VPWR VPWR
+ _1139_ sky130_fd_sc_hd__and3_1
X_3516_ _2944_ _2942_ _2955_ _2956_ VGND VGND VPWR VPWR _2957_ sky130_fd_sc_hd__o211a_1
X_4496_ _1003_ _1070_ VGND VGND VPWR VPWR _1071_ sky130_fd_sc_hd__nor2_1
XFILLER_0_12_265 VPWR VGND VPWR VGND sky130_ef_sc_hd__decap_12
XPHY_EDGE_ROW_4_Right_4 VGND VGND VPWR VPWR sky130_fd_sc_hd__decap_3
X_6235_ clknet_leaf_15_clk _0148_ VGND VGND VPWR VPWR u_interface.core_attn_out\[10\]
+ sky130_fd_sc_hd__dfxtp_1
X_3447_ _2833_ u_interface.u_compute_core.mac_accum\[26\] VGND VGND VPWR VPWR _2897_
+ sky130_fd_sc_hd__or2_1
X_6166_ clknet_leaf_2_clk _0079_ VGND VGND VPWR VPWR u_interface.u_compute_core.mac_accum\[20\]
+ sky130_fd_sc_hd__dfxtp_1
X_3378_ u_interface.u_compute_core.u_mac.product_reg\[15\] u_interface.u_compute_core.mac_accum\[16\]
+ VGND VGND VPWR VPWR _2838_ sky130_fd_sc_hd__or2_1
X_5117_ _1666_ _1682_ _1683_ VGND VGND VPWR VPWR _1684_ sky130_fd_sc_hd__nand3_1
X_6097_ clknet_leaf_6_clk _0010_ VGND VGND VPWR VPWR u_interface.u_compute_core.relu_data\[10\]
+ sky130_fd_sc_hd__dfxtp_2
X_5048_ _1613_ _1614_ _1591_ VGND VGND VPWR VPWR _1616_ sky130_fd_sc_hd__a21oi_1
XTAP_TAPCELL_ROW_68_842 VGND VPWR sky130_fd_sc_hd__tapvpwrvgnd_1
XFILLER_0_79_276 VGND VGND VPWR VPWR sky130_fd_sc_hd__decap_4
XFILLER_0_67_405 VPWR VGND VPWR VGND sky130_ef_sc_hd__decap_12
XFILLER_0_67_449 VGND VGND VPWR VPWR sky130_fd_sc_hd__decap_6
XTAP_TAPCELL_ROW_23_422 VGND VPWR sky130_fd_sc_hd__tapvpwrvgnd_1
XFILLER_0_75_482 VGND VGND VPWR VPWR sky130_fd_sc_hd__decap_6
XFILLER_0_62_110 VGND VGND VPWR VPWR sky130_fd_sc_hd__decap_4
XFILLER_0_7_281 VPWR VGND VPWR VGND sky130_ef_sc_hd__decap_12
XFILLER_0_50_338 VGND VGND VPWR VPWR sky130_fd_sc_hd__decap_8
XFILLER_0_31_541 VGND VGND VPWR VPWR sky130_fd_sc_hd__fill_2
XTAP_TAPCELL_ROW_89_1044 VGND VPWR sky130_fd_sc_hd__tapvpwrvgnd_1
XFILLER_0_85_213 VGND VGND VPWR VPWR sky130_fd_sc_hd__decap_6
XFILLER_0_85_279 VGND VGND VPWR VPWR sky130_fd_sc_hd__fill_1
XFILLER_0_73_419 VGND VGND VPWR VPWR sky130_fd_sc_hd__fill_2
XFILLER_0_26_313 VGND VGND VPWR VPWR sky130_fd_sc_hd__fill_1
XFILLER_0_53_198 VGND VGND VPWR VPWR sky130_fd_sc_hd__fill_1
X_4350_ u_interface.u_compute_core.relu_data\[11\] VGND VGND VPWR VPWR _0927_ sky130_fd_sc_hd__buf_6
XFILLER_0_22_541 VGND VGND VPWR VPWR sky130_fd_sc_hd__fill_2
X_3301_ _2768_ _2771_ VGND VGND VPWR VPWR _2772_ sky130_fd_sc_hd__or2_1
X_4281_ _2615_ _0489_ _0534_ _2611_ VGND VGND VPWR VPWR _0859_ sky130_fd_sc_hd__a22o_1
XFILLER_0_39_43 VPWR VGND VPWR VGND sky130_ef_sc_hd__decap_12
X_6020_ _2534_ VGND VGND VPWR VPWR _0181_ sky130_fd_sc_hd__clkbuf_1
X_3232_ _2716_ _2717_ VGND VGND VPWR VPWR _2718_ sky130_fd_sc_hd__and2_1
Xclkbuf_leaf_3_clk clknet_1_0__leaf_clk VGND VGND VPWR VPWR clknet_leaf_3_clk sky130_fd_sc_hd__clkbuf_8
X_3163_ _2579_ VGND VGND VPWR VPWR _2670_ sky130_fd_sc_hd__buf_2
XFILLER_0_89_541 VGND VGND VPWR VPWR sky130_fd_sc_hd__decap_6
X_3094_ u_interface.u_compute_core.relu_data\[10\] VGND VGND VPWR VPWR _2619_ sky130_fd_sc_hd__buf_6
XTAP_TAPCELL_ROW_37_547 VGND VPWR sky130_fd_sc_hd__tapvpwrvgnd_1
XFILLER_0_49_405 VGND VGND VPWR VPWR sky130_fd_sc_hd__decap_6
XFILLER_0_76_202 VGND VGND VPWR VPWR sky130_fd_sc_hd__decap_3
XFILLER_0_76_257 VGND VGND VPWR VPWR sky130_fd_sc_hd__fill_1
X_5804_ u_interface.core_attn_out\[8\] u_interface.u_compute_core.u_av.product_reg\[11\]
+ VGND VGND VPWR VPWR _2354_ sky130_fd_sc_hd__or2_1
XFILLER_0_29_151 VPWR VGND VPWR VGND sky130_ef_sc_hd__decap_12
XFILLER_0_29_173 VGND VGND VPWR VPWR sky130_fd_sc_hd__fill_1
X_3996_ _2604_ _0502_ _0504_ net95 VGND VGND VPWR VPWR _0580_ sky130_fd_sc_hd__a22oi_1
XFILLER_0_84_290 VPWR VGND VPWR VGND sky130_ef_sc_hd__decap_12
XFILLER_0_17_335 VGND VGND VPWR VPWR sky130_fd_sc_hd__fill_1
X_5735_ _1860_ _2293_ VGND VGND VPWR VPWR _2294_ sky130_fd_sc_hd__xnor2_1
XFILLER_0_17_357 VPWR VGND VPWR VGND sky130_ef_sc_hd__decap_12
X_5666_ _2152_ _2154_ VGND VGND VPWR VPWR _2226_ sky130_fd_sc_hd__and2b_1
X_4617_ u_interface.u_compute_core.relu_data\[7\] _0702_ _1140_ _1139_ VGND VGND VPWR
+ VPWR _1190_ sky130_fd_sc_hd__a31o_1
XFILLER_0_4_251 VGND VGND VPWR VPWR sky130_fd_sc_hd__fill_1
X_5597_ _2072_ _2061_ VGND VGND VPWR VPWR _2158_ sky130_fd_sc_hd__or2b_1
X_4548_ _0947_ _0948_ _1120_ VGND VGND VPWR VPWR _1122_ sky130_fd_sc_hd__a21o_1
X_4479_ _2611_ _0819_ _0656_ VGND VGND VPWR VPWR _1054_ sky130_fd_sc_hd__and3_1
X_6218_ clknet_leaf_11_clk _0131_ VGND VGND VPWR VPWR u_interface.u_compute_core.u_av.product_reg\[25\]
+ sky130_fd_sc_hd__dfxtp_1
X_6149_ clknet_leaf_20_clk _0062_ VGND VGND VPWR VPWR u_interface.u_compute_core.mac_accum\[3\]
+ sky130_fd_sc_hd__dfxtp_1
XPHY_EDGE_ROW_79_Right_79 VGND VGND VPWR VPWR sky130_fd_sc_hd__decap_3
XTAP_TAPCELL_ROW_0_194 VGND VPWR sky130_fd_sc_hd__tapvpwrvgnd_1
XFILLER_0_82_205 VGND VGND VPWR VPWR sky130_fd_sc_hd__fill_1
XFILLER_0_90_271 VGND VGND VPWR VPWR sky130_fd_sc_hd__fill_2
XPHY_EDGE_ROW_88_Right_88 VGND VGND VPWR VPWR sky130_fd_sc_hd__decap_3
XFILLER_0_76_19 VGND VGND VPWR VPWR sky130_fd_sc_hd__decap_8
XTAP_TAPCELL_ROW_8_272 VGND VPWR sky130_fd_sc_hd__tapvpwrvgnd_1
XTAP_TAPCELL_ROW_79_948 VGND VPWR sky130_fd_sc_hd__tapvpwrvgnd_1
XFILLER_0_92_29 VPWR VGND VPWR VGND sky130_ef_sc_hd__decap_12
XFILLER_0_86_533 VPWR VGND VPWR VGND sky130_ef_sc_hd__decap_12
XFILLER_0_25_89 VGND VGND VPWR VPWR sky130_fd_sc_hd__decap_3
X_3850_ _0440_ _0426_ VGND VGND VPWR VPWR _0442_ sky130_fd_sc_hd__and2b_1
XFILLER_0_46_419 VGND VGND VPWR VPWR sky130_fd_sc_hd__fill_1
XFILLER_0_58_279 VPWR VGND VPWR VGND sky130_ef_sc_hd__decap_12
X_3781_ _0335_ _0340_ _0334_ VGND VGND VPWR VPWR _0375_ sky130_fd_sc_hd__a21oi_1
XFILLER_0_26_121 VGND VGND VPWR VPWR sky130_fd_sc_hd__decap_3
X_5520_ _1998_ _2000_ _1999_ VGND VGND VPWR VPWR _2082_ sky130_fd_sc_hd__a21o_1
XTAP_TAPCELL_ROW_42_594 VGND VPWR sky130_fd_sc_hd__tapvpwrvgnd_1
XFILLER_0_81_260 VPWR VGND VPWR VGND sky130_ef_sc_hd__decap_12
XFILLER_0_41_113 VGND VGND VPWR VPWR sky130_fd_sc_hd__fill_1
X_5451_ _2009_ _2010_ _2013_ VGND VGND VPWR VPWR _2014_ sky130_fd_sc_hd__or3_1
XFILLER_0_41_146 VGND VGND VPWR VPWR sky130_fd_sc_hd__decap_3
XFILLER_0_41_157 VGND VGND VPWR VPWR sky130_fd_sc_hd__fill_1
X_4402_ _0908_ _0911_ _0977_ VGND VGND VPWR VPWR _0979_ sky130_fd_sc_hd__a21oi_1
X_5382_ _1867_ _1857_ _1944_ VGND VGND VPWR VPWR _1946_ sky130_fd_sc_hd__nand3_1
XFILLER_0_10_533 VPWR VGND VPWR VGND sky130_ef_sc_hd__decap_12
X_4333_ _0852_ _0851_ _0908_ _0910_ _0909_ VGND VGND VPWR VPWR _0911_ sky130_fd_sc_hd__o2111ai_4
X_4264_ _0842_ _0841_ _0773_ VGND VGND VPWR VPWR _0843_ sky130_fd_sc_hd__nor3b_4
XFILLER_0_66_41 VPWR VGND VPWR VGND sky130_ef_sc_hd__decap_12
X_6003_ _2523_ VGND VGND VPWR VPWR _0175_ sky130_fd_sc_hd__clkbuf_1
XFILLER_0_5_77 VGND VGND VPWR VPWR sky130_fd_sc_hd__fill_2
XFILLER_0_5_55 VGND VGND VPWR VPWR sky130_fd_sc_hd__fill_1
X_3215_ _2694_ _2705_ VGND VGND VPWR VPWR _2706_ sky130_fd_sc_hd__and2_1
XFILLER_0_66_96 VGND VGND VPWR VPWR sky130_fd_sc_hd__decap_3
XFILLER_0_66_85 VGND VGND VPWR VPWR sky130_fd_sc_hd__decap_4
X_4195_ _0747_ _0773_ _0774_ VGND VGND VPWR VPWR _0775_ sky130_fd_sc_hd__or3_4
X_3146_ u_interface.u_compute_core.relu_data\[23\] VGND VGND VPWR VPWR _2658_ sky130_fd_sc_hd__inv_2
X_3077_ u_interface.u_compute_core.scaled_data\[6\] _2584_ _2605_ _2587_ VGND VGND
+ VPWR VPWR _2606_ sky130_fd_sc_hd__o2bb2a_1
XFILLER_0_10_3 VGND VGND VPWR VPWR sky130_fd_sc_hd__decap_8
XFILLER_0_64_249 VGND VGND VPWR VPWR sky130_fd_sc_hd__decap_3
XFILLER_0_64_227 VGND VGND VPWR VPWR sky130_fd_sc_hd__fill_1
XFILLER_0_17_110 VGND VGND VPWR VPWR sky130_fd_sc_hd__fill_2
X_3979_ _0523_ _0538_ _0562_ _0563_ VGND VGND VPWR VPWR _0564_ sky130_fd_sc_hd__nor4_1
X_5718_ _2256_ _2276_ VGND VGND VPWR VPWR _2277_ sky130_fd_sc_hd__xnor2_1
XFILLER_0_72_271 VGND VGND VPWR VPWR sky130_fd_sc_hd__decap_8
X_5649_ _2207_ _2208_ VGND VGND VPWR VPWR _2209_ sky130_fd_sc_hd__nand2_1
XFILLER_0_20_319 VGND VGND VPWR VPWR sky130_fd_sc_hd__fill_2
XFILLER_0_60_477 VGND VGND VPWR VPWR sky130_fd_sc_hd__decap_3
XFILLER_0_13_393 VGND VGND VPWR VPWR sky130_fd_sc_hd__decap_8
XFILLER_0_40_190 VGND VGND VPWR VPWR sky130_fd_sc_hd__decap_6
XTAP_TAPCELL_ROW_76_918 VGND VPWR sky130_fd_sc_hd__tapvpwrvgnd_1
XTAP_TAPCELL_ROW_86_1014 VGND VPWR sky130_fd_sc_hd__tapvpwrvgnd_1
XFILLER_0_68_533 VPWR VGND VPWR VGND sky130_ef_sc_hd__decap_12
XFILLER_0_68_522 VGND VGND VPWR VPWR sky130_fd_sc_hd__decap_8
XTAP_TAPCELL_ROW_84_995 VGND VPWR sky130_fd_sc_hd__tapvpwrvgnd_1
XFILLER_0_83_503 VGND VGND VPWR VPWR sky130_fd_sc_hd__fill_1
XFILLER_0_28_419 VGND VGND VPWR VPWR sky130_fd_sc_hd__fill_1
XFILLER_0_23_113 VGND VGND VPWR VPWR sky130_fd_sc_hd__decap_4
XFILLER_0_51_488 VGND VGND VPWR VPWR sky130_fd_sc_hd__decap_4
XFILLER_0_51_499 VGND VGND VPWR VPWR sky130_fd_sc_hd__decap_4
XFILLER_0_36_11 VGND VGND VPWR VPWR sky130_fd_sc_hd__fill_2
Xinput7 s_tdata[13] VGND VGND VPWR VPWR net7 sky130_fd_sc_hd__buf_1
XFILLER_0_36_55 VGND VGND VPWR VPWR sky130_fd_sc_hd__fill_1
XTAP_TAPCELL_ROW_47_642 VGND VPWR sky130_fd_sc_hd__tapvpwrvgnd_1
X_4951_ _1446_ _1453_ _1452_ VGND VGND VPWR VPWR _1520_ sky130_fd_sc_hd__a21bo_1
XTAP_TAPCELL_ROW_19_377 VGND VPWR sky130_fd_sc_hd__tapvpwrvgnd_1
XFILLER_0_86_363 VGND VGND VPWR VPWR sky130_fd_sc_hd__fill_1
X_4882_ _1362_ _1450_ _1451_ VGND VGND VPWR VPWR _1452_ sky130_fd_sc_hd__nand3_1
X_3902_ _0488_ VGND VGND VPWR VPWR _0489_ sky130_fd_sc_hd__buf_6
XFILLER_0_19_408 VGND VGND VPWR VPWR sky130_fd_sc_hd__fill_2
XFILLER_0_46_205 VGND VGND VPWR VPWR sky130_fd_sc_hd__fill_1
XFILLER_0_46_216 VPWR VGND VPWR VGND sky130_ef_sc_hd__decap_12
X_3833_ _0408_ VGND VGND VPWR VPWR _0425_ sky130_fd_sc_hd__inv_2
X_3764_ _0321_ _0324_ _0358_ VGND VGND VPWR VPWR _0359_ sky130_fd_sc_hd__a21o_1
X_5503_ _1509_ _1209_ _0648_ VGND VGND VPWR VPWR _2065_ sky130_fd_sc_hd__o21ai_1
X_3695_ _2936_ _0217_ VGND VGND VPWR VPWR _0291_ sky130_fd_sc_hd__nor2_1
X_5434_ _1911_ _1913_ VGND VGND VPWR VPWR _1997_ sky130_fd_sc_hd__nand2_1
XFILLER_0_42_477 VGND VGND VPWR VPWR sky130_fd_sc_hd__decap_3
XFILLER_0_77_73 VGND VGND VPWR VPWR sky130_fd_sc_hd__fill_2
X_5365_ net128 _1928_ VGND VGND VPWR VPWR _1929_ sky130_fd_sc_hd__xnor2_1
XFILLER_0_58_3 VPWR VGND VPWR VGND sky130_ef_sc_hd__decap_12
X_5296_ _1860_ _1774_ _1773_ VGND VGND VPWR VPWR _1861_ sky130_fd_sc_hd__a21bo_1
X_4316_ _0870_ _0892_ _0893_ VGND VGND VPWR VPWR _0894_ sky130_fd_sc_hd__nand3_2
X_4247_ _0815_ _0824_ _0825_ VGND VGND VPWR VPWR _0826_ sky130_fd_sc_hd__nand3_1
X_4178_ u_interface.u_compute_core.relu_data\[4\] _0594_ VGND VGND VPWR VPWR _0758_
+ sky130_fd_sc_hd__nand2_1
XTAP_TAPCELL_ROW_2_223 VGND VPWR sky130_fd_sc_hd__tapvpwrvgnd_1
XFILLER_0_69_319 VGND VGND VPWR VPWR sky130_fd_sc_hd__fill_1
X_3129_ u_interface.u_compute_core.scaled_data\[18\] _2618_ _2645_ _2586_ VGND VGND
+ VPWR VPWR _2646_ sky130_fd_sc_hd__o2bb2a_1
XTAP_TAPCELL_ROW_81_965 VGND VPWR sky130_fd_sc_hd__tapvpwrvgnd_1
XFILLER_0_92_333 VGND VGND VPWR VPWR sky130_fd_sc_hd__decap_3
XFILLER_0_92_377 VPWR VGND VPWR VGND sky130_ef_sc_hd__decap_12
XFILLER_0_18_485 VGND VGND VPWR VPWR sky130_fd_sc_hd__decap_3
XFILLER_0_18_496 VGND VGND VPWR VPWR sky130_fd_sc_hd__decap_4
XFILLER_0_45_260 VPWR VGND VPWR VGND sky130_ef_sc_hd__decap_12
XFILLER_0_45_293 VGND VGND VPWR VPWR sky130_fd_sc_hd__decap_4
XTAP_TAPCELL_ROW_92_1084 VGND VPWR sky130_fd_sc_hd__tapvpwrvgnd_1
XTAP_TAPCELL_ROW_92_1073 VGND VPWR sky130_fd_sc_hd__tapvpwrvgnd_1
XFILLER_0_87_127 VGND VGND VPWR VPWR sky130_fd_sc_hd__fill_2
XFILLER_0_68_363 VGND VGND VPWR VPWR sky130_fd_sc_hd__fill_1
XFILLER_0_68_352 VGND VGND VPWR VPWR sky130_fd_sc_hd__decap_3
XTAP_TAPCELL_ROW_16_347 VGND VPWR sky130_fd_sc_hd__tapvpwrvgnd_1
XFILLER_0_83_377 VGND VGND VPWR VPWR sky130_fd_sc_hd__decap_4
XFILLER_0_71_517 VPWR VGND VPWR VGND sky130_ef_sc_hd__decap_12
XFILLER_0_3_305 VPWR VGND VPWR VGND sky130_ef_sc_hd__decap_12
XFILLER_0_24_433 VPWR VGND VPWR VGND sky130_ef_sc_hd__decap_12
XFILLER_0_24_455 VGND VGND VPWR VPWR sky130_fd_sc_hd__fill_1
XFILLER_0_3_349 VPWR VGND VPWR VGND sky130_ef_sc_hd__decap_12
X_3480_ _2834_ u_interface.u_compute_core.mac_accum\[31\] VGND VGND VPWR VPWR _2925_
+ sky130_fd_sc_hd__xnor2_1
XFILLER_0_24_477 VPWR VGND VPWR VGND sky130_ef_sc_hd__decap_12
XFILLER_0_24_499 VPWR VGND VPWR VGND sky130_ef_sc_hd__decap_12
XFILLER_0_51_285 VGND VGND VPWR VPWR sky130_fd_sc_hd__fill_1
X_5150_ _1667_ _1681_ _1680_ VGND VGND VPWR VPWR _1716_ sky130_fd_sc_hd__a21bo_1
X_5081_ u_interface.u_compute_core.relu_data\[21\] _2640_ _0499_ _0819_ VGND VGND
+ VPWR VPWR _1648_ sky130_fd_sc_hd__and4_1
X_4101_ _0682_ _0651_ VGND VGND VPWR VPWR _0683_ sky130_fd_sc_hd__xor2_1
XFILLER_0_47_76 VPWR VGND VPWR VGND sky130_ef_sc_hd__decap_12
X_4032_ net82 net86 _0503_ net19 VGND VGND VPWR VPWR _0615_ sky130_fd_sc_hd__and4_1
X_5983_ _2308_ _2507_ _2508_ u_interface.core_attn_out\[31\] VGND VGND VPWR VPWR _2510_
+ sky130_fd_sc_hd__a31o_1
X_4934_ u_interface.u_compute_core.relu_data\[20\] u_interface.u_compute_core.relu_data\[19\]
+ _0495_ _0499_ VGND VGND VPWR VPWR _1503_ sky130_fd_sc_hd__and4_1
XFILLER_0_47_503 VGND VGND VPWR VPWR sky130_fd_sc_hd__fill_1
XFILLER_0_59_363 VGND VGND VPWR VPWR sky130_fd_sc_hd__fill_2
X_4865_ _1433_ _1434_ VGND VGND VPWR VPWR _1435_ sky130_fd_sc_hd__and2b_1
X_4796_ _1365_ _1366_ VGND VGND VPWR VPWR _1367_ sky130_fd_sc_hd__or2_1
XFILLER_0_74_377 VGND VGND VPWR VPWR sky130_fd_sc_hd__decap_8
X_3816_ _2928_ _2930_ _0265_ VGND VGND VPWR VPWR _0409_ sky130_fd_sc_hd__o21a_1
XFILLER_0_62_517 VPWR VGND VPWR VGND sky130_ef_sc_hd__decap_12
X_3747_ _0326_ _0341_ VGND VGND VPWR VPWR _0342_ sky130_fd_sc_hd__and2b_1
XFILLER_0_12_90 VPWR VGND VPWR VGND sky130_ef_sc_hd__decap_12
X_3678_ _0273_ _0274_ VGND VGND VPWR VPWR _0275_ sky130_fd_sc_hd__or2b_1
XFILLER_0_88_83 VGND VGND VPWR VPWR sky130_fd_sc_hd__fill_1
X_5417_ _1655_ _1978_ VGND VGND VPWR VPWR _1980_ sky130_fd_sc_hd__and2_1
XFILLER_0_30_469 VGND VGND VPWR VPWR sky130_fd_sc_hd__decap_6
X_5348_ net118 _1600_ _1910_ VGND VGND VPWR VPWR _1912_ sky130_fd_sc_hd__a21o_1
XFILLER_0_10_171 VGND VGND VPWR VPWR sky130_fd_sc_hd__fill_1
XFILLER_0_10_182 VGND VGND VPWR VPWR sky130_fd_sc_hd__fill_1
X_5279_ _1841_ _1842_ _1787_ _1788_ VGND VGND VPWR VPWR _1844_ sky130_fd_sc_hd__a211oi_2
XTAP_TAPCELL_ROW_58_748 VGND VPWR sky130_fd_sc_hd__tapvpwrvgnd_1
XFILLER_0_65_300 VPWR VGND VPWR VGND sky130_ef_sc_hd__decap_12
XFILLER_0_53_517 VGND VGND VPWR VPWR sky130_fd_sc_hd__fill_2
XFILLER_0_17_79 VPWR VGND VPWR VGND sky130_ef_sc_hd__decap_12
XTAP_TAPCELL_ROW_29_472 VGND VPWR sky130_fd_sc_hd__tapvpwrvgnd_1
X_4650_ _1221_ _1219_ _1222_ VGND VGND VPWR VPWR _1223_ sky130_fd_sc_hd__a21o_1
Xinput21 s_tdata[4] VGND VGND VPWR VPWR net21 sky130_fd_sc_hd__clkbuf_2
X_3601_ _3037_ _3038_ VGND VGND VPWR VPWR _3039_ sky130_fd_sc_hd__nand2_1
Xinput10 s_tdata[16] VGND VGND VPWR VPWR net10 sky130_fd_sc_hd__buf_1
XFILLER_0_3_102 VGND VGND VPWR VPWR sky130_fd_sc_hd__fill_2
X_4581_ _2628_ _0816_ VGND VGND VPWR VPWR _1155_ sky130_fd_sc_hd__nand2_1
XFILLER_0_71_369 VGND VGND VPWR VPWR sky130_fd_sc_hd__fill_2
X_3532_ _2931_ _2945_ _2970_ _2929_ VGND VGND VPWR VPWR _2972_ sky130_fd_sc_hd__a22o_1
X_6251_ clknet_leaf_13_clk _0164_ VGND VGND VPWR VPWR u_interface.core_attn_out\[26\]
+ sky130_fd_sc_hd__dfxtp_1
X_3463_ _2896_ _2908_ _2909_ _2910_ VGND VGND VPWR VPWR _2911_ sky130_fd_sc_hd__o211ai_2
X_5202_ _1765_ _1766_ _1718_ VGND VGND VPWR VPWR _1768_ sky130_fd_sc_hd__o21ai_1
X_6182_ clknet_leaf_20_clk _0095_ VGND VGND VPWR VPWR u_interface.u_compute_core.u_mac.product_reg\[4\]
+ sky130_fd_sc_hd__dfxtp_1
X_3394_ _2850_ _2851_ VGND VGND VPWR VPWR _2852_ sky130_fd_sc_hd__nand2_1
X_5133_ _1042_ _1699_ VGND VGND VPWR VPWR _1700_ sky130_fd_sc_hd__xnor2_2
XFILLER_0_74_52 VGND VGND VPWR VPWR sky130_fd_sc_hd__fill_1
X_5064_ _1557_ _1554_ _1555_ VGND VGND VPWR VPWR _1632_ sky130_fd_sc_hd__o21ba_1
XFILLER_0_74_85 VGND VGND VPWR VPWR sky130_fd_sc_hd__decap_4
X_4015_ _0593_ _0598_ VGND VGND VPWR VPWR _0599_ sky130_fd_sc_hd__xor2_1
XFILLER_0_79_458 VPWR VGND VPWR VGND sky130_ef_sc_hd__decap_12
XTAP_TAPCELL_ROW_55_718 VGND VPWR sky130_fd_sc_hd__tapvpwrvgnd_1
X_5966_ net170 _2304_ _0981_ _2495_ VGND VGND VPWR VPWR _0166_ sky130_fd_sc_hd__o211a_1
X_4917_ _1409_ _1392_ net76 _1469_ VGND VGND VPWR VPWR _1486_ sky130_fd_sc_hd__a211o_1
XFILLER_0_74_141 VGND VGND VPWR VPWR sky130_fd_sc_hd__decap_8
X_5897_ u_interface.core_attn_out\[20\] u_interface.u_compute_core.u_av.product_reg\[23\]
+ VGND VGND VPWR VPWR _2435_ sky130_fd_sc_hd__or2_1
XTAP_TAPCELL_ROW_63_795 VGND VPWR sky130_fd_sc_hd__tapvpwrvgnd_1
X_4848_ _1010_ _1192_ VGND VGND VPWR VPWR _1418_ sky130_fd_sc_hd__or2_1
XFILLER_0_7_441 VGND VGND VPWR VPWR sky130_fd_sc_hd__decap_6
XFILLER_0_7_485 VPWR VGND VPWR VGND sky130_ef_sc_hd__decap_12
X_4779_ _1347_ _1348_ _1349_ VGND VGND VPWR VPWR _1350_ sky130_fd_sc_hd__nand3_1
XFILLER_0_15_296 VGND VGND VPWR VPWR sky130_fd_sc_hd__decap_3
XFILLER_0_11_480 VGND VGND VPWR VPWR sky130_fd_sc_hd__fill_1
XFILLER_0_85_417 VGND VGND VPWR VPWR sky130_fd_sc_hd__fill_1
XFILLER_0_85_428 VPWR VGND VPWR VGND sky130_ef_sc_hd__decap_12
XTAP_TAPCELL_ROW_26_442 VGND VPWR sky130_fd_sc_hd__tapvpwrvgnd_1
XFILLER_0_80_100 VPWR VGND VPWR VGND sky130_ef_sc_hd__decap_12
XFILLER_0_79_19 VPWR VGND VPWR VGND sky130_ef_sc_hd__decap_12
XFILLER_0_41_509 VGND VGND VPWR VPWR sky130_fd_sc_hd__fill_1
XFILLER_0_61_391 VGND VGND VPWR VPWR sky130_fd_sc_hd__fill_1
XFILLER_0_88_222 VGND VGND VPWR VPWR sky130_fd_sc_hd__fill_1
XFILLER_0_44_66 VGND VGND VPWR VPWR sky130_fd_sc_hd__fill_2
XFILLER_0_44_77 VGND VGND VPWR VPWR sky130_fd_sc_hd__fill_2
X_5820_ _2366_ _2367_ VGND VGND VPWR VPWR _2368_ sky130_fd_sc_hd__nand2_1
XFILLER_0_8_227 VPWR VGND VPWR VGND sky130_ef_sc_hd__decap_12
X_5751_ u_interface.u_compute_core.u_av.valid_a VGND VGND VPWR VPWR _2308_ sky130_fd_sc_hd__buf_2
XFILLER_0_56_141 VGND VGND VPWR VPWR sky130_fd_sc_hd__fill_2
X_4702_ _1272_ _1271_ _0835_ VGND VGND VPWR VPWR _1274_ sky130_fd_sc_hd__a21o_1
XFILLER_0_17_528 VPWR VGND VPWR VGND sky130_ef_sc_hd__decap_12
XTAP_TAPCELL_ROW_60_765 VGND VPWR sky130_fd_sc_hd__tapvpwrvgnd_1
XFILLER_0_60_54 VGND VGND VPWR VPWR sky130_fd_sc_hd__decap_8
X_5682_ _1860_ _2241_ VGND VGND VPWR VPWR _2242_ sky130_fd_sc_hd__xnor2_1
X_4633_ _1203_ _1204_ _1164_ VGND VGND VPWR VPWR _1206_ sky130_fd_sc_hd__a21o_1
XFILLER_0_71_155 VGND VGND VPWR VPWR sky130_fd_sc_hd__decap_6
XFILLER_0_8_11 VGND VGND VPWR VPWR sky130_fd_sc_hd__fill_1
XFILLER_0_4_433 VPWR VGND VPWR VGND sky130_ef_sc_hd__decap_12
X_4564_ _2637_ _0515_ VGND VGND VPWR VPWR _1138_ sky130_fd_sc_hd__nand2_1
XFILLER_0_8_44 VPWR VGND VPWR VGND sky130_ef_sc_hd__decap_12
X_3515_ _2946_ _2948_ _2952_ _2953_ VGND VGND VPWR VPWR _2956_ sky130_fd_sc_hd__a22o_1
XFILLER_0_12_222 VPWR VGND VPWR VGND sky130_ef_sc_hd__decap_12
XFILLER_0_4_477 VPWR VGND VPWR VGND sky130_ef_sc_hd__decap_12
XFILLER_0_40_531 VGND VGND VPWR VPWR sky130_fd_sc_hd__fill_1
X_4495_ _1068_ _1069_ VGND VGND VPWR VPWR _1070_ sky130_fd_sc_hd__nand2_1
X_6234_ clknet_leaf_15_clk _0147_ VGND VGND VPWR VPWR u_interface.core_attn_out\[9\]
+ sky130_fd_sc_hd__dfxtp_1
XFILLER_0_12_277 VGND VGND VPWR VPWR sky130_fd_sc_hd__decap_4
X_3446_ u_interface.u_compute_core.mac_accum\[25\] u_interface.u_compute_core.mac_accum\[24\]
+ _2833_ VGND VGND VPWR VPWR _2896_ sky130_fd_sc_hd__o21a_1
X_6165_ clknet_leaf_2_clk _0078_ VGND VGND VPWR VPWR u_interface.u_compute_core.mac_accum\[19\]
+ sky130_fd_sc_hd__dfxtp_1
X_3377_ net182 _2805_ _2837_ _2741_ VGND VGND VPWR VPWR _0074_ sky130_fd_sc_hd__a22o_1
XFILLER_0_40_3 VPWR VGND VPWR VGND sky130_ef_sc_hd__decap_12
X_5116_ _1680_ _1681_ _1667_ VGND VGND VPWR VPWR _1683_ sky130_fd_sc_hd__a21o_1
X_6096_ clknet_leaf_5_clk _0009_ VGND VGND VPWR VPWR u_interface.u_compute_core.relu_data\[9\]
+ sky130_fd_sc_hd__dfxtp_4
X_5047_ _1614_ _1613_ _1591_ VGND VGND VPWR VPWR _1615_ sky130_fd_sc_hd__and3_1
XTAP_TAPCELL_ROW_68_843 VGND VPWR sky130_fd_sc_hd__tapvpwrvgnd_1
XFILLER_0_67_417 VPWR VGND VPWR VGND sky130_ef_sc_hd__decap_12
X_5949_ _2474_ _2479_ _2477_ VGND VGND VPWR VPWR _2481_ sky130_fd_sc_hd__a21oi_1
XFILLER_0_47_196 VGND VGND VPWR VPWR sky130_fd_sc_hd__fill_1
XFILLER_0_7_293 VGND VGND VPWR VPWR sky130_fd_sc_hd__fill_1
XFILLER_0_62_177 VGND VGND VPWR VPWR sky130_fd_sc_hd__fill_1
XFILLER_0_62_188 VGND VGND VPWR VPWR sky130_fd_sc_hd__decap_3
XTAP_TAPCELL_ROW_89_1045 VGND VPWR sky130_fd_sc_hd__tapvpwrvgnd_1
XFILLER_0_38_141 VPWR VGND VPWR VGND sky130_ef_sc_hd__decap_12
XFILLER_0_81_431 VPWR VGND VPWR VGND sky130_ef_sc_hd__decap_12
XFILLER_0_26_369 VGND VGND VPWR VPWR sky130_fd_sc_hd__fill_1
XFILLER_0_1_447 VGND VGND VPWR VPWR sky130_fd_sc_hd__fill_1
X_3300_ _2769_ _2770_ VGND VGND VPWR VPWR _2771_ sky130_fd_sc_hd__nand2_1
X_4280_ _2615_ _2610_ _0488_ _0534_ VGND VGND VPWR VPWR _0858_ sky130_fd_sc_hd__and4_1
XFILLER_0_39_55 VGND VGND VPWR VPWR sky130_fd_sc_hd__fill_1
X_3231_ u_interface.u_compute_core.scaled_data\[20\] u_interface.u_compute_core.mac_accum\[23\]
+ _2713_ VGND VGND VPWR VPWR _2717_ sky130_fd_sc_hd__mux2_1
XFILLER_0_39_77 VGND VGND VPWR VPWR sky130_fd_sc_hd__decap_3
X_3162_ u_interface.u_compute_core.mac_last VGND VGND VPWR VPWR _2669_ sky130_fd_sc_hd__clkbuf_4
XTAP_TAPCELL_ROW_65_813 VGND VPWR sky130_fd_sc_hd__tapvpwrvgnd_1
X_3093_ _2583_ VGND VGND VPWR VPWR _2618_ sky130_fd_sc_hd__buf_2
XTAP_TAPCELL_ROW_37_548 VGND VPWR sky130_fd_sc_hd__tapvpwrvgnd_1
XTAP_TAPCELL_ROW_73_890 VGND VPWR sky130_fd_sc_hd__tapvpwrvgnd_1
XFILLER_0_71_53 VGND VGND VPWR VPWR sky130_fd_sc_hd__decap_3
X_5803_ net176 _2304_ _0981_ _2353_ VGND VGND VPWR VPWR _0145_ sky130_fd_sc_hd__o211a_1
XFILLER_0_9_503 VGND VGND VPWR VPWR sky130_fd_sc_hd__fill_1
XFILLER_0_91_217 VGND VGND VPWR VPWR sky130_fd_sc_hd__decap_6
XFILLER_0_29_163 VGND VGND VPWR VPWR sky130_fd_sc_hd__decap_4
X_3995_ _0577_ _0578_ _2598_ _0525_ VGND VGND VPWR VPWR _0579_ sky130_fd_sc_hd__and4b_1
XFILLER_0_57_472 VPWR VGND VPWR VGND sky130_ef_sc_hd__decap_12
X_5734_ _1935_ _2232_ _2292_ VGND VGND VPWR VPWR _2293_ sky130_fd_sc_hd__o21a_1
XFILLER_0_72_475 VGND VGND VPWR VPWR sky130_fd_sc_hd__fill_1
XFILLER_0_72_442 VGND VGND VPWR VPWR sky130_fd_sc_hd__decap_8
XFILLER_0_17_369 VPWR VGND VPWR VGND sky130_ef_sc_hd__decap_12
X_5665_ _2223_ _2224_ VGND VGND VPWR VPWR _2225_ sky130_fd_sc_hd__nor2_1
XFILLER_0_88_3 VPWR VGND VPWR VGND sky130_ef_sc_hd__decap_12
X_4616_ _1121_ _1123_ VGND VGND VPWR VPWR _1189_ sky130_fd_sc_hd__nand2_1
XFILLER_0_44_177 VPWR VGND VPWR VGND sky130_ef_sc_hd__decap_12
X_5596_ _1593_ _2085_ _2156_ VGND VGND VPWR VPWR _2157_ sky130_fd_sc_hd__a21bo_1
X_4547_ _0947_ _0948_ _1120_ VGND VGND VPWR VPWR _1121_ sky130_fd_sc_hd__nand3_1
XFILLER_0_20_90 VGND VGND VPWR VPWR sky130_fd_sc_hd__fill_1
X_4478_ _1051_ _1052_ VGND VGND VPWR VPWR _1053_ sky130_fd_sc_hd__or2_1
X_3429_ net215 _2805_ _2880_ _2881_ VGND VGND VPWR VPWR _0082_ sky130_fd_sc_hd__a22o_1
X_6217_ clknet_leaf_11_clk _0130_ VGND VGND VPWR VPWR u_interface.u_compute_core.u_av.product_reg\[24\]
+ sky130_fd_sc_hd__dfxtp_1
X_6148_ clknet_leaf_2_clk _0061_ VGND VGND VPWR VPWR u_interface.u_compute_core.mac_accum\[2\]
+ sky130_fd_sc_hd__dfxtp_1
X_6079_ net49 u_interface.core_attn_out\[29\] u_interface.core_valid_out VGND VGND
+ VPWR VPWR _2574_ sky130_fd_sc_hd__mux2_1
XFILLER_0_67_225 VGND VGND VPWR VPWR sky130_fd_sc_hd__decap_6
XTAP_TAPCELL_ROW_0_195 VGND VPWR sky130_fd_sc_hd__tapvpwrvgnd_1
XFILLER_0_63_442 VGND VGND VPWR VPWR sky130_fd_sc_hd__decap_6
XFILLER_0_35_144 VGND VGND VPWR VPWR sky130_fd_sc_hd__fill_1
XFILLER_0_90_283 VGND VGND VPWR VPWR sky130_fd_sc_hd__fill_2
XFILLER_0_63_475 VGND VGND VPWR VPWR sky130_fd_sc_hd__fill_1
XFILLER_0_23_328 VGND VGND VPWR VPWR sky130_fd_sc_hd__fill_1
XFILLER_0_35_177 VGND VGND VPWR VPWR sky130_fd_sc_hd__decap_3
XTAP_TAPCELL_ROW_79_949 VGND VPWR sky130_fd_sc_hd__tapvpwrvgnd_1
XTAP_TAPCELL_ROW_8_273 VGND VPWR sky130_fd_sc_hd__tapvpwrvgnd_1
XFILLER_0_86_545 VGND VGND VPWR VPWR sky130_fd_sc_hd__fill_2
XTAP_TAPCELL_ROW_34_518 VGND VPWR sky130_fd_sc_hd__tapvpwrvgnd_1
XFILLER_0_39_461 VPWR VGND VPWR VGND sky130_ef_sc_hd__decap_12
XTAP_TAPCELL_ROW_70_860 VGND VPWR sky130_fd_sc_hd__tapvpwrvgnd_1
X_3780_ _0372_ _0373_ VGND VGND VPWR VPWR _0374_ sky130_fd_sc_hd__nand2_1
XTAP_TAPCELL_ROW_42_595 VGND VPWR sky130_fd_sc_hd__tapvpwrvgnd_1
XFILLER_0_81_272 VGND VGND VPWR VPWR sky130_fd_sc_hd__decap_8
X_5450_ _1689_ _2012_ VGND VGND VPWR VPWR _2013_ sky130_fd_sc_hd__xnor2_1
XFILLER_0_14_317 VPWR VGND VPWR VGND sky130_ef_sc_hd__decap_12
X_4401_ _0908_ _0911_ _0977_ VGND VGND VPWR VPWR _0978_ sky130_fd_sc_hd__and3_1
XFILLER_0_1_211 VPWR VGND VPWR VGND sky130_ef_sc_hd__decap_12
X_5381_ _1867_ _1857_ _1944_ VGND VGND VPWR VPWR _1945_ sky130_fd_sc_hd__a21o_1
XFILLER_0_10_545 VGND VGND VPWR VPWR sky130_fd_sc_hd__fill_2
X_4332_ _0847_ _0848_ _0782_ _0849_ VGND VGND VPWR VPWR _0910_ sky130_fd_sc_hd__a211o_4
XFILLER_0_5_23 VGND VGND VPWR VPWR sky130_fd_sc_hd__fill_1
X_4263_ _0839_ _0840_ _0775_ VGND VGND VPWR VPWR _0842_ sky130_fd_sc_hd__a21boi_1
XFILLER_0_66_53 VGND VGND VPWR VPWR sky130_fd_sc_hd__decap_6
X_6002_ _2516_ _2522_ VGND VGND VPWR VPWR _2523_ sky130_fd_sc_hd__and2_1
X_3214_ u_interface.u_compute_core.scaled_data\[15\] u_interface.u_compute_core.mac_accum\[18\]
+ _2691_ VGND VGND VPWR VPWR _2705_ sky130_fd_sc_hd__mux2_1
X_4194_ _0771_ _0772_ _0749_ VGND VGND VPWR VPWR _0774_ sky130_fd_sc_hd__a21oi_1
XPHY_EDGE_ROW_19_Left_112 VGND VGND VPWR VPWR sky130_fd_sc_hd__decap_3
X_3145_ _2643_ _2657_ VGND VGND VPWR VPWR _0022_ sky130_fd_sc_hd__nor2_1
XFILLER_0_82_41 VGND VGND VPWR VPWR sky130_fd_sc_hd__decap_6
X_3076_ _2604_ VGND VGND VPWR VPWR _2605_ sky130_fd_sc_hd__inv_2
XFILLER_0_89_383 VGND VGND VPWR VPWR sky130_fd_sc_hd__fill_1
XFILLER_0_82_74 VGND VGND VPWR VPWR sky130_fd_sc_hd__decap_8
XFILLER_0_82_85 VPWR VGND VPWR VGND sky130_ef_sc_hd__decap_12
XFILLER_0_77_545 VGND VGND VPWR VPWR sky130_fd_sc_hd__fill_2
XFILLER_0_49_225 VGND VGND VPWR VPWR sky130_fd_sc_hd__decap_4
XFILLER_0_9_377 VPWR VGND VPWR VGND sky130_ef_sc_hd__decap_12
X_3978_ _0546_ _0548_ _0561_ VGND VGND VPWR VPWR _0563_ sky130_fd_sc_hd__a21oi_1
XPHY_EDGE_ROW_28_Left_121 VGND VGND VPWR VPWR sky130_fd_sc_hd__decap_3
XFILLER_0_45_453 VPWR VGND VPWR VGND sky130_ef_sc_hd__decap_12
X_5717_ _2271_ _2275_ VGND VGND VPWR VPWR _2276_ sky130_fd_sc_hd__xor2_1
X_5648_ _2192_ _2206_ VGND VGND VPWR VPWR _2208_ sky130_fd_sc_hd__or2_1
XFILLER_0_20_309 VGND VGND VPWR VPWR sky130_fd_sc_hd__decap_6
X_5579_ _2129_ _2139_ VGND VGND VPWR VPWR _2140_ sky130_fd_sc_hd__xnor2_1
XTAP_TAPCELL_ROW_5_243 VGND VPWR sky130_fd_sc_hd__tapvpwrvgnd_1
XPHY_EDGE_ROW_37_Left_130 VGND VGND VPWR VPWR sky130_fd_sc_hd__decap_3
XTAP_TAPCELL_ROW_76_919 VGND VPWR sky130_fd_sc_hd__tapvpwrvgnd_1
XTAP_TAPCELL_ROW_86_1015 VGND VPWR sky130_fd_sc_hd__tapvpwrvgnd_1
XTAP_TAPCELL_ROW_84_996 VGND VPWR sky130_fd_sc_hd__tapvpwrvgnd_1
XFILLER_0_68_545 VGND VGND VPWR VPWR sky130_fd_sc_hd__fill_2
XFILLER_0_70_209 VGND VGND VPWR VPWR sky130_fd_sc_hd__decap_8
XFILLER_0_11_15 VGND VGND VPWR VPWR sky130_fd_sc_hd__fill_2
XFILLER_0_36_475 VGND VGND VPWR VPWR sky130_fd_sc_hd__fill_1
XFILLER_0_36_497 VGND VGND VPWR VPWR sky130_fd_sc_hd__fill_1
XFILLER_0_51_401 VGND VGND VPWR VPWR sky130_fd_sc_hd__fill_2
Xinput8 s_tdata[14] VGND VGND VPWR VPWR net8 sky130_fd_sc_hd__buf_1
XFILLER_0_78_309 VPWR VGND VPWR VGND sky130_ef_sc_hd__decap_12
XTAP_TAPCELL_ROW_47_643 VGND VPWR sky130_fd_sc_hd__tapvpwrvgnd_1
X_4950_ _1438_ _1437_ VGND VGND VPWR VPWR _1519_ sky130_fd_sc_hd__and2b_1
XTAP_TAPCELL_ROW_19_378 VGND VPWR sky130_fd_sc_hd__tapvpwrvgnd_1
X_4881_ _1448_ _1449_ _1447_ VGND VGND VPWR VPWR _1451_ sky130_fd_sc_hd__a21bo_1
X_3901_ net20 VGND VGND VPWR VPWR _0488_ sky130_fd_sc_hd__buf_6
X_3832_ _0423_ _0424_ net148 _2756_ VGND VGND VPWR VPWR _0103_ sky130_fd_sc_hd__a2bb2o_1
XFILLER_0_46_228 VPWR VGND VPWR VGND sky130_ef_sc_hd__decap_12
XFILLER_0_6_325 VGND VGND VPWR VPWR sky130_fd_sc_hd__decap_8
X_5502_ _2644_ _0648_ _1985_ VGND VGND VPWR VPWR _2064_ sky130_fd_sc_hd__and3_1
XFILLER_0_14_103 VGND VGND VPWR VPWR sky130_fd_sc_hd__fill_2
XFILLER_0_6_369 VPWR VGND VPWR VGND sky130_ef_sc_hd__decap_12
X_3763_ _0356_ _0357_ VGND VGND VPWR VPWR _0358_ sky130_fd_sc_hd__nand2_1
X_3694_ _0249_ _0251_ _0252_ VGND VGND VPWR VPWR _0290_ sky130_fd_sc_hd__o21ba_1
X_5433_ net71 VGND VGND VPWR VPWR _1996_ sky130_fd_sc_hd__inv_2
XFILLER_0_2_531 VGND VGND VPWR VPWR sky130_fd_sc_hd__fill_1
XFILLER_0_42_489 VGND VGND VPWR VPWR sky130_fd_sc_hd__fill_1
X_5364_ _1825_ _1838_ _1837_ VGND VGND VPWR VPWR _1928_ sky130_fd_sc_hd__a21boi_2
X_4315_ _0890_ _0891_ _0871_ VGND VGND VPWR VPWR _0893_ sky130_fd_sc_hd__a21o_1
X_5295_ _1042_ VGND VGND VPWR VPWR _1860_ sky130_fd_sc_hd__clkbuf_4
X_4246_ _0822_ _0823_ _0817_ VGND VGND VPWR VPWR _0825_ sky130_fd_sc_hd__a21o_1
X_4177_ u_interface.u_compute_core.relu_data\[7\] _0498_ _0697_ _0696_ VGND VGND VPWR
+ VPWR _0757_ sky130_fd_sc_hd__a31o_1
X_3128_ _2644_ VGND VGND VPWR VPWR _2645_ sky130_fd_sc_hd__inv_2
X_3059_ u_interface.u_compute_core.relu_data\[2\] VGND VGND VPWR VPWR _2592_ sky130_fd_sc_hd__buf_2
XTAP_TAPCELL_ROW_81_966 VGND VPWR sky130_fd_sc_hd__tapvpwrvgnd_1
XFILLER_0_77_364 VGND VGND VPWR VPWR sky130_fd_sc_hd__fill_1
XFILLER_0_9_141 VGND VGND VPWR VPWR sky130_fd_sc_hd__fill_1
XFILLER_0_92_389 VGND VGND VPWR VPWR sky130_fd_sc_hd__decap_3
XFILLER_0_18_475 VGND VGND VPWR VPWR sky130_fd_sc_hd__fill_1
XFILLER_0_45_272 VGND VGND VPWR VPWR sky130_fd_sc_hd__fill_1
XFILLER_0_52_209 VGND VGND VPWR VPWR sky130_fd_sc_hd__decap_6
XFILLER_0_5_391 VGND VGND VPWR VPWR sky130_fd_sc_hd__fill_1
XFILLER_0_33_478 VGND VGND VPWR VPWR sky130_fd_sc_hd__fill_1
XTAP_TAPCELL_ROW_92_1085 VGND VPWR sky130_fd_sc_hd__tapvpwrvgnd_1
XTAP_TAPCELL_ROW_92_1074 VGND VPWR sky130_fd_sc_hd__tapvpwrvgnd_1
XFILLER_0_68_320 VPWR VGND VPWR VGND sky130_ef_sc_hd__decap_12
XTAP_TAPCELL_ROW_44_613 VGND VPWR sky130_fd_sc_hd__tapvpwrvgnd_1
XTAP_TAPCELL_ROW_16_348 VGND VPWR sky130_fd_sc_hd__tapvpwrvgnd_1
XFILLER_0_83_389 VGND VGND VPWR VPWR sky130_fd_sc_hd__decap_3
XFILLER_0_71_529 VPWR VGND VPWR VGND sky130_ef_sc_hd__decap_12
XFILLER_0_22_69 VGND VGND VPWR VPWR sky130_fd_sc_hd__decap_6
XFILLER_0_36_250 VGND VGND VPWR VPWR sky130_fd_sc_hd__fill_2
XTAP_TAPCELL_ROW_52_690 VGND VPWR sky130_fd_sc_hd__tapvpwrvgnd_1
XFILLER_0_3_317 VPWR VGND VPWR VGND sky130_ef_sc_hd__decap_12
XFILLER_0_24_489 VGND VGND VPWR VPWR sky130_fd_sc_hd__decap_3
XFILLER_0_11_106 VGND VGND VPWR VPWR sky130_fd_sc_hd__decap_6
X_5080_ _1645_ _1646_ VGND VGND VPWR VPWR _1647_ sky130_fd_sc_hd__nor2_1
X_4100_ _0679_ _0681_ VGND VGND VPWR VPWR _0682_ sky130_fd_sc_hd__xor2_2
XFILLER_0_47_88 VGND VGND VPWR VPWR sky130_fd_sc_hd__decap_3
X_4031_ _2598_ _0488_ VGND VGND VPWR VPWR _0614_ sky130_fd_sc_hd__nand2_1
X_5982_ u_interface.core_attn_out\[31\] _2308_ _2507_ _2508_ net2 VGND VGND VPWR VPWR
+ _2509_ sky130_fd_sc_hd__a41o_1
X_4933_ _2637_ _0559_ VGND VGND VPWR VPWR _1502_ sky130_fd_sc_hd__nand2_1
XFILLER_0_59_375 VGND VGND VPWR VPWR sky130_fd_sc_hd__fill_1
X_4864_ u_interface.u_compute_core.relu_data\[20\] _0502_ _0495_ u_interface.u_compute_core.relu_data\[19\]
+ VGND VGND VPWR VPWR _1434_ sky130_fd_sc_hd__a22o_1
X_4795_ _1307_ _1364_ VGND VGND VPWR VPWR _1366_ sky130_fd_sc_hd__nor2_1
X_3815_ _0406_ _0407_ VGND VGND VPWR VPWR _0408_ sky130_fd_sc_hd__or2_1
XFILLER_0_62_529 VGND VGND VPWR VPWR sky130_fd_sc_hd__decap_3
X_3746_ _0336_ _0340_ VGND VGND VPWR VPWR _0341_ sky130_fd_sc_hd__xnor2_1
XFILLER_0_15_467 VGND VGND VPWR VPWR sky130_fd_sc_hd__decap_6
XFILLER_0_70_3 VPWR VGND VPWR VGND sky130_ef_sc_hd__decap_12
X_5416_ _1655_ _1978_ VGND VGND VPWR VPWR _1979_ sky130_fd_sc_hd__nor2_1
X_3677_ _0264_ _0272_ VGND VGND VPWR VPWR _0274_ sky130_fd_sc_hd__nand2_1
X_5347_ net118 _1600_ _1910_ VGND VGND VPWR VPWR _1911_ sky130_fd_sc_hd__nand3_1
X_5278_ _1788_ _1787_ _1841_ _1842_ VGND VGND VPWR VPWR _1843_ sky130_fd_sc_hd__o211a_1
X_4229_ _0769_ _0771_ VGND VGND VPWR VPWR _0808_ sky130_fd_sc_hd__nand2_1
XTAP_TAPCELL_ROW_58_749 VGND VPWR sky130_fd_sc_hd__tapvpwrvgnd_1
XFILLER_0_65_312 VGND VGND VPWR VPWR sky130_fd_sc_hd__decap_8
XFILLER_0_92_197 VPWR VGND VPWR VGND sky130_ef_sc_hd__decap_12
XTAP_TAPCELL_ROW_21_395 VGND VPWR sky130_fd_sc_hd__tapvpwrvgnd_1
XFILLER_0_0_309 VGND VGND VPWR VPWR sky130_fd_sc_hd__fill_2
XFILLER_0_33_297 VGND VGND VPWR VPWR sky130_fd_sc_hd__fill_1
XFILLER_0_17_36 VGND VGND VPWR VPWR sky130_fd_sc_hd__fill_2
XTAP_TAPCELL_ROW_29_473 VGND VPWR sky130_fd_sc_hd__tapvpwrvgnd_1
XFILLER_0_68_183 VGND VGND VPWR VPWR sky130_fd_sc_hd__decap_3
XFILLER_0_29_526 VPWR VGND VPWR VGND sky130_ef_sc_hd__decap_12
XFILLER_0_33_35 VGND VGND VPWR VPWR sky130_fd_sc_hd__fill_2
XFILLER_0_56_301 VGND VGND VPWR VPWR sky130_fd_sc_hd__decap_6
XFILLER_0_56_389 VGND VGND VPWR VPWR sky130_fd_sc_hd__decap_3
XFILLER_0_83_186 VGND VGND VPWR VPWR sky130_fd_sc_hd__fill_1
X_4580_ _2628_ _0500_ _1048_ _1047_ VGND VGND VPWR VPWR _1154_ sky130_fd_sc_hd__a31o_1
Xinput22 s_tdata[5] VGND VGND VPWR VPWR net22 sky130_fd_sc_hd__dlymetal6s2s_1
XFILLER_0_71_337 VGND VGND VPWR VPWR sky130_fd_sc_hd__decap_6
XFILLER_0_71_326 VGND VGND VPWR VPWR sky130_fd_sc_hd__fill_1
X_3600_ _3000_ _3036_ VGND VGND VPWR VPWR _3038_ sky130_fd_sc_hd__or2b_1
Xinput11 s_tdata[17] VGND VGND VPWR VPWR net11 sky130_fd_sc_hd__clkbuf_1
X_3531_ _2970_ _2947_ VGND VGND VPWR VPWR _2971_ sky130_fd_sc_hd__nand2_1
XFILLER_0_3_125 VGND VGND VPWR VPWR sky130_fd_sc_hd__fill_1
XFILLER_0_24_253 VGND VGND VPWR VPWR sky130_fd_sc_hd__decap_8
X_6250_ clknet_leaf_13_clk _0163_ VGND VGND VPWR VPWR u_interface.core_attn_out\[25\]
+ sky130_fd_sc_hd__dfxtp_1
X_3462_ _2833_ u_interface.u_compute_core.mac_accum\[28\] VGND VGND VPWR VPWR _2910_
+ sky130_fd_sc_hd__or2_1
X_5201_ _1718_ _1765_ _1766_ VGND VGND VPWR VPWR _1767_ sky130_fd_sc_hd__or3_1
X_6181_ clknet_leaf_22_clk _0094_ VGND VGND VPWR VPWR u_interface.u_compute_core.u_mac.product_reg\[3\]
+ sky130_fd_sc_hd__dfxtp_1
X_3393_ _2832_ u_interface.u_compute_core.mac_accum\[18\] VGND VGND VPWR VPWR _2851_
+ sky130_fd_sc_hd__nand2_1
X_5132_ _1698_ _1638_ VGND VGND VPWR VPWR _1699_ sky130_fd_sc_hd__xnor2_2
Xclkbuf_1_0__f_clk clknet_0_clk VGND VGND VPWR VPWR clknet_1_0__leaf_clk sky130_fd_sc_hd__clkbuf_16
XFILLER_0_58_76 VGND VGND VPWR VPWR sky130_fd_sc_hd__decap_8
X_5063_ _1555_ _1554_ _1479_ VGND VGND VPWR VPWR _1631_ sky130_fd_sc_hd__or3_4
XFILLER_0_74_64 VGND VGND VPWR VPWR sky130_fd_sc_hd__decap_3
X_4014_ u_interface.u_compute_core.relu_data\[0\] _0597_ VGND VGND VPWR VPWR _0598_
+ sky130_fd_sc_hd__nand2_1
XTAP_TAPCELL_ROW_55_719 VGND VPWR sky130_fd_sc_hd__tapvpwrvgnd_1
XFILLER_0_90_41 VPWR VGND VPWR VGND sky130_ef_sc_hd__decap_12
X_5965_ _2493_ _2494_ _2301_ VGND VGND VPWR VPWR _2495_ sky130_fd_sc_hd__o21ai_1
XFILLER_0_90_85 VPWR VGND VPWR VGND sky130_ef_sc_hd__decap_12
X_5896_ net153 VGND VGND VPWR VPWR _2434_ sky130_fd_sc_hd__inv_2
X_4916_ _2736_ _1484_ _1485_ _1337_ VGND VGND VPWR VPWR _0126_ sky130_fd_sc_hd__o211a_1
XTAP_TAPCELL_ROW_63_796 VGND VPWR sky130_fd_sc_hd__tapvpwrvgnd_1
X_4847_ _1191_ _1010_ VGND VGND VPWR VPWR _1417_ sky130_fd_sc_hd__and2b_1
X_4778_ _1264_ _1267_ _1266_ VGND VGND VPWR VPWR _1349_ sky130_fd_sc_hd__a21bo_1
XFILLER_0_7_497 VGND VGND VPWR VPWR sky130_fd_sc_hd__decap_6
X_3729_ _0281_ _0285_ _0323_ VGND VGND VPWR VPWR _0325_ sky130_fd_sc_hd__or3_1
XFILLER_0_70_392 VGND VGND VPWR VPWR sky130_fd_sc_hd__decap_8
XTAP_TAPCELL_ROW_26_443 VGND VPWR sky130_fd_sc_hd__tapvpwrvgnd_1
XFILLER_0_53_315 VGND VGND VPWR VPWR sky130_fd_sc_hd__decap_8
XFILLER_0_80_112 VGND VGND VPWR VPWR sky130_fd_sc_hd__fill_1
XFILLER_0_21_223 VGND VGND VPWR VPWR sky130_fd_sc_hd__fill_1
XFILLER_0_0_139 VGND VGND VPWR VPWR sky130_fd_sc_hd__fill_1
XFILLER_0_0_128 VGND VGND VPWR VPWR sky130_fd_sc_hd__fill_1
XFILLER_0_44_45 VGND VGND VPWR VPWR sky130_fd_sc_hd__decap_4
XFILLER_0_44_56 VGND VGND VPWR VPWR sky130_fd_sc_hd__fill_1
X_5750_ u_interface.core_attn_out\[0\] u_interface.u_compute_core.u_av.product_reg\[3\]
+ _2305_ VGND VGND VPWR VPWR _2307_ sky130_fd_sc_hd__a21oi_1
XFILLER_0_56_131 VGND VGND VPWR VPWR sky130_fd_sc_hd__fill_2
X_4701_ _0835_ _1271_ _1272_ VGND VGND VPWR VPWR _1273_ sky130_fd_sc_hd__nand3_1
XFILLER_0_8_239 VPWR VGND VPWR VGND sky130_ef_sc_hd__decap_12
X_5681_ _2239_ _2240_ VGND VGND VPWR VPWR _2241_ sky130_fd_sc_hd__xnor2_1
XTAP_TAPCELL_ROW_60_766 VGND VPWR sky130_fd_sc_hd__tapvpwrvgnd_1
XFILLER_0_84_484 VGND VGND VPWR VPWR sky130_fd_sc_hd__fill_2
X_4632_ _1164_ _1203_ _1204_ VGND VGND VPWR VPWR _1205_ sky130_fd_sc_hd__nand3_2
XFILLER_0_71_101 VGND VGND VPWR VPWR sky130_fd_sc_hd__fill_2
XFILLER_0_44_348 VGND VGND VPWR VPWR sky130_fd_sc_hd__decap_6
XFILLER_0_4_401 VPWR VGND VPWR VGND sky130_ef_sc_hd__decap_12
X_4563_ _1135_ _1134_ _1117_ VGND VGND VPWR VPWR _1137_ sky130_fd_sc_hd__a21o_1
XFILLER_0_69_31 VGND VGND VPWR VPWR sky130_fd_sc_hd__fill_1
XFILLER_0_8_56 VGND VGND VPWR VPWR sky130_fd_sc_hd__fill_2
XFILLER_0_4_445 VPWR VGND VPWR VGND sky130_ef_sc_hd__decap_12
X_4494_ _1053_ _1067_ VGND VGND VPWR VPWR _1069_ sky130_fd_sc_hd__nand2_1
XFILLER_0_69_75 VPWR VGND VPWR VGND sky130_ef_sc_hd__decap_12
XFILLER_0_12_234 VPWR VGND VPWR VGND sky130_ef_sc_hd__decap_12
XFILLER_0_4_489 VPWR VGND VPWR VGND sky130_ef_sc_hd__decap_12
X_3514_ _2954_ VGND VGND VPWR VPWR _2955_ sky130_fd_sc_hd__inv_2
X_6233_ clknet_leaf_16_clk _0146_ VGND VGND VPWR VPWR u_interface.core_attn_out\[8\]
+ sky130_fd_sc_hd__dfxtp_1
X_3445_ _2887_ _2892_ VGND VGND VPWR VPWR _2895_ sky130_fd_sc_hd__and2_1
X_3376_ _2830_ _2836_ VGND VGND VPWR VPWR _2837_ sky130_fd_sc_hd__xnor2_1
X_6164_ clknet_leaf_1_clk _0077_ VGND VGND VPWR VPWR u_interface.u_compute_core.mac_accum\[18\]
+ sky130_fd_sc_hd__dfxtp_1
XFILLER_0_85_63 VGND VGND VPWR VPWR sky130_fd_sc_hd__decap_4
X_5115_ _1667_ _1680_ _1681_ VGND VGND VPWR VPWR _1682_ sky130_fd_sc_hd__nand3_1
X_6095_ clknet_leaf_5_clk _0008_ VGND VGND VPWR VPWR u_interface.u_compute_core.relu_data\[8\]
+ sky130_fd_sc_hd__dfxtp_2
X_5046_ _1612_ _1611_ _1592_ VGND VGND VPWR VPWR _1614_ sky130_fd_sc_hd__a21o_1
XFILLER_0_85_96 VGND VGND VPWR VPWR sky130_fd_sc_hd__fill_1
XTAP_TAPCELL_ROW_68_844 VGND VPWR sky130_fd_sc_hd__tapvpwrvgnd_1
XFILLER_0_33_3 VGND VGND VPWR VPWR sky130_fd_sc_hd__decap_6
XFILLER_0_79_223 VGND VGND VPWR VPWR sky130_fd_sc_hd__fill_1
XFILLER_0_67_429 VPWR VGND VPWR VGND sky130_ef_sc_hd__decap_12
X_5948_ _2474_ _2477_ _2479_ VGND VGND VPWR VPWR _2480_ sky130_fd_sc_hd__and3_1
XFILLER_0_75_462 VGND VGND VPWR VPWR sky130_fd_sc_hd__fill_1
XFILLER_0_47_153 VGND VGND VPWR VPWR sky130_fd_sc_hd__fill_2
X_5879_ net183 _2309_ _2418_ _2419_ _0855_ VGND VGND VPWR VPWR _0155_ sky130_fd_sc_hd__o221a_1
Xclone58 u_interface.u_compute_core.relu_data\[15\] VGND VGND VPWR VPWR net123 sky130_fd_sc_hd__clkbuf_16
XFILLER_0_7_261 VPWR VGND VPWR VGND sky130_ef_sc_hd__decap_12
XFILLER_0_50_307 VGND VGND VPWR VPWR sky130_fd_sc_hd__fill_1
XTAP_TAPCELL_ROW_31_490 VGND VPWR sky130_fd_sc_hd__tapvpwrvgnd_1
XFILLER_0_31_521 VPWR VGND VPWR VGND sky130_ef_sc_hd__decap_12
XTAP_TAPCELL_ROW_89_1046 VGND VPWR sky130_fd_sc_hd__tapvpwrvgnd_1
XFILLER_0_58_407 VPWR VGND VPWR VGND sky130_ef_sc_hd__decap_12
XFILLER_0_38_153 VGND VGND VPWR VPWR sky130_fd_sc_hd__decap_8
XFILLER_0_38_197 VGND VGND VPWR VPWR sky130_fd_sc_hd__decap_4
XFILLER_0_81_443 VGND VGND VPWR VPWR sky130_fd_sc_hd__decap_4
XFILLER_0_81_487 VPWR VGND VPWR VGND sky130_ef_sc_hd__decap_12
XFILLER_0_53_167 VGND VGND VPWR VPWR sky130_fd_sc_hd__fill_1
X_3230_ _2580_ VGND VGND VPWR VPWR _2716_ sky130_fd_sc_hd__clkbuf_2
X_3161_ _2643_ _2668_ VGND VGND VPWR VPWR _0027_ sky130_fd_sc_hd__nor2_1
XTAP_TAPCELL_ROW_65_814 VGND VPWR sky130_fd_sc_hd__tapvpwrvgnd_1
XFILLER_0_55_55 VGND VGND VPWR VPWR sky130_fd_sc_hd__fill_1
X_3092_ _2609_ _2617_ VGND VGND VPWR VPWR _0009_ sky130_fd_sc_hd__nor2_1
XTAP_TAPCELL_ROW_37_549 VGND VPWR sky130_fd_sc_hd__tapvpwrvgnd_1
XFILLER_0_49_429 VGND VGND VPWR VPWR sky130_fd_sc_hd__decap_8
XFILLER_0_71_43 VGND VGND VPWR VPWR sky130_fd_sc_hd__fill_1
X_5802_ _2351_ _2352_ _2309_ VGND VGND VPWR VPWR _2353_ sky130_fd_sc_hd__o21ai_1
XTAP_TAPCELL_ROW_73_891 VGND VPWR sky130_fd_sc_hd__tapvpwrvgnd_1
X_3994_ _2604_ _0492_ _0503_ net95 VGND VGND VPWR VPWR _0578_ sky130_fd_sc_hd__a22o_1
XFILLER_0_91_229 VGND VGND VPWR VPWR sky130_fd_sc_hd__fill_1
XFILLER_0_72_421 VGND VGND VPWR VPWR sky130_fd_sc_hd__decap_8
X_5733_ _2229_ _2230_ _1639_ VGND VGND VPWR VPWR _2292_ sky130_fd_sc_hd__a21o_1
XFILLER_0_57_484 VGND VGND VPWR VPWR sky130_fd_sc_hd__decap_8
X_5664_ _2215_ _2216_ _2222_ VGND VGND VPWR VPWR _2224_ sky130_fd_sc_hd__a21oi_1
X_4615_ _1130_ _1132_ VGND VGND VPWR VPWR _1188_ sky130_fd_sc_hd__nand2_1
X_5595_ _1977_ _1979_ _1999_ VGND VGND VPWR VPWR _2156_ sky130_fd_sc_hd__o21ai_2
XFILLER_0_32_307 VGND VGND VPWR VPWR sky130_fd_sc_hd__fill_1
XFILLER_0_44_189 VGND VGND VPWR VPWR sky130_fd_sc_hd__decap_6
X_4546_ _0988_ _1055_ _1054_ _2615_ VGND VGND VPWR VPWR _1120_ sky130_fd_sc_hd__a22o_1
XFILLER_0_13_521 VPWR VGND VPWR VGND sky130_ef_sc_hd__decap_12
XFILLER_0_4_253 VPWR VGND VPWR VGND sky130_ef_sc_hd__decap_12
XFILLER_0_20_80 VGND VGND VPWR VPWR sky130_fd_sc_hd__fill_1
X_4477_ _0985_ _1050_ VGND VGND VPWR VPWR _1052_ sky130_fd_sc_hd__nor2_1
X_3428_ _2878_ _2879_ _2740_ VGND VGND VPWR VPWR _2881_ sky130_fd_sc_hd__o21a_1
X_6216_ clknet_leaf_11_clk _0129_ VGND VGND VPWR VPWR u_interface.u_compute_core.u_av.product_reg\[23\]
+ sky130_fd_sc_hd__dfxtp_1
X_6147_ clknet_leaf_22_clk _0060_ VGND VGND VPWR VPWR u_interface.u_compute_core.mac_accum\[1\]
+ sky130_fd_sc_hd__dfxtp_1
X_3359_ _2818_ _2821_ VGND VGND VPWR VPWR _2822_ sky130_fd_sc_hd__xnor2_1
X_6078_ _2573_ VGND VGND VPWR VPWR _0200_ sky130_fd_sc_hd__clkbuf_1
X_5029_ _2631_ net123 _0656_ VGND VGND VPWR VPWR _1597_ sky130_fd_sc_hd__o21ai_4
XTAP_TAPCELL_ROW_0_196 VGND VPWR sky130_fd_sc_hd__tapvpwrvgnd_1
XFILLER_0_82_218 VGND VGND VPWR VPWR sky130_fd_sc_hd__decap_6
XFILLER_0_75_281 VPWR VGND VPWR VGND sky130_ef_sc_hd__decap_12
XFILLER_0_35_167 VGND VGND VPWR VPWR sky130_fd_sc_hd__fill_1
XTAP_TAPCELL_ROW_8_274 VGND VPWR sky130_fd_sc_hd__tapvpwrvgnd_1
XTAP_TAPCELL_ROW_34_519 VGND VPWR sky130_fd_sc_hd__tapvpwrvgnd_1
XFILLER_0_58_259 VGND VGND VPWR VPWR sky130_fd_sc_hd__fill_2
XTAP_TAPCELL_ROW_70_861 VGND VPWR sky130_fd_sc_hd__tapvpwrvgnd_1
XFILLER_0_39_473 VPWR VGND VPWR VGND sky130_ef_sc_hd__decap_12
XFILLER_0_54_421 VPWR VGND VPWR VGND sky130_ef_sc_hd__decap_12
XFILLER_0_26_134 VGND VGND VPWR VPWR sky130_fd_sc_hd__fill_1
XTAP_TAPCELL_ROW_42_596 VGND VPWR sky130_fd_sc_hd__tapvpwrvgnd_1
XFILLER_0_14_329 VGND VGND VPWR VPWR sky130_fd_sc_hd__decap_3
X_4400_ _0975_ net79 VGND VGND VPWR VPWR _0977_ sky130_fd_sc_hd__nor2_1
XFILLER_0_1_223 VGND VGND VPWR VPWR sky130_fd_sc_hd__fill_1
X_5380_ _1042_ _1943_ VGND VGND VPWR VPWR _1944_ sky130_fd_sc_hd__xnor2_1
XFILLER_0_22_395 VGND VGND VPWR VPWR sky130_fd_sc_hd__decap_8
X_4331_ _0905_ _0906_ _0907_ VGND VGND VPWR VPWR _0909_ sky130_fd_sc_hd__a21o_1
X_4262_ _0775_ _0839_ _0840_ VGND VGND VPWR VPWR _0841_ sky130_fd_sc_hd__and3b_2
X_6001_ net53 u_interface.core_attn_out\[3\] _2521_ VGND VGND VPWR VPWR _2522_ sky130_fd_sc_hd__mux2_1
X_3213_ _2704_ VGND VGND VPWR VPWR _0043_ sky130_fd_sc_hd__clkbuf_1
X_4193_ _0749_ _0771_ _0772_ VGND VGND VPWR VPWR _0773_ sky130_fd_sc_hd__and3_1
X_3144_ u_interface.u_compute_core.scaled_data\[22\] _2583_ _2656_ _2586_ VGND VGND
+ VPWR VPWR _2657_ sky130_fd_sc_hd__o2bb2a_1
X_3075_ u_interface.u_compute_core.relu_data\[6\] VGND VGND VPWR VPWR _2604_ sky130_fd_sc_hd__buf_8
XFILLER_0_77_513 VPWR VGND VPWR VGND sky130_ef_sc_hd__decap_12
XFILLER_0_82_97 VPWR VGND VPWR VGND sky130_ef_sc_hd__decap_12
XFILLER_0_49_237 VGND VGND VPWR VPWR sky130_fd_sc_hd__decap_4
XFILLER_0_92_505 VPWR VGND VPWR VGND sky130_ef_sc_hd__decap_12
X_3977_ _0546_ _0548_ _0561_ VGND VGND VPWR VPWR _0562_ sky130_fd_sc_hd__and3_1
XFILLER_0_57_270 VGND VGND VPWR VPWR sky130_fd_sc_hd__decap_8
XFILLER_0_57_281 VPWR VGND VPWR VGND sky130_ef_sc_hd__decap_12
XFILLER_0_9_389 VGND VGND VPWR VPWR sky130_fd_sc_hd__decap_3
XFILLER_0_45_432 VGND VGND VPWR VPWR sky130_fd_sc_hd__fill_2
X_5716_ _2272_ _2274_ VGND VGND VPWR VPWR _2275_ sky130_fd_sc_hd__xnor2_1
XFILLER_0_72_251 VGND VGND VPWR VPWR sky130_fd_sc_hd__fill_1
XFILLER_0_17_167 VGND VGND VPWR VPWR sky130_fd_sc_hd__fill_1
XFILLER_0_45_465 VGND VGND VPWR VPWR sky130_fd_sc_hd__decap_6
X_5647_ _2192_ _2206_ VGND VGND VPWR VPWR _2207_ sky130_fd_sc_hd__nand2_1
X_5578_ _2130_ _2138_ VGND VGND VPWR VPWR _2139_ sky130_fd_sc_hd__xor2_1
X_4529_ _0962_ _1029_ _1103_ VGND VGND VPWR VPWR _1104_ sky130_fd_sc_hd__o21ai_1
XFILLER_0_13_384 VGND VGND VPWR VPWR sky130_fd_sc_hd__decap_8
XTAP_TAPCELL_ROW_5_244 VGND VPWR sky130_fd_sc_hd__tapvpwrvgnd_1
XTAP_TAPCELL_ROW_86_1016 VGND VPWR sky130_fd_sc_hd__tapvpwrvgnd_1
XTAP_TAPCELL_ROW_84_997 VGND VPWR sky130_fd_sc_hd__tapvpwrvgnd_1
XFILLER_0_83_505 VPWR VGND VPWR VGND sky130_ef_sc_hd__decap_12
XFILLER_0_51_446 VGND VGND VPWR VPWR sky130_fd_sc_hd__fill_2
XFILLER_0_31_181 VGND VGND VPWR VPWR sky130_fd_sc_hd__fill_2
Xinput9 s_tdata[15] VGND VGND VPWR VPWR net9 sky130_fd_sc_hd__dlymetal6s2s_1
XTAP_TAPCELL_ROW_47_644 VGND VPWR sky130_fd_sc_hd__tapvpwrvgnd_1
XFILLER_0_59_502 VGND VGND VPWR VPWR sky130_fd_sc_hd__fill_2
XFILLER_0_86_321 VGND VGND VPWR VPWR sky130_fd_sc_hd__decap_4
XTAP_TAPCELL_ROW_19_379 VGND VPWR sky130_fd_sc_hd__tapvpwrvgnd_1
XFILLER_0_86_365 VGND VGND VPWR VPWR sky130_fd_sc_hd__decap_6
X_4880_ _1447_ _1448_ _1449_ VGND VGND VPWR VPWR _1450_ sky130_fd_sc_hd__nand3b_1
X_3900_ u_interface.u_compute_core.relu_data\[0\] VGND VGND VPWR VPWR _0487_ sky130_fd_sc_hd__buf_2
X_3831_ _0390_ _0394_ _0422_ _2754_ VGND VGND VPWR VPWR _0424_ sky130_fd_sc_hd__a31o_1
X_3762_ _0354_ _0355_ VGND VGND VPWR VPWR _0357_ sky130_fd_sc_hd__nand2_1
XFILLER_0_54_240 VGND VGND VPWR VPWR sky130_fd_sc_hd__fill_1
X_5501_ _1872_ _1969_ _2062_ VGND VGND VPWR VPWR _2063_ sky130_fd_sc_hd__a21o_1
X_3693_ _0256_ _0260_ _0288_ VGND VGND VPWR VPWR _0289_ sky130_fd_sc_hd__a21oi_1
X_5432_ _1898_ _1900_ VGND VGND VPWR VPWR _1995_ sky130_fd_sc_hd__and2_1
XFILLER_0_42_457 VPWR VGND VPWR VGND sky130_ef_sc_hd__decap_12
X_5363_ _1924_ _1925_ _1823_ _1841_ VGND VGND VPWR VPWR _1927_ sky130_fd_sc_hd__o211a_1
XTAP_TAPCELL_ROW_10_290 VGND VPWR sky130_fd_sc_hd__tapvpwrvgnd_1
XFILLER_0_77_31 VPWR VGND VPWR VGND sky130_ef_sc_hd__decap_12
X_4314_ _0871_ _0890_ _0891_ VGND VGND VPWR VPWR _0892_ sky130_fd_sc_hd__nand3_1
XFILLER_0_10_365 VPWR VGND VPWR VGND sky130_ef_sc_hd__decap_12
X_5294_ _1857_ _1858_ VGND VGND VPWR VPWR _1859_ sky130_fd_sc_hd__and2_1
X_4245_ _0817_ _0822_ _0823_ VGND VGND VPWR VPWR _0824_ sky130_fd_sc_hd__nand3_1
X_4176_ _0714_ _0716_ VGND VGND VPWR VPWR _0756_ sky130_fd_sc_hd__nand2_1
X_3127_ u_interface.u_compute_core.relu_data\[18\] VGND VGND VPWR VPWR _2644_ sky130_fd_sc_hd__clkbuf_4
XTAP_TAPCELL_ROW_2_214 VGND VPWR sky130_fd_sc_hd__tapvpwrvgnd_1
X_3058_ _2582_ _2591_ VGND VGND VPWR VPWR _0001_ sky130_fd_sc_hd__nor2_1
XTAP_TAPCELL_ROW_81_967 VGND VPWR sky130_fd_sc_hd__tapvpwrvgnd_1
XFILLER_0_65_527 VPWR VGND VPWR VGND sky130_ef_sc_hd__decap_12
XFILLER_0_37_229 VGND VGND VPWR VPWR sky130_fd_sc_hd__fill_1
XFILLER_0_18_421 VPWR VGND VPWR VGND sky130_ef_sc_hd__decap_12
XFILLER_0_80_519 VPWR VGND VPWR VGND sky130_ef_sc_hd__decap_12
XFILLER_0_33_446 VGND VGND VPWR VPWR sky130_fd_sc_hd__fill_2
XFILLER_0_60_243 VGND VGND VPWR VPWR sky130_fd_sc_hd__decap_8
XTAP_TAPCELL_ROW_92_1086 VGND VPWR sky130_fd_sc_hd__tapvpwrvgnd_1
XTAP_TAPCELL_ROW_92_1075 VGND VPWR sky130_fd_sc_hd__tapvpwrvgnd_1
XFILLER_0_68_332 VPWR VGND VPWR VGND sky130_ef_sc_hd__decap_12
XTAP_TAPCELL_ROW_44_614 VGND VPWR sky130_fd_sc_hd__tapvpwrvgnd_1
XFILLER_0_68_365 VPWR VGND VPWR VGND sky130_ef_sc_hd__decap_12
XFILLER_0_83_324 VPWR VGND VPWR VGND sky130_ef_sc_hd__decap_12
XTAP_TAPCELL_ROW_16_349 VGND VPWR sky130_fd_sc_hd__tapvpwrvgnd_1
XFILLER_0_83_357 VGND VGND VPWR VPWR sky130_fd_sc_hd__decap_6
XFILLER_0_24_402 VGND VGND VPWR VPWR sky130_fd_sc_hd__fill_1
XTAP_TAPCELL_ROW_52_691 VGND VPWR sky130_fd_sc_hd__tapvpwrvgnd_1
XFILLER_0_51_221 VGND VGND VPWR VPWR sky130_fd_sc_hd__decap_3
XFILLER_0_3_329 VGND VGND VPWR VPWR sky130_fd_sc_hd__decap_6
XPHY_EDGE_ROW_10_Right_10 VGND VGND VPWR VPWR sky130_fd_sc_hd__decap_3
X_4030_ _0612_ _0515_ VGND VGND VPWR VPWR _0613_ sky130_fd_sc_hd__nand2_1
X_5981_ _2502_ _2497_ _2503_ _2504_ VGND VGND VPWR VPWR _2508_ sky130_fd_sc_hd__a31oi_1
XFILLER_0_2_69 VGND VGND VPWR VPWR sky130_fd_sc_hd__fill_1
XPHY_EDGE_ROW_56_Left_149 VGND VGND VPWR VPWR sky130_fd_sc_hd__decap_3
X_4932_ _1492_ _1500_ VGND VGND VPWR VPWR _1501_ sky130_fd_sc_hd__xnor2_1
XFILLER_0_47_505 VPWR VGND VPWR VGND sky130_ef_sc_hd__decap_12
XFILLER_0_63_88 VGND VGND VPWR VPWR sky130_fd_sc_hd__decap_8
XFILLER_0_74_335 VGND VGND VPWR VPWR sky130_fd_sc_hd__decap_8
X_4863_ u_interface.u_compute_core.relu_data\[20\] u_interface.u_compute_core.relu_data\[19\]
+ _0502_ _0495_ VGND VGND VPWR VPWR _1433_ sky130_fd_sc_hd__and4_1
X_4794_ _1307_ _1364_ VGND VGND VPWR VPWR _1365_ sky130_fd_sc_hd__and2_1
X_3814_ _0395_ _0373_ _0405_ VGND VGND VPWR VPWR _0407_ sky130_fd_sc_hd__and3_1
XFILLER_0_6_112 VPWR VGND VPWR VGND sky130_ef_sc_hd__decap_12
XFILLER_0_62_508 VGND VGND VPWR VPWR sky130_fd_sc_hd__fill_2
XFILLER_0_70_530 VGND VGND VPWR VPWR sky130_fd_sc_hd__fill_2
XFILLER_0_15_424 VGND VGND VPWR VPWR sky130_fd_sc_hd__decap_4
X_3745_ _0304_ _0339_ VGND VGND VPWR VPWR _0340_ sky130_fd_sc_hd__xnor2_1
XFILLER_0_27_284 VPWR VGND VPWR VGND sky130_ef_sc_hd__decap_12
XFILLER_0_88_41 VPWR VGND VPWR VGND sky130_ef_sc_hd__decap_12
X_5415_ _1976_ _1977_ VGND VGND VPWR VPWR _1978_ sky130_fd_sc_hd__or2_1
XPHY_EDGE_ROW_65_Left_158 VGND VGND VPWR VPWR sky130_fd_sc_hd__decap_3
X_3676_ _0264_ _0272_ VGND VGND VPWR VPWR _0273_ sky130_fd_sc_hd__nor2_1
XFILLER_0_42_265 VGND VGND VPWR VPWR sky130_fd_sc_hd__fill_1
XFILLER_0_42_276 VGND VGND VPWR VPWR sky130_fd_sc_hd__decap_6
XFILLER_0_88_85 VGND VGND VPWR VPWR sky130_fd_sc_hd__decap_6
XFILLER_0_63_3 VPWR VGND VPWR VGND sky130_ef_sc_hd__decap_12
X_5346_ _1655_ _1802_ _1803_ VGND VGND VPWR VPWR _1910_ sky130_fd_sc_hd__o21bai_1
X_5277_ _1823_ _1824_ _1839_ _1840_ VGND VGND VPWR VPWR _1842_ sky130_fd_sc_hd__a22o_1
X_4228_ _0805_ _0806_ VGND VGND VPWR VPWR _0807_ sky130_fd_sc_hd__or2_1
XPHY_EDGE_ROW_74_Left_167 VGND VGND VPWR VPWR sky130_fd_sc_hd__decap_3
X_4159_ _0699_ _0725_ VGND VGND VPWR VPWR _0739_ sky130_fd_sc_hd__or2_1
XFILLER_0_77_151 VPWR VGND VPWR VGND sky130_ef_sc_hd__decap_12
XTAP_TAPCELL_ROW_13_319 VGND VPWR sky130_fd_sc_hd__tapvpwrvgnd_1
XFILLER_0_92_165 VGND VGND VPWR VPWR sky130_fd_sc_hd__decap_3
XPHY_EDGE_ROW_83_Left_176 VGND VGND VPWR VPWR sky130_fd_sc_hd__decap_3
XFILLER_0_18_295 VGND VGND VPWR VPWR sky130_fd_sc_hd__fill_2
XTAP_TAPCELL_ROW_21_396 VGND VPWR sky130_fd_sc_hd__tapvpwrvgnd_1
XFILLER_0_21_438 VGND VGND VPWR VPWR sky130_fd_sc_hd__decap_8
XPHY_EDGE_ROW_92_Left_185 VGND VGND VPWR VPWR sky130_fd_sc_hd__decap_3
XTAP_TAPCELL_ROW_29_474 VGND VPWR sky130_fd_sc_hd__tapvpwrvgnd_1
XPHY_EDGE_ROW_1_Left_94 VGND VGND VPWR VPWR sky130_fd_sc_hd__decap_3
XFILLER_0_29_505 VGND VGND VPWR VPWR sky130_fd_sc_hd__fill_2
XFILLER_0_29_538 VGND VGND VPWR VPWR sky130_fd_sc_hd__decap_4
Xinput12 s_tdata[18] VGND VGND VPWR VPWR net12 sky130_fd_sc_hd__clkbuf_1
Xinput23 s_tdata[6] VGND VGND VPWR VPWR net23 sky130_fd_sc_hd__buf_1
X_3530_ net6 VGND VGND VPWR VPWR _2970_ sky130_fd_sc_hd__buf_2
X_3461_ _2834_ u_interface.u_compute_core.mac_accum\[28\] VGND VGND VPWR VPWR _2909_
+ sky130_fd_sc_hd__nand2_2
X_5200_ _1763_ _1764_ _1719_ _1720_ VGND VGND VPWR VPWR _1766_ sky130_fd_sc_hd__a211oi_1
X_6180_ clknet_leaf_22_clk _0093_ VGND VGND VPWR VPWR u_interface.u_compute_core.u_mac.product_reg\[2\]
+ sky130_fd_sc_hd__dfxtp_1
X_3392_ u_interface.u_compute_core.u_mac.product_reg\[15\] u_interface.u_compute_core.mac_accum\[18\]
+ VGND VGND VPWR VPWR _2850_ sky130_fd_sc_hd__or2_1
X_5131_ _1641_ _1697_ VGND VGND VPWR VPWR _1698_ sky130_fd_sc_hd__xnor2_2
X_5062_ _1629_ _1628_ VGND VGND VPWR VPWR _1630_ sky130_fd_sc_hd__xnor2_2
X_4013_ _0596_ VGND VGND VPWR VPWR _0597_ sky130_fd_sc_hd__clkbuf_4
XFILLER_0_79_405 VPWR VGND VPWR VGND sky130_ef_sc_hd__decap_12
XFILLER_0_79_449 VGND VGND VPWR VPWR sky130_fd_sc_hd__fill_2
XFILLER_0_90_53 VPWR VGND VPWR VGND sky130_ef_sc_hd__decap_12
X_5964_ _2483_ _2489_ _2492_ VGND VGND VPWR VPWR _2494_ sky130_fd_sc_hd__a21oi_1
Xclkbuf_leaf_17_clk clknet_1_1__leaf_clk VGND VGND VPWR VPWR clknet_leaf_17_clk sky130_fd_sc_hd__clkbuf_8
XFILLER_0_90_97 VPWR VGND VPWR VGND sky130_ef_sc_hd__decap_12
XFILLER_0_74_121 VGND VGND VPWR VPWR sky130_fd_sc_hd__decap_4
XTAP_TAPCELL_ROW_63_797 VGND VPWR sky130_fd_sc_hd__tapvpwrvgnd_1
X_5895_ net202 _2309_ _2430_ _2433_ _0486_ VGND VGND VPWR VPWR _0157_ sky130_fd_sc_hd__o221a_1
X_4915_ _0915_ net209 VGND VGND VPWR VPWR _1485_ sky130_fd_sc_hd__or2_1
XFILLER_0_47_335 VGND VGND VPWR VPWR sky130_fd_sc_hd__fill_1
XFILLER_0_59_195 VGND VGND VPWR VPWR sky130_fd_sc_hd__fill_2
X_4846_ net120 _1373_ _1415_ VGND VGND VPWR VPWR _1416_ sky130_fd_sc_hd__a21o_1
X_4777_ _1345_ _1346_ _1343_ VGND VGND VPWR VPWR _1348_ sky130_fd_sc_hd__o21ai_1
X_3728_ _0281_ _0285_ _0323_ VGND VGND VPWR VPWR _0324_ sky130_fd_sc_hd__o21ai_2
XFILLER_0_30_213 VGND VGND VPWR VPWR sky130_fd_sc_hd__fill_2
X_3659_ _0254_ _0255_ VGND VGND VPWR VPWR _0256_ sky130_fd_sc_hd__xor2_1
XFILLER_0_2_170 VGND VGND VPWR VPWR sky130_fd_sc_hd__fill_1
XFILLER_0_2_181 VGND VGND VPWR VPWR sky130_fd_sc_hd__decap_8
X_5329_ _1806_ _1807_ _1808_ VGND VGND VPWR VPWR _1893_ sky130_fd_sc_hd__o21bai_1
XTAP_TAPCELL_ROW_26_444 VGND VPWR sky130_fd_sc_hd__tapvpwrvgnd_1
XFILLER_0_34_541 VGND VGND VPWR VPWR sky130_fd_sc_hd__fill_2
XFILLER_0_61_371 VPWR VGND VPWR VGND sky130_ef_sc_hd__decap_12
XFILLER_0_61_393 VGND VGND VPWR VPWR sky130_fd_sc_hd__decap_8
XFILLER_0_28_47 VGND VGND VPWR VPWR sky130_fd_sc_hd__fill_1
XFILLER_0_28_58 VGND VGND VPWR VPWR sky130_fd_sc_hd__fill_1
XFILLER_0_44_35 VGND VGND VPWR VPWR sky130_fd_sc_hd__fill_1
XFILLER_0_69_482 VPWR VGND VPWR VGND sky130_ef_sc_hd__decap_12
X_4700_ _1268_ _1269_ _1270_ VGND VGND VPWR VPWR _1272_ sky130_fd_sc_hd__o21ai_1
X_5680_ _2172_ _2173_ _2177_ VGND VGND VPWR VPWR _2240_ sky130_fd_sc_hd__o21ba_1
X_4631_ _1201_ _1202_ _0835_ VGND VGND VPWR VPWR _1204_ sky130_fd_sc_hd__a21o_1
XFILLER_0_71_113 VGND VGND VPWR VPWR sky130_fd_sc_hd__fill_2
XFILLER_0_60_89 VGND VGND VPWR VPWR sky130_fd_sc_hd__fill_1
XTAP_TAPCELL_ROW_60_767 VGND VPWR sky130_fd_sc_hd__tapvpwrvgnd_1
XFILLER_0_4_413 VGND VGND VPWR VPWR sky130_fd_sc_hd__decap_6
X_4562_ _1117_ _1134_ _1135_ VGND VGND VPWR VPWR _1136_ sky130_fd_sc_hd__nand3_2
XFILLER_0_12_202 VGND VGND VPWR VPWR sky130_fd_sc_hd__decap_6
XFILLER_0_4_457 VPWR VGND VPWR VGND sky130_ef_sc_hd__decap_12
XFILLER_0_40_500 VGND VGND VPWR VPWR sky130_fd_sc_hd__fill_1
X_4493_ _1053_ _1067_ VGND VGND VPWR VPWR _1068_ sky130_fd_sc_hd__or2_4
X_3513_ _2946_ _2948_ _2952_ _2953_ VGND VGND VPWR VPWR _2954_ sky130_fd_sc_hd__and4_1
XFILLER_0_12_246 VGND VGND VPWR VPWR sky130_fd_sc_hd__decap_6
XFILLER_0_40_533 VPWR VGND VPWR VGND sky130_ef_sc_hd__decap_12
Xclkbuf_leaf_6_clk clknet_1_0__leaf_clk VGND VGND VPWR VPWR clknet_leaf_6_clk sky130_fd_sc_hd__clkbuf_8
XFILLER_0_69_87 VPWR VGND VPWR VGND sky130_ef_sc_hd__decap_12
X_6232_ clknet_leaf_16_clk _0145_ VGND VGND VPWR VPWR u_interface.core_attn_out\[7\]
+ sky130_fd_sc_hd__dfxtp_1
X_3444_ _2890_ _2893_ _2894_ _2867_ net178 VGND VGND VPWR VPWR _0084_ sky130_fd_sc_hd__a32o_1
X_3375_ _2831_ _2835_ VGND VGND VPWR VPWR _2836_ sky130_fd_sc_hd__nand2_1
X_6163_ clknet_leaf_1_clk _0076_ VGND VGND VPWR VPWR u_interface.u_compute_core.mac_accum\[17\]
+ sky130_fd_sc_hd__dfxtp_1
X_5114_ _1678_ _1679_ _1588_ VGND VGND VPWR VPWR _1681_ sky130_fd_sc_hd__a21o_1
X_6094_ clknet_leaf_5_clk _0007_ VGND VGND VPWR VPWR u_interface.u_compute_core.relu_data\[7\]
+ sky130_fd_sc_hd__dfxtp_2
X_5045_ _1592_ _1611_ _1612_ VGND VGND VPWR VPWR _1613_ sky130_fd_sc_hd__nand3_1
XTAP_TAPCELL_ROW_68_845 VGND VPWR sky130_fd_sc_hd__tapvpwrvgnd_1
XFILLER_0_79_202 VGND VGND VPWR VPWR sky130_fd_sc_hd__fill_1
XFILLER_0_26_3 VGND VGND VPWR VPWR sky130_fd_sc_hd__decap_8
XFILLER_0_79_268 VGND VGND VPWR VPWR sky130_fd_sc_hd__fill_1
X_5947_ _2455_ _2464_ _2461_ _2470_ _2478_ VGND VGND VPWR VPWR _2479_ sky130_fd_sc_hd__a311o_1
XTAP_TAPCELL_ROW_23_414 VGND VPWR sky130_fd_sc_hd__tapvpwrvgnd_1
X_5878_ _2407_ _2411_ _2417_ _2318_ VGND VGND VPWR VPWR _2419_ sky130_fd_sc_hd__a31o_1
XFILLER_0_7_273 VGND VGND VPWR VPWR sky130_fd_sc_hd__decap_6
X_4829_ _0918_ _1398_ _1399_ VGND VGND VPWR VPWR _1400_ sky130_fd_sc_hd__or3_4
XFILLER_0_62_135 VGND VGND VPWR VPWR sky130_fd_sc_hd__fill_1
XFILLER_0_62_157 VGND VGND VPWR VPWR sky130_fd_sc_hd__fill_2
XFILLER_0_90_477 VPWR VGND VPWR VGND sky130_ef_sc_hd__decap_12
XTAP_TAPCELL_ROW_31_491 VGND VPWR sky130_fd_sc_hd__tapvpwrvgnd_1
XFILLER_0_31_533 VGND VGND VPWR VPWR sky130_fd_sc_hd__decap_8
XTAP_TAPCELL_ROW_89_1047 VGND VPWR sky130_fd_sc_hd__tapvpwrvgnd_1
XFILLER_0_58_419 VGND VGND VPWR VPWR sky130_fd_sc_hd__fill_1
XFILLER_0_38_121 VPWR VGND VPWR VGND sky130_ef_sc_hd__decap_12
XFILLER_0_53_113 VGND VGND VPWR VPWR sky130_fd_sc_hd__fill_2
XFILLER_0_19_390 VGND VGND VPWR VPWR sky130_fd_sc_hd__fill_2
XFILLER_0_30_15 VPWR VGND VPWR VGND sky130_ef_sc_hd__decap_12
XFILLER_0_81_499 VGND VGND VPWR VPWR sky130_fd_sc_hd__decap_4
XFILLER_0_1_405 VPWR VGND VPWR VGND sky130_ef_sc_hd__decap_12
XFILLER_0_22_533 VGND VGND VPWR VPWR sky130_fd_sc_hd__decap_8
XFILLER_0_1_449 VPWR VGND VPWR VGND sky130_ef_sc_hd__decap_12
XFILLER_0_39_57 VPWR VGND VPWR VGND sky130_ef_sc_hd__decap_12
X_3160_ u_interface.u_compute_core.scaled_data\[27\] _2583_ _2587_ _2667_ VGND VGND
+ VPWR VPWR _2668_ sky130_fd_sc_hd__o2bb2a_1
X_3091_ u_interface.u_compute_core.scaled_data\[9\] _2584_ _2616_ _2613_ VGND VGND
+ VPWR VPWR _2617_ sky130_fd_sc_hd__o2bb2a_1
XTAP_TAPCELL_ROW_65_815 VGND VPWR sky130_fd_sc_hd__tapvpwrvgnd_1
XFILLER_0_49_419 VGND VGND VPWR VPWR sky130_fd_sc_hd__fill_1
X_5801_ _2348_ _2349_ _2350_ VGND VGND VPWR VPWR _2352_ sky130_fd_sc_hd__a21oi_1
XFILLER_0_9_505 VPWR VGND VPWR VGND sky130_ef_sc_hd__decap_12
XPHY_EDGE_ROW_8_Right_8 VGND VGND VPWR VPWR sky130_fd_sc_hd__decap_3
XFILLER_0_57_430 VGND VGND VPWR VPWR sky130_fd_sc_hd__decap_8
XFILLER_0_91_208 VGND VGND VPWR VPWR sky130_fd_sc_hd__decap_6
XTAP_TAPCELL_ROW_73_892 VGND VPWR sky130_fd_sc_hd__tapvpwrvgnd_1
X_5732_ _2223_ _2224_ _2227_ _2228_ _2290_ VGND VGND VPWR VPWR _2291_ sky130_fd_sc_hd__o32a_1
X_3993_ _2604_ net86 _0492_ _0503_ VGND VGND VPWR VPWR _0577_ sky130_fd_sc_hd__and4_1
XFILLER_0_84_271 VGND VGND VPWR VPWR sky130_fd_sc_hd__fill_1
X_5663_ _2215_ _2216_ _2222_ VGND VGND VPWR VPWR _2223_ sky130_fd_sc_hd__and3_1
XFILLER_0_4_210 VGND VGND VPWR VPWR sky130_fd_sc_hd__fill_2
X_4614_ _2736_ _1186_ _1187_ net61 VGND VGND VPWR VPWR _0122_ sky130_fd_sc_hd__o211a_1
X_5594_ _2152_ _2154_ VGND VGND VPWR VPWR _2155_ sky130_fd_sc_hd__xor2_1
X_4545_ _1080_ _1082_ VGND VGND VPWR VPWR _1119_ sky130_fd_sc_hd__nand2_1
XFILLER_0_13_533 VPWR VGND VPWR VGND sky130_ef_sc_hd__decap_12
XFILLER_0_4_265 VPWR VGND VPWR VGND sky130_ef_sc_hd__decap_12
XFILLER_0_40_330 VPWR VGND VPWR VGND sky130_ef_sc_hd__decap_12
XFILLER_0_40_363 VGND VGND VPWR VPWR sky130_fd_sc_hd__fill_1
X_4476_ _0985_ _1050_ VGND VGND VPWR VPWR _1051_ sky130_fd_sc_hd__and2_1
X_6215_ clknet_leaf_11_clk _0128_ VGND VGND VPWR VPWR u_interface.u_compute_core.u_av.product_reg\[22\]
+ sky130_fd_sc_hd__dfxtp_1
X_3427_ _2878_ _2879_ VGND VGND VPWR VPWR _2880_ sky130_fd_sc_hd__nand2_1
XPHY_EDGE_ROW_39_Right_39 VGND VGND VPWR VPWR sky130_fd_sc_hd__decap_3
X_6146_ clknet_leaf_22_clk _0059_ VGND VGND VPWR VPWR u_interface.u_compute_core.mac_accum\[0\]
+ sky130_fd_sc_hd__dfxtp_1
X_3358_ _2819_ _2820_ VGND VGND VPWR VPWR _2821_ sky130_fd_sc_hd__nor2_1
X_6077_ _2670_ _2572_ VGND VGND VPWR VPWR _2573_ sky130_fd_sc_hd__and2_1
X_3289_ _2761_ VGND VGND VPWR VPWR _2762_ sky130_fd_sc_hd__inv_2
X_5028_ _2634_ net119 _0632_ VGND VGND VPWR VPWR _1596_ sky130_fd_sc_hd__and3_4
XTAP_TAPCELL_ROW_0_186 VGND VPWR sky130_fd_sc_hd__tapvpwrvgnd_1
XTAP_TAPCELL_ROW_0_197 VGND VPWR sky130_fd_sc_hd__tapvpwrvgnd_1
XPHY_EDGE_ROW_48_Right_48 VGND VGND VPWR VPWR sky130_fd_sc_hd__decap_3
XFILLER_0_0_91 VGND VGND VPWR VPWR sky130_fd_sc_hd__decap_3
XFILLER_0_75_293 VGND VGND VPWR VPWR sky130_fd_sc_hd__decap_3
XFILLER_0_16_360 VGND VGND VPWR VPWR sky130_fd_sc_hd__decap_4
XFILLER_0_23_319 VGND VGND VPWR VPWR sky130_fd_sc_hd__fill_2
XFILLER_0_16_382 VGND VGND VPWR VPWR sky130_fd_sc_hd__decap_6
XPHY_EDGE_ROW_57_Right_57 VGND VGND VPWR VPWR sky130_fd_sc_hd__decap_3
XTAP_TAPCELL_ROW_8_275 VGND VPWR sky130_fd_sc_hd__tapvpwrvgnd_1
XFILLER_0_25_15 VGND VGND VPWR VPWR sky130_fd_sc_hd__decap_4
XFILLER_0_86_503 VGND VGND VPWR VPWR sky130_fd_sc_hd__fill_1
XFILLER_0_58_216 VPWR VGND VPWR VGND sky130_ef_sc_hd__decap_12
XPHY_EDGE_ROW_66_Right_66 VGND VGND VPWR VPWR sky130_fd_sc_hd__decap_3
XFILLER_0_73_219 VGND VGND VPWR VPWR sky130_fd_sc_hd__decap_4
XTAP_TAPCELL_ROW_70_862 VGND VPWR sky130_fd_sc_hd__tapvpwrvgnd_1
XFILLER_0_26_102 VGND VGND VPWR VPWR sky130_fd_sc_hd__decap_3
XFILLER_0_26_113 VGND VGND VPWR VPWR sky130_fd_sc_hd__decap_8
XFILLER_0_39_485 VPWR VGND VPWR VGND sky130_ef_sc_hd__decap_12
XTAP_TAPCELL_ROW_42_597 VGND VPWR sky130_fd_sc_hd__tapvpwrvgnd_1
XFILLER_0_54_433 VPWR VGND VPWR VGND sky130_ef_sc_hd__decap_12
XFILLER_0_26_179 VPWR VGND VPWR VGND sky130_ef_sc_hd__decap_12
XFILLER_0_81_296 VPWR VGND VPWR VGND sky130_ef_sc_hd__decap_12
XFILLER_0_41_138 VGND VGND VPWR VPWR sky130_fd_sc_hd__decap_8
XPHY_EDGE_ROW_75_Right_75 VGND VGND VPWR VPWR sky130_fd_sc_hd__decap_3
XFILLER_0_22_363 VGND VGND VPWR VPWR sky130_fd_sc_hd__fill_1
X_4330_ _0905_ _0906_ _0907_ VGND VGND VPWR VPWR _0908_ sky130_fd_sc_hd__nand3_2
XFILLER_0_5_36 VPWR VGND VPWR VGND sky130_ef_sc_hd__decap_12
XFILLER_0_1_279 VGND VGND VPWR VPWR sky130_fd_sc_hd__fill_1
X_4261_ _0837_ _0838_ _0807_ VGND VGND VPWR VPWR _0840_ sky130_fd_sc_hd__o21ai_1
X_6000_ u_interface.core_valid_out VGND VGND VPWR VPWR _2521_ sky130_fd_sc_hd__clkbuf_4
XFILLER_0_5_69 VGND VGND VPWR VPWR sky130_fd_sc_hd__decap_8
X_3212_ _2694_ _2703_ VGND VGND VPWR VPWR _2704_ sky130_fd_sc_hd__and2_1
X_4192_ _0769_ _0770_ _0754_ VGND VGND VPWR VPWR _0772_ sky130_fd_sc_hd__a21o_1
XTAP_TAPCELL_ROW_78_940 VGND VPWR sky130_fd_sc_hd__tapvpwrvgnd_1
X_3143_ _2655_ VGND VGND VPWR VPWR _2656_ sky130_fd_sc_hd__inv_2
XPHY_EDGE_ROW_84_Right_84 VGND VGND VPWR VPWR sky130_fd_sc_hd__decap_3
X_3074_ _2582_ _2603_ VGND VGND VPWR VPWR _0005_ sky130_fd_sc_hd__nor2_1
XFILLER_0_77_525 VPWR VGND VPWR VGND sky130_ef_sc_hd__decap_12
XFILLER_0_49_216 VGND VGND VPWR VPWR sky130_fd_sc_hd__fill_1
XFILLER_0_92_517 VPWR VGND VPWR VGND sky130_ef_sc_hd__decap_12
XFILLER_0_17_102 VGND VGND VPWR VPWR sky130_fd_sc_hd__decap_8
XFILLER_0_17_113 VPWR VGND VPWR VGND sky130_ef_sc_hd__decap_12
X_3976_ _0555_ _0560_ VGND VGND VPWR VPWR _0561_ sky130_fd_sc_hd__xnor2_1
XFILLER_0_57_260 VGND VGND VPWR VPWR sky130_fd_sc_hd__decap_3
X_5715_ _2199_ _2203_ _2273_ VGND VGND VPWR VPWR _2274_ sky130_fd_sc_hd__o21ba_1
XFILLER_0_57_293 VGND VGND VPWR VPWR sky130_fd_sc_hd__fill_1
XFILLER_0_5_541 VGND VGND VPWR VPWR sky130_fd_sc_hd__decap_6
X_5646_ _2197_ _2205_ VGND VGND VPWR VPWR _2206_ sky130_fd_sc_hd__xnor2_1
X_5577_ _2136_ _2137_ VGND VGND VPWR VPWR _2138_ sky130_fd_sc_hd__nor2_1
XFILLER_0_60_458 VGND VGND VPWR VPWR sky130_fd_sc_hd__decap_6
X_4528_ _0964_ _1028_ VGND VGND VPWR VPWR _1103_ sky130_fd_sc_hd__nand2_1
X_4459_ _0970_ _0983_ _1033_ VGND VGND VPWR VPWR _1035_ sky130_fd_sc_hd__or3_1
XTAP_TAPCELL_ROW_5_245 VGND VPWR sky130_fd_sc_hd__tapvpwrvgnd_1
X_6129_ clknet_leaf_4_clk _0042_ VGND VGND VPWR VPWR u_interface.u_compute_core.scaled_data\[13\]
+ sky130_fd_sc_hd__dfxtp_1
XTAP_TAPCELL_ROW_86_1017 VGND VPWR sky130_fd_sc_hd__tapvpwrvgnd_1
XTAP_TAPCELL_ROW_84_998 VGND VPWR sky130_fd_sc_hd__tapvpwrvgnd_1
XFILLER_0_83_517 VPWR VGND VPWR VGND sky130_ef_sc_hd__decap_12
XFILLER_0_8_390 VGND VGND VPWR VPWR sky130_fd_sc_hd__decap_6
XFILLER_0_23_105 VGND VGND VPWR VPWR sky130_fd_sc_hd__decap_6
XTAP_TAPCELL_ROW_75_910 VGND VPWR sky130_fd_sc_hd__tapvpwrvgnd_1
XTAP_TAPCELL_ROW_47_645 VGND VPWR sky130_fd_sc_hd__tapvpwrvgnd_1
X_3830_ _0390_ _0394_ _0422_ VGND VGND VPWR VPWR _0423_ sky130_fd_sc_hd__a21oi_1
X_3761_ _0354_ _0355_ VGND VGND VPWR VPWR _0356_ sky130_fd_sc_hd__or2_1
XFILLER_0_6_349 VPWR VGND VPWR VGND sky130_ef_sc_hd__decap_12
XFILLER_0_54_263 VGND VGND VPWR VPWR sky130_fd_sc_hd__fill_2
X_5500_ _1970_ _1964_ VGND VGND VPWR VPWR _2062_ sky130_fd_sc_hd__and2b_1
XFILLER_0_14_116 VPWR VGND VPWR VGND sky130_ef_sc_hd__decap_12
X_3692_ _0254_ _0255_ VGND VGND VPWR VPWR _0288_ sky130_fd_sc_hd__and2_1
X_5431_ _1916_ _1918_ VGND VGND VPWR VPWR _1994_ sky130_fd_sc_hd__nand2_1
XFILLER_0_2_533 VPWR VGND VPWR VGND sky130_ef_sc_hd__decap_12
XFILLER_0_42_469 VGND VGND VPWR VPWR sky130_fd_sc_hd__decap_6
X_5362_ _1823_ _1841_ _1924_ _1925_ VGND VGND VPWR VPWR _1926_ sky130_fd_sc_hd__a211oi_1
XTAP_TAPCELL_ROW_10_291 VGND VPWR sky130_fd_sc_hd__tapvpwrvgnd_1
XFILLER_0_77_43 VPWR VGND VPWR VGND sky130_ef_sc_hd__decap_12
XFILLER_0_10_322 VPWR VGND VPWR VGND sky130_ef_sc_hd__decap_12
X_4313_ _0888_ _0889_ _0813_ VGND VGND VPWR VPWR _0891_ sky130_fd_sc_hd__a21o_1
XFILLER_0_77_65 VGND VGND VPWR VPWR sky130_fd_sc_hd__decap_8
XFILLER_0_10_377 VGND VGND VPWR VPWR sky130_fd_sc_hd__decap_8
X_5293_ _1042_ _1856_ VGND VGND VPWR VPWR _1858_ sky130_fd_sc_hd__or2_1
X_4244_ _0821_ _0820_ _0818_ VGND VGND VPWR VPWR _0823_ sky130_fd_sc_hd__a21o_1
X_4175_ _0712_ _0719_ _0718_ VGND VGND VPWR VPWR _0755_ sky130_fd_sc_hd__a21bo_1
XTAP_TAPCELL_ROW_2_215 VGND VPWR sky130_fd_sc_hd__tapvpwrvgnd_1
X_3126_ _2581_ VGND VGND VPWR VPWR _2643_ sky130_fd_sc_hd__buf_2
XFILLER_0_26_80 VGND VGND VPWR VPWR sky130_fd_sc_hd__decap_4
X_3057_ u_interface.u_compute_core.scaled_data\[1\] _2584_ _2590_ _2587_ VGND VGND
+ VPWR VPWR _2591_ sky130_fd_sc_hd__o2bb2a_1
XFILLER_0_77_344 VPWR VGND VPWR VGND sky130_ef_sc_hd__decap_12
XTAP_TAPCELL_ROW_81_968 VGND VPWR sky130_fd_sc_hd__tapvpwrvgnd_1
XFILLER_0_65_539 VGND VGND VPWR VPWR sky130_fd_sc_hd__decap_8
XFILLER_0_37_219 VGND VGND VPWR VPWR sky130_fd_sc_hd__decap_4
XFILLER_0_18_433 VGND VGND VPWR VPWR sky130_fd_sc_hd__decap_6
XFILLER_0_9_198 VGND VGND VPWR VPWR sky130_fd_sc_hd__decap_3
XFILLER_0_18_477 VGND VGND VPWR VPWR sky130_fd_sc_hd__decap_4
X_3959_ _0485_ net169 _0486_ _0544_ VGND VGND VPWR VPWR _0110_ sky130_fd_sc_hd__o211a_1
XFILLER_0_60_222 VGND VGND VPWR VPWR sky130_fd_sc_hd__fill_2
X_5629_ _0521_ net199 _2188_ _2189_ _0855_ VGND VGND VPWR VPWR _0135_ sky130_fd_sc_hd__o221a_1
XFILLER_0_13_160 VGND VGND VPWR VPWR sky130_fd_sc_hd__decap_8
XFILLER_0_5_393 VPWR VGND VPWR VGND sky130_ef_sc_hd__decap_12
XTAP_TAPCELL_ROW_92_1087 VGND VPWR sky130_fd_sc_hd__tapvpwrvgnd_1
XTAP_TAPCELL_ROW_92_1076 VGND VPWR sky130_fd_sc_hd__tapvpwrvgnd_1
XFILLER_0_87_119 VGND VGND VPWR VPWR sky130_fd_sc_hd__decap_8
XFILLER_0_68_344 VGND VGND VPWR VPWR sky130_fd_sc_hd__decap_8
XTAP_TAPCELL_ROW_44_615 VGND VPWR sky130_fd_sc_hd__tapvpwrvgnd_1
XFILLER_0_68_377 VGND VGND VPWR VPWR sky130_fd_sc_hd__decap_8
XTAP_TAPCELL_ROW_52_692 VGND VPWR sky130_fd_sc_hd__tapvpwrvgnd_1
XFILLER_0_51_233 VGND VGND VPWR VPWR sky130_fd_sc_hd__decap_6
XFILLER_0_2_15 VPWR VGND VPWR VGND sky130_ef_sc_hd__decap_12
X_5980_ u_interface.core_attn_out\[30\] u_interface.u_compute_core.u_av.product_reg\[31\]
+ VGND VGND VPWR VPWR _2507_ sky130_fd_sc_hd__nand2_1
X_4931_ _1493_ _1499_ VGND VGND VPWR VPWR _1500_ sky130_fd_sc_hd__xnor2_1
XFILLER_0_59_344 VGND VGND VPWR VPWR sky130_fd_sc_hd__decap_4
X_4862_ _2637_ _0536_ VGND VGND VPWR VPWR _1432_ sky130_fd_sc_hd__nand2_1
XFILLER_0_47_517 VGND VGND VPWR VPWR sky130_fd_sc_hd__decap_6
X_3813_ _0395_ _0373_ _0405_ VGND VGND VPWR VPWR _0406_ sky130_fd_sc_hd__a21oi_1
X_4793_ _1360_ _1363_ VGND VGND VPWR VPWR _1364_ sky130_fd_sc_hd__xor2_1
XFILLER_0_6_124 VGND VGND VPWR VPWR sky130_fd_sc_hd__decap_8
X_3744_ _0300_ _0337_ _0338_ VGND VGND VPWR VPWR _0339_ sky130_fd_sc_hd__a21oi_1
XFILLER_0_27_296 VGND VGND VPWR VPWR sky130_fd_sc_hd__decap_6
X_3675_ _0267_ _0271_ VGND VGND VPWR VPWR _0272_ sky130_fd_sc_hd__xnor2_1
XFILLER_0_88_53 VPWR VGND VPWR VGND sky130_ef_sc_hd__decap_12
X_5414_ u_interface.u_compute_core.relu_data\[20\] u_interface.u_compute_core.relu_data\[19\]
+ _0633_ VGND VGND VPWR VPWR _1977_ sky130_fd_sc_hd__and3_1
XFILLER_0_2_363 VGND VGND VPWR VPWR sky130_fd_sc_hd__fill_1
X_5345_ _1596_ net118 VGND VGND VPWR VPWR _1909_ sky130_fd_sc_hd__or2b_1
XFILLER_0_56_3 VPWR VGND VPWR VGND sky130_ef_sc_hd__decap_12
X_5276_ _1823_ _1824_ _1839_ _1840_ VGND VGND VPWR VPWR _1841_ sky130_fd_sc_hd__nand4_2
X_4227_ _0802_ _0804_ _0801_ VGND VGND VPWR VPWR _0806_ sky130_fd_sc_hd__a21oi_1
X_4158_ _0724_ _0701_ VGND VGND VPWR VPWR _0738_ sky130_fd_sc_hd__or2b_1
X_3109_ _2609_ _2630_ VGND VGND VPWR VPWR _0013_ sky130_fd_sc_hd__nor2_1
X_4089_ _0614_ _0616_ _0615_ VGND VGND VPWR VPWR _0671_ sky130_fd_sc_hd__o21bai_1
XFILLER_0_77_174 VPWR VGND VPWR VGND sky130_ef_sc_hd__decap_12
XFILLER_0_77_163 VGND VGND VPWR VPWR sky130_fd_sc_hd__fill_1
XFILLER_0_18_241 VGND VGND VPWR VPWR sky130_fd_sc_hd__decap_4
XFILLER_0_73_391 VGND VGND VPWR VPWR sky130_fd_sc_hd__fill_1
XTAP_TAPCELL_ROW_21_397 VGND VPWR sky130_fd_sc_hd__tapvpwrvgnd_1
XFILLER_0_88_417 VGND VGND VPWR VPWR sky130_fd_sc_hd__decap_3
XFILLER_0_17_49 VGND VGND VPWR VPWR sky130_fd_sc_hd__decap_3
XTAP_TAPCELL_ROW_57_740 VGND VPWR sky130_fd_sc_hd__tapvpwrvgnd_1
XTAP_TAPCELL_ROW_29_475 VGND VPWR sky130_fd_sc_hd__tapvpwrvgnd_1
XFILLER_0_83_111 VGND VGND VPWR VPWR sky130_fd_sc_hd__fill_1
Xinput13 s_tdata[19] VGND VGND VPWR VPWR net13 sky130_fd_sc_hd__buf_1
Xinput24 s_tdata[8] VGND VGND VPWR VPWR net24 sky130_fd_sc_hd__buf_2
XFILLER_0_52_531 VGND VGND VPWR VPWR sky130_fd_sc_hd__fill_1
XFILLER_0_3_149 VGND VGND VPWR VPWR sky130_fd_sc_hd__fill_2
X_3460_ _2900_ _2895_ _2903_ _2907_ VGND VGND VPWR VPWR _2908_ sky130_fd_sc_hd__a31o_1
XFILLER_0_20_450 VGND VGND VPWR VPWR sky130_fd_sc_hd__fill_1
X_3391_ u_interface.u_compute_core.mac_accum\[17\] u_interface.u_compute_core.mac_accum\[16\]
+ _2834_ VGND VGND VPWR VPWR _2849_ sky130_fd_sc_hd__o21ai_1
X_5130_ _1695_ _1696_ VGND VGND VPWR VPWR _1697_ sky130_fd_sc_hd__nor2_1
X_5061_ _1549_ _1551_ VGND VGND VPWR VPWR _1629_ sky130_fd_sc_hd__and2b_1
X_4012_ _0595_ VGND VGND VPWR VPWR _0596_ sky130_fd_sc_hd__buf_2
XFILLER_0_79_417 VGND VGND VPWR VPWR sky130_fd_sc_hd__fill_1
X_5963_ _2483_ _2489_ _2492_ VGND VGND VPWR VPWR _2493_ sky130_fd_sc_hd__and3_1
XFILLER_0_87_483 VPWR VGND VPWR VGND sky130_ef_sc_hd__decap_12
X_4914_ _1479_ _1483_ VGND VGND VPWR VPWR _1484_ sky130_fd_sc_hd__xor2_1
XFILLER_0_59_152 VPWR VGND VPWR VGND sky130_ef_sc_hd__decap_12
XFILLER_0_90_65 VPWR VGND VPWR VGND sky130_ef_sc_hd__decap_12
XTAP_TAPCELL_ROW_63_798 VGND VPWR sky130_fd_sc_hd__tapvpwrvgnd_1
X_5894_ _2427_ _2432_ _2301_ VGND VGND VPWR VPWR _2433_ sky130_fd_sc_hd__o21ai_1
X_4845_ _2619_ _1369_ VGND VGND VPWR VPWR _1415_ sky130_fd_sc_hd__and2_1
X_4776_ _1343_ _1345_ _1346_ VGND VGND VPWR VPWR _1347_ sky130_fd_sc_hd__or3_4
X_3727_ _0321_ _0322_ VGND VGND VPWR VPWR _0323_ sky130_fd_sc_hd__and2_1
XFILLER_0_55_391 VGND VGND VPWR VPWR sky130_fd_sc_hd__fill_1
XFILLER_0_70_361 VGND VGND VPWR VPWR sky130_fd_sc_hd__decap_3
XFILLER_0_70_383 VGND VGND VPWR VPWR sky130_fd_sc_hd__fill_1
X_3658_ _2929_ _3012_ _0217_ VGND VGND VPWR VPWR _0255_ sky130_fd_sc_hd__a21oi_1
X_3589_ net24 net17 _3026_ VGND VGND VPWR VPWR _3027_ sky130_fd_sc_hd__and3_1
X_5328_ _1889_ _1890_ _1806_ VGND VGND VPWR VPWR _1892_ sky130_fd_sc_hd__o21ai_1
X_5259_ _1821_ _1822_ _1789_ VGND VGND VPWR VPWR _1824_ sky130_fd_sc_hd__o21ai_1
XTAP_TAPCELL_ROW_54_710 VGND VPWR sky130_fd_sc_hd__tapvpwrvgnd_1
XTAP_TAPCELL_ROW_26_445 VGND VPWR sky130_fd_sc_hd__tapvpwrvgnd_1
XFILLER_0_38_303 VGND VGND VPWR VPWR sky130_fd_sc_hd__decap_4
XFILLER_0_78_494 VGND VGND VPWR VPWR sky130_fd_sc_hd__decap_8
XFILLER_0_65_100 VPWR VGND VPWR VGND sky130_ef_sc_hd__decap_12
XFILLER_0_80_147 VGND VGND VPWR VPWR sky130_fd_sc_hd__fill_2
XFILLER_0_21_225 VGND VGND VPWR VPWR sky130_fd_sc_hd__decap_6
XFILLER_0_61_383 VGND VGND VPWR VPWR sky130_fd_sc_hd__decap_8
XFILLER_0_28_15 VPWR VGND VPWR VGND sky130_ef_sc_hd__decap_12
XFILLER_0_88_214 VGND VGND VPWR VPWR sky130_fd_sc_hd__decap_8
XFILLER_0_69_461 VPWR VGND VPWR VGND sky130_ef_sc_hd__decap_12
XFILLER_0_69_494 VGND VGND VPWR VPWR sky130_fd_sc_hd__decap_4
X_4630_ _0835_ _1201_ _1202_ VGND VGND VPWR VPWR _1203_ sky130_fd_sc_hd__nand3_1
XFILLER_0_56_188 VGND VGND VPWR VPWR sky130_fd_sc_hd__fill_1
XTAP_TAPCELL_ROW_60_768 VGND VPWR sky130_fd_sc_hd__tapvpwrvgnd_1
XFILLER_0_37_391 VGND VGND VPWR VPWR sky130_fd_sc_hd__fill_1
X_4561_ _1133_ _1132_ _1071_ VGND VGND VPWR VPWR _1135_ sky130_fd_sc_hd__a21o_1
X_4492_ _1066_ _1057_ VGND VGND VPWR VPWR _1067_ sky130_fd_sc_hd__xnor2_1
X_3512_ _2950_ _2951_ _2938_ VGND VGND VPWR VPWR _2953_ sky130_fd_sc_hd__a21bo_1
XFILLER_0_4_469 VGND VGND VPWR VPWR sky130_fd_sc_hd__decap_6
XFILLER_0_40_545 VGND VGND VPWR VPWR sky130_fd_sc_hd__fill_2
XFILLER_0_69_99 VPWR VGND VPWR VGND sky130_ef_sc_hd__decap_12
X_6231_ clknet_leaf_16_clk _0144_ VGND VGND VPWR VPWR u_interface.core_attn_out\[6\]
+ sky130_fd_sc_hd__dfxtp_1
X_3443_ _2891_ _2887_ _2892_ VGND VGND VPWR VPWR _2894_ sky130_fd_sc_hd__o21ai_1
X_6162_ clknet_leaf_1_clk _0075_ VGND VGND VPWR VPWR u_interface.u_compute_core.mac_accum\[16\]
+ sky130_fd_sc_hd__dfxtp_1
X_5113_ _1588_ _1678_ _1679_ VGND VGND VPWR VPWR _1680_ sky130_fd_sc_hd__nand3_1
X_3374_ _2834_ u_interface.u_compute_core.mac_accum\[15\] VGND VGND VPWR VPWR _2835_
+ sky130_fd_sc_hd__or2_1
X_6093_ clknet_leaf_4_clk _0006_ VGND VGND VPWR VPWR u_interface.u_compute_core.relu_data\[6\]
+ sky130_fd_sc_hd__dfxtp_4
X_5044_ _1610_ _1609_ _1515_ VGND VGND VPWR VPWR _1612_ sky130_fd_sc_hd__a21o_1
XTAP_TAPCELL_ROW_68_846 VGND VPWR sky130_fd_sc_hd__tapvpwrvgnd_1
XFILLER_0_79_225 VGND VGND VPWR VPWR sky130_fd_sc_hd__decap_4
XFILLER_0_19_3 VGND VGND VPWR VPWR sky130_fd_sc_hd__decap_6
X_5946_ _2460_ VGND VGND VPWR VPWR _2478_ sky130_fd_sc_hd__inv_2
XTAP_TAPCELL_ROW_23_415 VGND VPWR sky130_fd_sc_hd__tapvpwrvgnd_1
X_5877_ _2407_ _2411_ _2417_ VGND VGND VPWR VPWR _2418_ sky130_fd_sc_hd__a21oi_1
X_4828_ _1397_ net133 _1340_ _1341_ VGND VGND VPWR VPWR _1399_ sky130_fd_sc_hd__o211a_4
XFILLER_0_62_114 VGND VGND VPWR VPWR sky130_fd_sc_hd__fill_1
Xclone49 u_interface.u_compute_core.relu_data\[11\] VGND VGND VPWR VPWR net114 sky130_fd_sc_hd__buf_4
XFILLER_0_16_531 VGND VGND VPWR VPWR sky130_fd_sc_hd__fill_1
XFILLER_0_90_489 VPWR VGND VPWR VGND sky130_ef_sc_hd__decap_12
XTAP_TAPCELL_ROW_31_492 VGND VPWR sky130_fd_sc_hd__tapvpwrvgnd_1
X_4759_ _1180_ _1181_ _1255_ _1256_ VGND VGND VPWR VPWR _1331_ sky130_fd_sc_hd__or4_4
XTAP_TAPCELL_ROW_89_1048 VGND VPWR sky130_fd_sc_hd__tapvpwrvgnd_1
XTAP_TAPCELL_ROW_39_570 VGND VPWR sky130_fd_sc_hd__tapvpwrvgnd_1
XFILLER_0_78_280 VGND VGND VPWR VPWR sky130_fd_sc_hd__fill_2
XFILLER_0_38_133 VGND VGND VPWR VPWR sky130_fd_sc_hd__decap_6
XFILLER_0_26_306 VGND VGND VPWR VPWR sky130_fd_sc_hd__fill_2
XFILLER_0_30_27 VGND VGND VPWR VPWR sky130_fd_sc_hd__fill_1
XFILLER_0_81_467 VPWR VGND VPWR VGND sky130_ef_sc_hd__decap_12
XFILLER_0_41_309 VGND VGND VPWR VPWR sky130_fd_sc_hd__decap_3
XFILLER_0_1_417 VPWR VGND VPWR VGND sky130_ef_sc_hd__decap_12
XFILLER_0_39_69 VGND VGND VPWR VPWR sky130_fd_sc_hd__decap_8
X_3090_ _2615_ VGND VGND VPWR VPWR _2616_ sky130_fd_sc_hd__inv_2
XFILLER_0_55_57 VPWR VGND VPWR VGND sky130_ef_sc_hd__decap_12
XTAP_TAPCELL_ROW_65_816 VGND VPWR sky130_fd_sc_hd__tapvpwrvgnd_1
X_5800_ _2348_ _2349_ _2350_ VGND VGND VPWR VPWR _2351_ sky130_fd_sc_hd__and3_1
XFILLER_0_9_517 VPWR VGND VPWR VGND sky130_ef_sc_hd__decap_12
XFILLER_0_29_111 VGND VGND VPWR VPWR sky130_fd_sc_hd__fill_1
X_3992_ _2585_ _0574_ _0575_ VGND VGND VPWR VPWR _0576_ sky130_fd_sc_hd__o21ai_1
XTAP_TAPCELL_ROW_73_893 VGND VPWR sky130_fd_sc_hd__tapvpwrvgnd_1
X_5731_ _2233_ VGND VGND VPWR VPWR _2290_ sky130_fd_sc_hd__inv_2
XFILLER_0_44_136 VGND VGND VPWR VPWR sky130_fd_sc_hd__decap_4
X_5662_ _2217_ _2221_ VGND VGND VPWR VPWR _2222_ sky130_fd_sc_hd__xnor2_1
XFILLER_0_72_467 VGND VGND VPWR VPWR sky130_fd_sc_hd__decap_8
X_4613_ _0915_ u_interface.u_compute_core.u_av.product_reg\[16\] VGND VGND VPWR VPWR
+ _1187_ sky130_fd_sc_hd__or2_1
X_5593_ _2153_ _2074_ VGND VGND VPWR VPWR _2154_ sky130_fd_sc_hd__nand2_1
X_4544_ _1076_ _1085_ _1084_ VGND VGND VPWR VPWR _1118_ sky130_fd_sc_hd__a21bo_1
XFILLER_0_13_545 VGND VGND VPWR VPWR sky130_fd_sc_hd__fill_2
XFILLER_0_4_277 VPWR VGND VPWR VGND sky130_ef_sc_hd__decap_12
XFILLER_0_40_342 VGND VGND VPWR VPWR sky130_fd_sc_hd__fill_1
X_4475_ _1046_ _1049_ VGND VGND VPWR VPWR _1050_ sky130_fd_sc_hd__xnor2_1
X_6214_ clknet_leaf_11_clk _0127_ VGND VGND VPWR VPWR u_interface.u_compute_core.u_av.product_reg\[21\]
+ sky130_fd_sc_hd__dfxtp_1
XFILLER_0_0_461 VGND VGND VPWR VPWR sky130_fd_sc_hd__decap_4
X_3426_ _2873_ _2875_ _2872_ VGND VGND VPWR VPWR _2879_ sky130_fd_sc_hd__a21o_1
X_6145_ clknet_leaf_18_clk _0058_ VGND VGND VPWR VPWR u_interface.u_compute_core.u_av.valid_a
+ sky130_fd_sc_hd__dfxtp_1
X_3357_ u_interface.u_compute_core.u_mac.product_reg\[13\] u_interface.u_compute_core.mac_accum\[13\]
+ VGND VGND VPWR VPWR _2820_ sky130_fd_sc_hd__nor2_1
X_6076_ net48 u_interface.core_attn_out\[28\] u_interface.core_valid_out VGND VGND
+ VPWR VPWR _2572_ sky130_fd_sc_hd__mux2_1
X_5027_ _1594_ VGND VGND VPWR VPWR _1595_ sky130_fd_sc_hd__inv_2
X_3288_ _2757_ _2758_ _2759_ VGND VGND VPWR VPWR _2761_ sky130_fd_sc_hd__and3_1
XTAP_TAPCELL_ROW_0_187 VGND VPWR sky130_fd_sc_hd__tapvpwrvgnd_1
XTAP_TAPCELL_ROW_36_540 VGND VPWR sky130_fd_sc_hd__tapvpwrvgnd_1
XTAP_TAPCELL_ROW_0_198 VGND VPWR sky130_fd_sc_hd__tapvpwrvgnd_1
X_5929_ _2447_ _2456_ VGND VGND VPWR VPWR _2463_ sky130_fd_sc_hd__nand2_1
XFILLER_0_35_103 VGND VGND VPWR VPWR sky130_fd_sc_hd__fill_2
XFILLER_0_48_475 VGND VGND VPWR VPWR sky130_fd_sc_hd__fill_1
XFILLER_0_35_169 VGND VGND VPWR VPWR sky130_fd_sc_hd__decap_8
XFILLER_0_50_128 VGND VGND VPWR VPWR sky130_fd_sc_hd__fill_2
XFILLER_0_31_353 VGND VGND VPWR VPWR sky130_fd_sc_hd__fill_1
XFILLER_0_8_3 VGND VGND VPWR VPWR sky130_fd_sc_hd__decap_8
XTAP_TAPCELL_ROW_8_276 VGND VPWR sky130_fd_sc_hd__tapvpwrvgnd_1
XFILLER_0_58_228 VPWR VGND VPWR VGND sky130_ef_sc_hd__decap_12
XTAP_TAPCELL_ROW_70_863 VGND VPWR sky130_fd_sc_hd__tapvpwrvgnd_1
XFILLER_0_41_15 VGND VGND VPWR VPWR sky130_fd_sc_hd__fill_1
XFILLER_0_39_497 VGND VGND VPWR VPWR sky130_fd_sc_hd__decap_6
XTAP_TAPCELL_ROW_42_598 VGND VPWR sky130_fd_sc_hd__tapvpwrvgnd_1
XFILLER_0_54_445 VPWR VGND VPWR VGND sky130_ef_sc_hd__decap_12
XFILLER_0_1_225 VPWR VGND VPWR VGND sky130_ef_sc_hd__decap_12
XFILLER_0_22_331 VGND VGND VPWR VPWR sky130_fd_sc_hd__fill_1
XFILLER_0_5_15 VGND VGND VPWR VPWR sky130_fd_sc_hd__fill_1
X_4260_ _0807_ _0837_ _0838_ VGND VGND VPWR VPWR _0839_ sky130_fd_sc_hd__or3_4
XFILLER_0_5_48 VGND VGND VPWR VPWR sky130_fd_sc_hd__decap_4
X_3211_ u_interface.u_compute_core.scaled_data\[14\] u_interface.u_compute_core.mac_accum\[17\]
+ _2691_ VGND VGND VPWR VPWR _2703_ sky130_fd_sc_hd__mux2_1
X_4191_ _0754_ _0769_ _0770_ VGND VGND VPWR VPWR _0771_ sky130_fd_sc_hd__nand3_1
X_3142_ u_interface.u_compute_core.relu_data\[22\] VGND VGND VPWR VPWR _2655_ sky130_fd_sc_hd__buf_2
XTAP_TAPCELL_ROW_78_941 VGND VPWR sky130_fd_sc_hd__tapvpwrvgnd_1
X_3073_ u_interface.u_compute_core.scaled_data\[5\] _2584_ _2602_ _2587_ VGND VGND
+ VPWR VPWR _2603_ sky130_fd_sc_hd__o2bb2a_1
XFILLER_0_89_364 VGND VGND VPWR VPWR sky130_fd_sc_hd__decap_8
XFILLER_0_77_537 VGND VGND VPWR VPWR sky130_fd_sc_hd__decap_8
XFILLER_0_9_303 VGND VGND VPWR VPWR sky130_fd_sc_hd__fill_1
XTAP_TAPCELL_ROW_33_510 VGND VPWR sky130_fd_sc_hd__tapvpwrvgnd_1
XFILLER_0_92_529 VGND VGND VPWR VPWR sky130_fd_sc_hd__decap_3
X_3975_ u_interface.u_compute_core.relu_data\[0\] _0559_ VGND VGND VPWR VPWR _0560_
+ sky130_fd_sc_hd__nand2_1
XFILLER_0_17_125 VGND VGND VPWR VPWR sky130_fd_sc_hd__decap_4
X_5714_ _2198_ _2204_ VGND VGND VPWR VPWR _2273_ sky130_fd_sc_hd__and2b_1
XFILLER_0_17_169 VGND VGND VPWR VPWR sky130_fd_sc_hd__decap_8
X_5645_ _2198_ _2204_ VGND VGND VPWR VPWR _2205_ sky130_fd_sc_hd__xnor2_1
XFILLER_0_86_3 VPWR VGND VPWR VGND sky130_ef_sc_hd__decap_12
XFILLER_0_13_353 VGND VGND VPWR VPWR sky130_fd_sc_hd__fill_1
XFILLER_0_25_180 VPWR VGND VPWR VGND sky130_ef_sc_hd__decap_12
X_5576_ _2042_ _2046_ _2135_ VGND VGND VPWR VPWR _2137_ sky130_fd_sc_hd__nor3_1
X_4527_ _1099_ _1100_ net90 VGND VGND VPWR VPWR _1102_ sky130_fd_sc_hd__a21o_1
XFILLER_0_40_150 VGND VGND VPWR VPWR sky130_fd_sc_hd__decap_8
X_4458_ _0970_ _0983_ _1033_ VGND VGND VPWR VPWR _1034_ sky130_fd_sc_hd__o21a_1
X_3409_ net62 _2863_ _2861_ VGND VGND VPWR VPWR _2865_ sky130_fd_sc_hd__o21a_1
XTAP_TAPCELL_ROW_5_246 VGND VPWR sky130_fd_sc_hd__tapvpwrvgnd_1
X_6128_ clknet_leaf_4_clk _0041_ VGND VGND VPWR VPWR u_interface.u_compute_core.scaled_data\[12\]
+ sky130_fd_sc_hd__dfxtp_1
X_4389_ _0894_ _0964_ _0965_ VGND VGND VPWR VPWR _0966_ sky130_fd_sc_hd__or3_4
XTAP_TAPCELL_ROW_86_1018 VGND VPWR sky130_fd_sc_hd__tapvpwrvgnd_1
X_6059_ _2539_ _2560_ VGND VGND VPWR VPWR _2561_ sky130_fd_sc_hd__and2_1
XTAP_TAPCELL_ROW_84_999 VGND VPWR sky130_fd_sc_hd__tapvpwrvgnd_1
XFILLER_0_83_529 VPWR VGND VPWR VGND sky130_ef_sc_hd__decap_12
XFILLER_0_36_401 VPWR VGND VPWR VGND sky130_ef_sc_hd__decap_12
XFILLER_0_36_434 VGND VGND VPWR VPWR sky130_fd_sc_hd__decap_4
XTAP_TAPCELL_ROW_75_911 VGND VPWR sky130_fd_sc_hd__tapvpwrvgnd_1
XTAP_TAPCELL_ROW_47_646 VGND VPWR sky130_fd_sc_hd__tapvpwrvgnd_1
X_3760_ _0317_ _0319_ _0315_ VGND VGND VPWR VPWR _0355_ sky130_fd_sc_hd__o21a_1
XFILLER_0_6_339 VGND VGND VPWR VPWR sky130_fd_sc_hd__fill_1
XFILLER_0_54_253 VGND VGND VPWR VPWR sky130_fd_sc_hd__decap_3
X_5430_ _1957_ _1902_ _1991_ VGND VGND VPWR VPWR _1993_ sky130_fd_sc_hd__and3_1
XFILLER_0_14_128 VPWR VGND VPWR VGND sky130_ef_sc_hd__decap_12
X_3691_ _0278_ _0279_ VGND VGND VPWR VPWR _0287_ sky130_fd_sc_hd__and2b_1
XFILLER_0_27_489 VGND VGND VPWR VPWR sky130_fd_sc_hd__decap_4
XFILLER_0_42_415 VGND VGND VPWR VPWR sky130_fd_sc_hd__fill_2
XFILLER_0_2_501 VPWR VGND VPWR VGND sky130_ef_sc_hd__decap_12
X_5361_ _1904_ _1905_ _1922_ _1923_ VGND VGND VPWR VPWR _1925_ sky130_fd_sc_hd__o22a_1
XFILLER_0_10_301 VGND VGND VPWR VPWR sky130_fd_sc_hd__decap_6
XTAP_TAPCELL_ROW_10_292 VGND VPWR sky130_fd_sc_hd__tapvpwrvgnd_1
XFILLER_0_2_545 VGND VGND VPWR VPWR sky130_fd_sc_hd__fill_2
XFILLER_0_77_55 VGND VGND VPWR VPWR sky130_fd_sc_hd__fill_1
XFILLER_0_10_334 VPWR VGND VPWR VGND sky130_ef_sc_hd__decap_12
X_5292_ _1042_ _1856_ VGND VGND VPWR VPWR _1857_ sky130_fd_sc_hd__nand2_1
X_4312_ _0813_ _0888_ _0889_ VGND VGND VPWR VPWR _0890_ sky130_fd_sc_hd__nand3_1
X_4243_ _0818_ _0820_ _0821_ VGND VGND VPWR VPWR _0822_ sky130_fd_sc_hd__nand3_1
X_4174_ _0635_ _0753_ VGND VGND VPWR VPWR _0754_ sky130_fd_sc_hd__xnor2_1
X_3125_ _2609_ _2642_ VGND VGND VPWR VPWR _0017_ sky130_fd_sc_hd__nor2_1
XTAP_TAPCELL_ROW_2_216 VGND VPWR sky130_fd_sc_hd__tapvpwrvgnd_1
X_3056_ _2589_ VGND VGND VPWR VPWR _2590_ sky130_fd_sc_hd__inv_2
XFILLER_0_77_312 VPWR VGND VPWR VGND sky130_ef_sc_hd__decap_12
XFILLER_0_77_356 VGND VGND VPWR VPWR sky130_fd_sc_hd__decap_8
XTAP_TAPCELL_ROW_18_370 VGND VPWR sky130_fd_sc_hd__tapvpwrvgnd_1
XTAP_TAPCELL_ROW_81_969 VGND VPWR sky130_fd_sc_hd__tapvpwrvgnd_1
XFILLER_0_92_337 VPWR VGND VPWR VGND sky130_ef_sc_hd__decap_12
XFILLER_0_18_445 VPWR VGND VPWR VGND sky130_ef_sc_hd__decap_12
X_3958_ _0542_ _0543_ _0521_ VGND VGND VPWR VPWR _0544_ sky130_fd_sc_hd__o21ai_1
X_3889_ _0411_ _0460_ VGND VGND VPWR VPWR _0479_ sky130_fd_sc_hd__xnor2_1
XFILLER_0_45_297 VGND VGND VPWR VPWR sky130_fd_sc_hd__fill_1
XFILLER_0_5_361 VPWR VGND VPWR VGND sky130_ef_sc_hd__decap_12
X_5628_ _2115_ _2118_ _2187_ _2735_ VGND VGND VPWR VPWR _2189_ sky130_fd_sc_hd__a31o_1
X_5559_ u_interface.u_compute_core.relu_valid u_interface.u_compute_core.u_av.product_reg\[28\]
+ VGND VGND VPWR VPWR _2121_ sky130_fd_sc_hd__or2_1
XTAP_TAPCELL_ROW_92_1077 VGND VPWR sky130_fd_sc_hd__tapvpwrvgnd_1
XTAP_TAPCELL_ROW_44_616 VGND VPWR sky130_fd_sc_hd__tapvpwrvgnd_1
XFILLER_0_83_337 VGND VGND VPWR VPWR sky130_fd_sc_hd__decap_8
XFILLER_0_36_242 VGND VGND VPWR VPWR sky130_fd_sc_hd__decap_8
XTAP_TAPCELL_ROW_52_693 VGND VPWR sky130_fd_sc_hd__tapvpwrvgnd_1
XFILLER_0_51_201 VGND VGND VPWR VPWR sky130_fd_sc_hd__decap_6
XFILLER_0_24_459 VPWR VGND VPWR VGND sky130_ef_sc_hd__decap_12
XFILLER_0_51_289 VGND VGND VPWR VPWR sky130_fd_sc_hd__decap_6
XFILLER_0_32_492 VGND VGND VPWR VPWR sky130_fd_sc_hd__decap_3
XFILLER_0_2_27 VGND VGND VPWR VPWR sky130_fd_sc_hd__fill_1
X_4930_ _1490_ _1498_ VGND VGND VPWR VPWR _1499_ sky130_fd_sc_hd__xnor2_1
X_4861_ _1427_ _1430_ VGND VGND VPWR VPWR _1431_ sky130_fd_sc_hd__nand2_1
XFILLER_0_59_389 VGND VGND VPWR VPWR sky130_fd_sc_hd__decap_3
XFILLER_0_86_197 VGND VGND VPWR VPWR sky130_fd_sc_hd__fill_1
XTAP_TAPCELL_ROW_15_340 VGND VPWR sky130_fd_sc_hd__tapvpwrvgnd_1
X_3812_ _0371_ _0404_ VGND VGND VPWR VPWR _0405_ sky130_fd_sc_hd__xnor2_1
X_4792_ _1361_ _1362_ VGND VGND VPWR VPWR _1363_ sky130_fd_sc_hd__or2_1
XFILLER_0_55_540 VGND VGND VPWR VPWR sky130_fd_sc_hd__decap_6
XFILLER_0_12_61 VGND VGND VPWR VPWR sky130_fd_sc_hd__fill_1
X_3743_ _2970_ _0300_ _0265_ _2945_ VGND VGND VPWR VPWR _0338_ sky130_fd_sc_hd__a22oi_1
X_3674_ _0268_ _0270_ VGND VGND VPWR VPWR _0271_ sky130_fd_sc_hd__xnor2_1
X_5413_ _2650_ _2647_ _0634_ VGND VGND VPWR VPWR _1976_ sky130_fd_sc_hd__o21ai_1
XFILLER_0_42_289 VPWR VGND VPWR VGND sky130_ef_sc_hd__decap_12
XFILLER_0_88_98 VGND VGND VPWR VPWR sky130_fd_sc_hd__decap_4
XFILLER_0_88_65 VPWR VGND VPWR VGND sky130_ef_sc_hd__decap_12
X_5344_ _1801_ _1818_ _1817_ VGND VGND VPWR VPWR _1908_ sky130_fd_sc_hd__a21bo_1
X_5275_ _1837_ _1838_ _1825_ VGND VGND VPWR VPWR _1840_ sky130_fd_sc_hd__a21o_1
X_4226_ _0801_ _0802_ _0804_ VGND VGND VPWR VPWR _0805_ sky130_fd_sc_hd__and3_1
XFILLER_0_49_3 VPWR VGND VPWR VGND sky130_ef_sc_hd__decap_12
X_4157_ _0726_ _0727_ VGND VGND VPWR VPWR _0737_ sky130_fd_sc_hd__nand2_1
X_3108_ u_interface.u_compute_core.scaled_data\[13\] _2618_ _2629_ _2613_ VGND VGND
+ VPWR VPWR _2630_ sky130_fd_sc_hd__o2bb2a_1
X_4088_ _0667_ _0668_ _0666_ VGND VGND VPWR VPWR _0670_ sky130_fd_sc_hd__a21bo_1
XFILLER_0_77_197 VGND VGND VPWR VPWR sky130_fd_sc_hd__fill_2
XFILLER_0_77_186 VGND VGND VPWR VPWR sky130_fd_sc_hd__decap_8
XFILLER_0_92_145 VPWR VGND VPWR VGND sky130_ef_sc_hd__decap_12
XFILLER_0_18_275 VPWR VGND VPWR VGND sky130_ef_sc_hd__decap_12
XFILLER_0_33_201 VGND VGND VPWR VPWR sky130_fd_sc_hd__fill_2
XFILLER_0_33_212 VPWR VGND VPWR VGND sky130_ef_sc_hd__decap_12
XTAP_TAPCELL_ROW_21_398 VGND VPWR sky130_fd_sc_hd__tapvpwrvgnd_1
XTAP_TAPCELL_ROW_57_741 VGND VPWR sky130_fd_sc_hd__tapvpwrvgnd_1
XTAP_TAPCELL_ROW_29_476 VGND VPWR sky130_fd_sc_hd__tapvpwrvgnd_1
XFILLER_0_68_175 VGND VGND VPWR VPWR sky130_fd_sc_hd__decap_8
XFILLER_0_56_326 VGND VGND VPWR VPWR sky130_fd_sc_hd__fill_1
XFILLER_0_56_348 VGND VGND VPWR VPWR sky130_fd_sc_hd__decap_3
XFILLER_0_83_167 VGND VGND VPWR VPWR sky130_fd_sc_hd__fill_1
XTAP_TAPCELL_ROW_12_310 VGND VPWR sky130_fd_sc_hd__tapvpwrvgnd_1
XFILLER_0_24_212 VGND VGND VPWR VPWR sky130_fd_sc_hd__decap_3
Xinput14 s_tdata[1] VGND VGND VPWR VPWR net14 sky130_fd_sc_hd__clkbuf_2
Xinput25 s_tdata[9] VGND VGND VPWR VPWR net25 sky130_fd_sc_hd__buf_1
XFILLER_0_12_418 VGND VGND VPWR VPWR sky130_fd_sc_hd__fill_2
XFILLER_0_12_429 VGND VGND VPWR VPWR sky130_fd_sc_hd__fill_1
XFILLER_0_24_289 VPWR VGND VPWR VGND sky130_ef_sc_hd__decap_12
X_3390_ _2843_ _2845_ VGND VGND VPWR VPWR _2848_ sky130_fd_sc_hd__or2_1
X_5060_ _1042_ _1627_ VGND VGND VPWR VPWR _1628_ sky130_fd_sc_hd__xnor2_1
X_4011_ _0594_ VGND VGND VPWR VPWR _0595_ sky130_fd_sc_hd__buf_4
XFILLER_0_74_89 VGND VGND VPWR VPWR sky130_fd_sc_hd__fill_1
X_5962_ _2490_ _2491_ VGND VGND VPWR VPWR _2492_ sky130_fd_sc_hd__nor2_1
XFILLER_0_59_120 VGND VGND VPWR VPWR sky130_fd_sc_hd__decap_6
XFILLER_0_87_462 VPWR VGND VPWR VGND sky130_ef_sc_hd__decap_12
X_4913_ _1185_ _1480_ _1482_ VGND VGND VPWR VPWR _1483_ sky130_fd_sc_hd__o21ba_1
XFILLER_0_59_164 VGND VGND VPWR VPWR sky130_fd_sc_hd__decap_4
XFILLER_0_90_77 VGND VGND VPWR VPWR sky130_fd_sc_hd__decap_6
XFILLER_0_87_495 VGND VGND VPWR VPWR sky130_fd_sc_hd__decap_8
X_5893_ _2415_ _2423_ _2420_ _2421_ _2431_ VGND VGND VPWR VPWR _2432_ sky130_fd_sc_hd__a41o_1
XFILLER_0_47_337 VPWR VGND VPWR VGND sky130_ef_sc_hd__decap_12
XFILLER_0_59_175 VPWR VGND VPWR VGND sky130_ef_sc_hd__decap_12
X_4844_ _1343_ _1346_ _1345_ VGND VGND VPWR VPWR _1414_ sky130_fd_sc_hd__o21ba_1
XTAP_TAPCELL_ROW_63_799 VGND VPWR sky130_fd_sc_hd__tapvpwrvgnd_1
X_4775_ _1193_ _1194_ _1344_ VGND VGND VPWR VPWR _1346_ sky130_fd_sc_hd__a21oi_1
XFILLER_0_74_178 VGND VGND VPWR VPWR sky130_fd_sc_hd__fill_2
XFILLER_0_23_93 VPWR VGND VPWR VGND sky130_ef_sc_hd__decap_12
X_3726_ _0276_ _0287_ _0320_ VGND VGND VPWR VPWR _0322_ sky130_fd_sc_hd__or3_1
X_3657_ _0249_ _0253_ VGND VGND VPWR VPWR _0254_ sky130_fd_sc_hd__xnor2_1
XFILLER_0_11_440 VGND VGND VPWR VPWR sky130_fd_sc_hd__decap_8
X_3588_ net25 net16 VGND VGND VPWR VPWR _3026_ sky130_fd_sc_hd__and2_1
XFILLER_0_2_150 VGND VGND VPWR VPWR sky130_fd_sc_hd__fill_1
X_5327_ _1806_ _1889_ _1890_ VGND VGND VPWR VPWR _1891_ sky130_fd_sc_hd__or3_1
X_5258_ _1789_ _1821_ _1822_ VGND VGND VPWR VPWR _1823_ sky130_fd_sc_hd__or3_2
X_5189_ _1752_ _1753_ _1754_ VGND VGND VPWR VPWR _1755_ sky130_fd_sc_hd__nand3_1
X_4209_ _0784_ _0785_ _0787_ VGND VGND VPWR VPWR _0789_ sky130_fd_sc_hd__a21o_1
XTAP_TAPCELL_ROW_54_711 VGND VPWR sky130_fd_sc_hd__tapvpwrvgnd_1
XFILLER_0_78_473 VGND VGND VPWR VPWR sky130_fd_sc_hd__decap_3
XTAP_TAPCELL_ROW_26_446 VGND VPWR sky130_fd_sc_hd__tapvpwrvgnd_1
XFILLER_0_65_167 VGND VGND VPWR VPWR sky130_fd_sc_hd__fill_1
XFILLER_0_28_27 VGND VGND VPWR VPWR sky130_fd_sc_hd__fill_1
XFILLER_0_44_15 VGND VGND VPWR VPWR sky130_fd_sc_hd__decap_8
XFILLER_0_44_26 VGND VGND VPWR VPWR sky130_fd_sc_hd__fill_2
XFILLER_0_69_473 VGND VGND VPWR VPWR sky130_fd_sc_hd__decap_4
XFILLER_0_56_112 VPWR VGND VPWR VGND sky130_ef_sc_hd__decap_12
XPHY_EDGE_ROW_7_Left_100 VGND VGND VPWR VPWR sky130_fd_sc_hd__decap_3
XTAP_TAPCELL_ROW_60_769 VGND VPWR sky130_fd_sc_hd__tapvpwrvgnd_1
X_4560_ _1071_ _1132_ _1133_ VGND VGND VPWR VPWR _1134_ sky130_fd_sc_hd__nand3_2
XFILLER_0_8_37 VGND VGND VPWR VPWR sky130_fd_sc_hd__fill_1
XFILLER_0_8_26 VGND VGND VPWR VPWR sky130_fd_sc_hd__fill_2
X_4491_ _1064_ _1065_ VGND VGND VPWR VPWR _1066_ sky130_fd_sc_hd__nor2b_1
X_3511_ _2938_ _2950_ _2951_ VGND VGND VPWR VPWR _2952_ sky130_fd_sc_hd__nand3b_1
X_6230_ clknet_leaf_17_clk _0143_ VGND VGND VPWR VPWR u_interface.core_attn_out\[5\]
+ sky130_fd_sc_hd__dfxtp_1
X_3442_ _2891_ _2887_ _2892_ VGND VGND VPWR VPWR _2893_ sky130_fd_sc_hd__or3_1
X_3373_ _2833_ VGND VGND VPWR VPWR _2834_ sky130_fd_sc_hd__clkbuf_4
X_6161_ clknet_leaf_1_clk _0074_ VGND VGND VPWR VPWR u_interface.u_compute_core.mac_accum\[15\]
+ sky130_fd_sc_hd__dfxtp_1
X_5112_ _1676_ _1677_ _1593_ VGND VGND VPWR VPWR _1679_ sky130_fd_sc_hd__a21o_1
XFILLER_0_20_270 VGND VGND VPWR VPWR sky130_fd_sc_hd__decap_8
X_6092_ clknet_leaf_4_clk _0005_ VGND VGND VPWR VPWR u_interface.u_compute_core.relu_data\[5\]
+ sky130_fd_sc_hd__dfxtp_4
X_5043_ _1515_ _1609_ _1610_ VGND VGND VPWR VPWR _1611_ sky130_fd_sc_hd__nand3_1
XTAP_TAPCELL_ROW_68_847 VGND VPWR sky130_fd_sc_hd__tapvpwrvgnd_1
XFILLER_0_87_281 VGND VGND VPWR VPWR sky130_fd_sc_hd__decap_8
X_5945_ _2475_ _2476_ VGND VGND VPWR VPWR _2477_ sky130_fd_sc_hd__nor2_1
XTAP_TAPCELL_ROW_23_416 VGND VPWR sky130_fd_sc_hd__tapvpwrvgnd_1
X_5876_ _2415_ _2416_ VGND VGND VPWR VPWR _2417_ sky130_fd_sc_hd__and2_1
XFILLER_0_47_134 VGND VGND VPWR VPWR sky130_fd_sc_hd__fill_2
XFILLER_0_47_145 VGND VGND VPWR VPWR sky130_fd_sc_hd__decap_8
XFILLER_0_90_424 VPWR VGND VPWR VGND sky130_ef_sc_hd__decap_12
XFILLER_0_90_413 VGND VGND VPWR VPWR sky130_fd_sc_hd__decap_6
X_4827_ _1340_ _1341_ net133 _1397_ VGND VGND VPWR VPWR _1398_ sky130_fd_sc_hd__a211oi_4
XFILLER_0_7_220 VGND VGND VPWR VPWR sky130_fd_sc_hd__decap_4
XFILLER_0_35_307 VPWR VGND VPWR VGND sky130_ef_sc_hd__decap_12
XFILLER_0_47_167 VGND VGND VPWR VPWR sky130_fd_sc_hd__fill_1
XTAP_TAPCELL_ROW_31_493 VGND VPWR sky130_fd_sc_hd__tapvpwrvgnd_1
X_4758_ _1328_ _1329_ VGND VGND VPWR VPWR _1330_ sky130_fd_sc_hd__xor2_2
X_4689_ _1170_ net224 _1245_ VGND VGND VPWR VPWR _1261_ sky130_fd_sc_hd__nand3_1
X_3709_ _0303_ _0304_ VGND VGND VPWR VPWR _0305_ sky130_fd_sc_hd__xor2_1
XFILLER_0_11_281 VPWR VGND VPWR VGND sky130_ef_sc_hd__decap_12
XTAP_TAPCELL_ROW_89_1049 VGND VPWR sky130_fd_sc_hd__tapvpwrvgnd_1
XTAP_TAPCELL_ROW_39_571 VGND VPWR sky130_fd_sc_hd__tapvpwrvgnd_1
XFILLER_0_14_29 VPWR VGND VPWR VGND sky130_ef_sc_hd__decap_12
XFILLER_0_81_479 VGND VGND VPWR VPWR sky130_fd_sc_hd__fill_2
XFILLER_0_22_524 VGND VGND VPWR VPWR sky130_fd_sc_hd__decap_8
XFILLER_0_61_181 VPWR VGND VPWR VGND sky130_ef_sc_hd__decap_12
XFILLER_0_1_429 VPWR VGND VPWR VGND sky130_ef_sc_hd__decap_12
XFILLER_0_39_15 VPWR VGND VPWR VGND sky130_ef_sc_hd__decap_12
XPHY_EDGE_ROW_89_Left_182 VGND VGND VPWR VPWR sky130_fd_sc_hd__decap_3
XTAP_TAPCELL_ROW_65_817 VGND VPWR sky130_fd_sc_hd__tapvpwrvgnd_1
XFILLER_0_69_270 VGND VGND VPWR VPWR sky130_fd_sc_hd__decap_6
X_3991_ _0554_ _0553_ VGND VGND VPWR VPWR _0575_ sky130_fd_sc_hd__or2b_1
XTAP_TAPCELL_ROW_73_894 VGND VPWR sky130_fd_sc_hd__tapvpwrvgnd_1
XFILLER_0_71_57 VPWR VGND VPWR VGND sky130_ef_sc_hd__decap_12
XFILLER_0_9_529 VPWR VGND VPWR VGND sky130_ef_sc_hd__decap_12
X_5730_ _2280_ _2288_ VGND VGND VPWR VPWR _2289_ sky130_fd_sc_hd__xnor2_1
XFILLER_0_84_251 VGND VGND VPWR VPWR sky130_fd_sc_hd__fill_1
XFILLER_0_29_167 VGND VGND VPWR VPWR sky130_fd_sc_hd__fill_1
XFILLER_0_29_178 VGND VGND VPWR VPWR sky130_fd_sc_hd__fill_1
X_5661_ _2219_ _2220_ VGND VGND VPWR VPWR _2221_ sky130_fd_sc_hd__nor2_1
XFILLER_0_57_498 VGND VGND VPWR VPWR sky130_fd_sc_hd__decap_6
XFILLER_0_4_201 VGND VGND VPWR VPWR sky130_fd_sc_hd__fill_1
XFILLER_0_25_351 VGND VGND VPWR VPWR sky130_fd_sc_hd__decap_6
X_4612_ _1182_ net77 VGND VGND VPWR VPWR _1186_ sky130_fd_sc_hd__xor2_1
X_5592_ _2040_ _2058_ VGND VGND VPWR VPWR _2153_ sky130_fd_sc_hd__or2b_1
X_4543_ _1089_ _1091_ VGND VGND VPWR VPWR _1117_ sky130_fd_sc_hd__nand2_1
XFILLER_0_4_289 VPWR VGND VPWR VGND sky130_ef_sc_hd__decap_12
X_4474_ _1047_ _1048_ VGND VGND VPWR VPWR _1049_ sky130_fd_sc_hd__and2b_1
X_6213_ clknet_leaf_11_clk _0126_ VGND VGND VPWR VPWR u_interface.u_compute_core.u_av.product_reg\[20\]
+ sky130_fd_sc_hd__dfxtp_1
XFILLER_0_40_365 VGND VGND VPWR VPWR sky130_fd_sc_hd__decap_6
X_3425_ _2832_ u_interface.u_compute_core.mac_accum\[23\] VGND VGND VPWR VPWR _2878_
+ sky130_fd_sc_hd__xor2_1
X_6144_ clknet_leaf_20_clk _0057_ VGND VGND VPWR VPWR u_interface.u_compute_core.scaled_data\[28\]
+ sky130_fd_sc_hd__dfxtp_1
X_3356_ u_interface.u_compute_core.u_mac.product_reg\[13\] u_interface.u_compute_core.mac_accum\[13\]
+ VGND VGND VPWR VPWR _2819_ sky130_fd_sc_hd__and2_1
X_6075_ _2571_ VGND VGND VPWR VPWR _0199_ sky130_fd_sc_hd__clkbuf_1
X_3287_ _2757_ _2758_ _2759_ VGND VGND VPWR VPWR _2760_ sky130_fd_sc_hd__a21o_1
X_5026_ _1447_ _1523_ _1524_ VGND VGND VPWR VPWR _1594_ sky130_fd_sc_hd__o21bai_1
XFILLER_0_31_3 VPWR VGND VPWR VGND sky130_ef_sc_hd__decap_12
XTAP_TAPCELL_ROW_0_188 VGND VPWR sky130_fd_sc_hd__tapvpwrvgnd_1
XTAP_TAPCELL_ROW_36_541 VGND VPWR sky130_fd_sc_hd__tapvpwrvgnd_1
XFILLER_0_48_421 VPWR VGND VPWR VGND sky130_ef_sc_hd__decap_12
XTAP_TAPCELL_ROW_0_199 VGND VPWR sky130_fd_sc_hd__tapvpwrvgnd_1
X_5928_ _2460_ _2461_ VGND VGND VPWR VPWR _2462_ sky130_fd_sc_hd__nand2_1
XFILLER_0_75_262 VGND VGND VPWR VPWR sky130_fd_sc_hd__decap_6
X_5859_ u_interface.core_attn_out\[15\] u_interface.u_compute_core.u_av.product_reg\[18\]
+ VGND VGND VPWR VPWR _2402_ sky130_fd_sc_hd__nand2_1
XFILLER_0_61_90 VGND VGND VPWR VPWR sky130_fd_sc_hd__fill_1
XFILLER_0_16_351 VGND VGND VPWR VPWR sky130_fd_sc_hd__decap_3
XTAP_TAPCELL_ROW_8_277 VGND VPWR sky130_fd_sc_hd__tapvpwrvgnd_1
XFILLER_0_86_516 VPWR VGND VPWR VGND sky130_ef_sc_hd__decap_12
XFILLER_0_25_39 VGND VGND VPWR VPWR sky130_fd_sc_hd__decap_3
XTAP_TAPCELL_ROW_70_864 VGND VPWR sky130_fd_sc_hd__tapvpwrvgnd_1
XFILLER_0_54_413 VGND VGND VPWR VPWR sky130_fd_sc_hd__decap_6
XFILLER_0_41_49 VGND VGND VPWR VPWR sky130_fd_sc_hd__fill_2
XTAP_TAPCELL_ROW_42_599 VGND VPWR sky130_fd_sc_hd__tapvpwrvgnd_1
XFILLER_0_54_457 VGND VGND VPWR VPWR sky130_fd_sc_hd__decap_3
XFILLER_0_10_505 VPWR VGND VPWR VGND sky130_ef_sc_hd__decap_12
XFILLER_0_1_237 VPWR VGND VPWR VGND sky130_ef_sc_hd__decap_12
XFILLER_0_22_365 VPWR VGND VPWR VGND sky130_ef_sc_hd__decap_12
X_3210_ _2702_ VGND VGND VPWR VPWR _0042_ sky130_fd_sc_hd__clkbuf_1
X_4190_ _0672_ _0721_ _0767_ _0768_ VGND VGND VPWR VPWR _0770_ sky130_fd_sc_hd__a2bb2o_1
XFILLER_0_66_68 VGND VGND VPWR VPWR sky130_fd_sc_hd__decap_4
X_3141_ _2643_ _2654_ VGND VGND VPWR VPWR _0021_ sky130_fd_sc_hd__nor2_1
XTAP_TAPCELL_ROW_78_942 VGND VPWR sky130_fd_sc_hd__tapvpwrvgnd_1
X_3072_ net95 VGND VGND VPWR VPWR _2602_ sky130_fd_sc_hd__inv_2
XFILLER_0_89_343 VGND VGND VPWR VPWR sky130_fd_sc_hd__fill_1
XFILLER_0_49_229 VGND VGND VPWR VPWR sky130_fd_sc_hd__fill_1
XFILLER_0_15_83 VPWR VGND VPWR VGND sky130_ef_sc_hd__decap_12
XTAP_TAPCELL_ROW_33_511 VGND VPWR sky130_fd_sc_hd__tapvpwrvgnd_1
X_3974_ _0558_ VGND VGND VPWR VPWR _0559_ sky130_fd_sc_hd__clkbuf_4
XFILLER_0_45_424 VGND VGND VPWR VPWR sky130_fd_sc_hd__decap_8
XFILLER_0_45_446 VGND VGND VPWR VPWR sky130_fd_sc_hd__fill_2
X_5713_ _2197_ _2205_ VGND VGND VPWR VPWR _2272_ sky130_fd_sc_hd__nand2_1
XFILLER_0_72_243 VGND VGND VPWR VPWR sky130_fd_sc_hd__decap_8
X_5644_ _2199_ _2203_ VGND VGND VPWR VPWR _2204_ sky130_fd_sc_hd__xor2_1
XFILLER_0_72_298 VGND VGND VPWR VPWR sky130_fd_sc_hd__fill_1
XFILLER_0_60_416 VGND VGND VPWR VPWR sky130_fd_sc_hd__decap_4
XFILLER_0_25_192 VGND VGND VPWR VPWR sky130_fd_sc_hd__decap_6
X_5575_ _2042_ _2046_ _2135_ VGND VGND VPWR VPWR _2136_ sky130_fd_sc_hd__o21a_1
X_4526_ _1099_ net90 _1100_ VGND VGND VPWR VPWR _1101_ sky130_fd_sc_hd__nand3_4
X_4457_ _0982_ _1032_ VGND VGND VPWR VPWR _1033_ sky130_fd_sc_hd__xnor2_1
XFILLER_0_0_281 VGND VGND VPWR VPWR sky130_fd_sc_hd__fill_2
X_3408_ _2861_ _2862_ _2863_ VGND VGND VPWR VPWR _2864_ sky130_fd_sc_hd__or3_1
X_6127_ clknet_leaf_4_clk _0040_ VGND VGND VPWR VPWR u_interface.u_compute_core.scaled_data\[11\]
+ sky130_fd_sc_hd__dfxtp_1
X_4388_ _0962_ _0963_ _0939_ VGND VGND VPWR VPWR _0965_ sky130_fd_sc_hd__a21oi_1
XTAP_TAPCELL_ROW_5_247 VGND VPWR sky130_fd_sc_hd__tapvpwrvgnd_1
X_3339_ _2781_ _2803_ _2804_ _2746_ net165 VGND VGND VPWR VPWR _0069_ sky130_fd_sc_hd__a32o_1
X_6058_ net42 u_interface.core_attn_out\[22\] _2544_ VGND VGND VPWR VPWR _2560_ sky130_fd_sc_hd__mux2_1
XTAP_TAPCELL_ROW_86_1019 VGND VPWR sky130_fd_sc_hd__tapvpwrvgnd_1
X_5009_ _1575_ _1576_ VGND VGND VPWR VPWR _1577_ sky130_fd_sc_hd__and2b_1
XFILLER_0_36_413 VGND VGND VPWR VPWR sky130_fd_sc_hd__decap_6
XFILLER_0_91_541 VGND VGND VPWR VPWR sky130_fd_sc_hd__decap_6
XFILLER_0_31_151 VGND VGND VPWR VPWR sky130_fd_sc_hd__fill_2
XTAP_TAPCELL_ROW_75_912 VGND VPWR sky130_fd_sc_hd__tapvpwrvgnd_1
XTAP_TAPCELL_ROW_47_647 VGND VPWR sky130_fd_sc_hd__tapvpwrvgnd_1
XFILLER_0_59_505 VPWR VGND VPWR VGND sky130_ef_sc_hd__decap_12
XFILLER_0_52_15 VPWR VGND VPWR VGND sky130_ef_sc_hd__decap_12
XFILLER_0_86_335 VGND VGND VPWR VPWR sky130_fd_sc_hd__fill_2
XFILLER_0_39_273 VGND VGND VPWR VPWR sky130_fd_sc_hd__fill_1
XFILLER_0_27_446 VGND VGND VPWR VPWR sky130_fd_sc_hd__fill_2
X_3690_ net135 _2756_ _0286_ VGND VGND VPWR VPWR _0099_ sky130_fd_sc_hd__a21bo_1
XFILLER_0_2_513 VPWR VGND VPWR VGND sky130_ef_sc_hd__decap_12
X_5360_ _1904_ _1905_ _1922_ _1923_ VGND VGND VPWR VPWR _1924_ sky130_fd_sc_hd__nor4_1
XTAP_TAPCELL_ROW_10_293 VGND VPWR sky130_fd_sc_hd__tapvpwrvgnd_1
X_5291_ _1855_ _1854_ VGND VGND VPWR VPWR _1856_ sky130_fd_sc_hd__xnor2_2
XFILLER_0_10_313 VGND VGND VPWR VPWR sky130_fd_sc_hd__decap_4
XFILLER_0_50_493 VGND VGND VPWR VPWR sky130_fd_sc_hd__fill_1
X_4311_ _0886_ _0887_ _0872_ net93 VGND VGND VPWR VPWR _0889_ sky130_fd_sc_hd__a211o_1
XFILLER_0_10_346 VPWR VGND VPWR VGND sky130_ef_sc_hd__decap_12
X_4242_ _2604_ _2601_ _0557_ _0595_ VGND VGND VPWR VPWR _0821_ sky130_fd_sc_hd__nand4_2
X_4173_ _0751_ _0752_ VGND VGND VPWR VPWR _0753_ sky130_fd_sc_hd__xor2_1
X_3124_ u_interface.u_compute_core.scaled_data\[17\] _2618_ _2641_ _2613_ VGND VGND
+ VPWR VPWR _2642_ sky130_fd_sc_hd__o2bb2a_1
XTAP_TAPCELL_ROW_2_217 VGND VPWR sky130_fd_sc_hd__tapvpwrvgnd_1
X_3055_ u_interface.u_compute_core.relu_data\[1\] VGND VGND VPWR VPWR _2589_ sky130_fd_sc_hd__buf_2
XFILLER_0_77_324 VGND VGND VPWR VPWR sky130_fd_sc_hd__fill_2
XFILLER_0_77_335 VGND VGND VPWR VPWR sky130_fd_sc_hd__fill_1
XFILLER_0_92_305 VGND VGND VPWR VPWR sky130_fd_sc_hd__decap_3
XTAP_TAPCELL_ROW_18_371 VGND VPWR sky130_fd_sc_hd__tapvpwrvgnd_1
XFILLER_0_92_349 VPWR VGND VPWR VGND sky130_ef_sc_hd__decap_12
XFILLER_0_9_156 VGND VGND VPWR VPWR sky130_fd_sc_hd__decap_4
XFILLER_0_9_145 VGND VGND VPWR VPWR sky130_fd_sc_hd__decap_8
X_3957_ _0540_ _0541_ _0519_ VGND VGND VPWR VPWR _0543_ sky130_fd_sc_hd__a21oi_1
XFILLER_0_73_541 VGND VGND VPWR VPWR sky130_fd_sc_hd__decap_6
XFILLER_0_18_457 VPWR VGND VPWR VGND sky130_ef_sc_hd__decap_12
X_3888_ _0414_ _0465_ _0463_ VGND VGND VPWR VPWR _0478_ sky130_fd_sc_hd__a21oi_1
XFILLER_0_33_427 VGND VGND VPWR VPWR sky130_fd_sc_hd__decap_8
XFILLER_0_5_373 VPWR VGND VPWR VGND sky130_ef_sc_hd__decap_12
X_5627_ _2115_ _2118_ _2187_ VGND VGND VPWR VPWR _2188_ sky130_fd_sc_hd__a21oi_1
X_5558_ _2118_ _2119_ VGND VGND VPWR VPWR _2120_ sky130_fd_sc_hd__and2_1
XFILLER_0_60_268 VPWR VGND VPWR VGND sky130_ef_sc_hd__decap_12
X_4509_ _1077_ _1082_ _1083_ VGND VGND VPWR VPWR _1084_ sky130_fd_sc_hd__nand3_1
XFILLER_0_13_184 VPWR VGND VPWR VGND sky130_ef_sc_hd__decap_12
XFILLER_0_41_471 VGND VGND VPWR VPWR sky130_fd_sc_hd__decap_4
XTAP_TAPCELL_ROW_92_1078 VGND VPWR sky130_fd_sc_hd__tapvpwrvgnd_1
Xwire1 _1396_ VGND VGND VPWR VPWR net133 sky130_fd_sc_hd__buf_4
X_5489_ _2655_ _0597_ _2049_ _2050_ VGND VGND VPWR VPWR _2051_ sky130_fd_sc_hd__o2bb2a_1
XTAP_TAPCELL_ROW_44_617 VGND VPWR sky130_fd_sc_hd__tapvpwrvgnd_1
XFILLER_0_56_508 VPWR VGND VPWR VGND sky130_ef_sc_hd__decap_12
XFILLER_0_76_390 VGND VGND VPWR VPWR sky130_fd_sc_hd__decap_6
XFILLER_0_36_221 VPWR VGND VPWR VGND sky130_ef_sc_hd__decap_12
XTAP_TAPCELL_ROW_52_694 VGND VPWR sky130_fd_sc_hd__tapvpwrvgnd_1
XFILLER_0_91_360 VPWR VGND VPWR VGND sky130_ef_sc_hd__decap_12
XFILLER_0_91_393 VPWR VGND VPWR VGND sky130_ef_sc_hd__decap_12
XFILLER_0_24_449 VGND VGND VPWR VPWR sky130_fd_sc_hd__decap_6
XFILLER_0_47_15 VPWR VGND VPWR VGND sky130_ef_sc_hd__decap_12
XPHY_EDGE_ROW_16_Left_109 VGND VGND VPWR VPWR sky130_fd_sc_hd__decap_3
XFILLER_0_59_313 VGND VGND VPWR VPWR sky130_fd_sc_hd__decap_4
X_4860_ _2644_ _0500_ _1212_ _1429_ VGND VGND VPWR VPWR _1430_ sky130_fd_sc_hd__a31o_1
XFILLER_0_74_316 VGND VGND VPWR VPWR sky130_fd_sc_hd__decap_4
XTAP_TAPCELL_ROW_15_341 VGND VPWR sky130_fd_sc_hd__tapvpwrvgnd_1
X_3811_ _0402_ _0403_ VGND VGND VPWR VPWR _0404_ sky130_fd_sc_hd__xnor2_1
XPHY_EDGE_ROW_25_Left_118 VGND VGND VPWR VPWR sky130_fd_sc_hd__decap_3
X_4791_ _2647_ u_interface.u_compute_core.relu_data\[16\] _0502_ _0816_ VGND VGND
+ VPWR VPWR _1362_ sky130_fd_sc_hd__and4_1
X_3742_ _2945_ _2970_ net18 VGND VGND VPWR VPWR _0337_ sky130_fd_sc_hd__and3_1
XFILLER_0_70_533 VPWR VGND VPWR VGND sky130_ef_sc_hd__decap_12
X_3673_ net24 _2930_ _0269_ VGND VGND VPWR VPWR _0270_ sky130_fd_sc_hd__a21o_1
XFILLER_0_42_224 VGND VGND VPWR VPWR sky130_fd_sc_hd__decap_4
XFILLER_0_2_321 VPWR VGND VPWR VGND sky130_ef_sc_hd__decap_12
X_5412_ _1878_ _1879_ VGND VGND VPWR VPWR _1975_ sky130_fd_sc_hd__nand2_1
XFILLER_0_88_77 VGND VGND VPWR VPWR sky130_fd_sc_hd__decap_6
X_5343_ _1906_ VGND VGND VPWR VPWR _1907_ sky130_fd_sc_hd__inv_2
XFILLER_0_10_110 VGND VGND VPWR VPWR sky130_fd_sc_hd__decap_8
XFILLER_0_2_365 VPWR VGND VPWR VGND sky130_ef_sc_hd__decap_12
XFILLER_0_23_482 VGND VGND VPWR VPWR sky130_fd_sc_hd__fill_2
X_5274_ _1825_ _1837_ _1838_ VGND VGND VPWR VPWR _1839_ sky130_fd_sc_hd__nand3_1
XFILLER_0_10_165 VGND VGND VPWR VPWR sky130_fd_sc_hd__decap_3
XPHY_EDGE_ROW_34_Left_127 VGND VGND VPWR VPWR sky130_fd_sc_hd__decap_3
X_4225_ _0803_ VGND VGND VPWR VPWR _0804_ sky130_fd_sc_hd__inv_2
X_4156_ _0703_ _0707_ _0709_ VGND VGND VPWR VPWR _0736_ sky130_fd_sc_hd__a21oi_1
X_3107_ _2628_ VGND VGND VPWR VPWR _2629_ sky130_fd_sc_hd__inv_2
X_4087_ _0666_ _0667_ _0668_ VGND VGND VPWR VPWR _0669_ sky130_fd_sc_hd__nand3b_1
XFILLER_0_38_508 VGND VGND VPWR VPWR sky130_fd_sc_hd__decap_4
XPHY_EDGE_ROW_43_Left_136 VGND VGND VPWR VPWR sky130_fd_sc_hd__decap_3
XFILLER_0_92_113 VPWR VGND VPWR VGND sky130_ef_sc_hd__decap_12
XFILLER_0_65_327 VGND VGND VPWR VPWR sky130_fd_sc_hd__decap_3
XFILLER_0_92_157 VGND VGND VPWR VPWR sky130_fd_sc_hd__decap_8
XFILLER_0_65_349 VPWR VGND VPWR VGND sky130_ef_sc_hd__decap_12
X_4989_ _1479_ _1483_ _1557_ VGND VGND VPWR VPWR _1558_ sky130_fd_sc_hd__o21a_1
XFILLER_0_18_287 VGND VGND VPWR VPWR sky130_fd_sc_hd__decap_4
XFILLER_0_73_393 VPWR VGND VPWR VGND sky130_ef_sc_hd__decap_12
XFILLER_0_5_181 VGND VGND VPWR VPWR sky130_fd_sc_hd__fill_1
XTAP_TAPCELL_ROW_21_399 VGND VPWR sky130_fd_sc_hd__tapvpwrvgnd_1
XPHY_EDGE_ROW_52_Left_145 VGND VGND VPWR VPWR sky130_fd_sc_hd__decap_3
XFILLER_0_17_29 VGND VGND VPWR VPWR sky130_fd_sc_hd__decap_3
XTAP_TAPCELL_ROW_57_742 VGND VPWR sky130_fd_sc_hd__tapvpwrvgnd_1
XTAP_TAPCELL_ROW_29_477 VGND VPWR sky130_fd_sc_hd__tapvpwrvgnd_1
XPHY_EDGE_ROW_61_Left_154 VGND VGND VPWR VPWR sky130_fd_sc_hd__decap_3
XFILLER_0_83_113 VGND VGND VPWR VPWR sky130_fd_sc_hd__decap_4
XFILLER_0_83_135 VPWR VGND VPWR VGND sky130_ef_sc_hd__decap_12
XTAP_TAPCELL_ROW_12_311 VGND VPWR sky130_fd_sc_hd__tapvpwrvgnd_1
XFILLER_0_64_393 VPWR VGND VPWR VGND sky130_ef_sc_hd__decap_12
Xinput15 s_tdata[20] VGND VGND VPWR VPWR net15 sky130_fd_sc_hd__buf_1
Xinput26 s_tlast VGND VGND VPWR VPWR net26 sky130_fd_sc_hd__buf_1
XFILLER_0_52_533 VPWR VGND VPWR VGND sky130_ef_sc_hd__decap_12
XPHY_EDGE_ROW_70_Left_163 VGND VGND VPWR VPWR sky130_fd_sc_hd__decap_3
X_4010_ net23 VGND VGND VPWR VPWR _0594_ sky130_fd_sc_hd__buf_6
XFILLER_0_74_13 VPWR VGND VPWR VGND sky130_ef_sc_hd__decap_12
X_5961_ u_interface.core_attn_out\[28\] u_interface.u_compute_core.u_av.product_reg\[31\]
+ VGND VGND VPWR VPWR _2491_ sky130_fd_sc_hd__nor2_1
XFILLER_0_87_474 VGND VGND VPWR VPWR sky130_fd_sc_hd__fill_2
X_4912_ _1333_ _1330_ _1403_ _1404_ _1481_ VGND VGND VPWR VPWR _1482_ sky130_fd_sc_hd__a311o_1
XFILLER_0_47_305 VPWR VGND VPWR VGND sky130_ef_sc_hd__decap_12
XFILLER_0_59_143 VGND VGND VPWR VPWR sky130_fd_sc_hd__decap_6
X_5892_ _2421_ _2429_ VGND VGND VPWR VPWR _2431_ sky130_fd_sc_hd__nand2_1
XFILLER_0_59_187 VGND VGND VPWR VPWR sky130_fd_sc_hd__decap_8
X_4843_ _1368_ _1411_ _1412_ VGND VGND VPWR VPWR _1413_ sky130_fd_sc_hd__a21o_1
XFILLER_0_74_135 VGND VGND VPWR VPWR sky130_fd_sc_hd__decap_4
XFILLER_0_23_50 VGND VGND VPWR VPWR sky130_fd_sc_hd__decap_6
XFILLER_0_47_349 VPWR VGND VPWR VGND sky130_ef_sc_hd__decap_12
X_4774_ _1193_ _1194_ _1344_ VGND VGND VPWR VPWR _1345_ sky130_fd_sc_hd__and3_1
XFILLER_0_43_511 VGND VGND VPWR VPWR sky130_fd_sc_hd__fill_1
X_3725_ _0276_ _0287_ _0320_ VGND VGND VPWR VPWR _0321_ sky130_fd_sc_hd__o21ai_2
XFILLER_0_43_544 VGND VGND VPWR VPWR sky130_fd_sc_hd__decap_3
XFILLER_0_55_393 VPWR VGND VPWR VGND sky130_ef_sc_hd__decap_12
XFILLER_0_15_257 VGND VGND VPWR VPWR sky130_fd_sc_hd__fill_1
Xclkbuf_leaf_9_clk clknet_1_1__leaf_clk VGND VGND VPWR VPWR clknet_leaf_9_clk sky130_fd_sc_hd__clkbuf_8
X_3656_ _0251_ _0252_ VGND VGND VPWR VPWR _0253_ sky130_fd_sc_hd__nor2_1
XFILLER_0_30_227 VGND VGND VPWR VPWR sky130_fd_sc_hd__decap_4
X_3587_ _2962_ _2993_ VGND VGND VPWR VPWR _3025_ sky130_fd_sc_hd__nor2_1
XFILLER_0_30_249 VGND VGND VPWR VPWR sky130_fd_sc_hd__decap_3
XFILLER_0_61_3 VPWR VGND VPWR VGND sky130_ef_sc_hd__decap_12
X_5326_ u_interface.u_compute_core.relu_data\[21\] _2640_ _0557_ _0633_ VGND VGND
+ VPWR VPWR _1890_ sky130_fd_sc_hd__and4_1
X_5257_ _1819_ _1820_ _1798_ VGND VGND VPWR VPWR _1822_ sky130_fd_sc_hd__a21oi_1
X_4208_ _0784_ _0785_ _0787_ VGND VGND VPWR VPWR _0788_ sky130_fd_sc_hd__and3_1
X_5188_ _1669_ _1672_ _1671_ VGND VGND VPWR VPWR _1754_ sky130_fd_sc_hd__o21bai_1
X_4139_ _0718_ _0719_ VGND VGND VPWR VPWR _0720_ sky130_fd_sc_hd__nand2_1
XTAP_TAPCELL_ROW_54_712 VGND VPWR sky130_fd_sc_hd__tapvpwrvgnd_1
XFILLER_0_78_463 VGND VGND VPWR VPWR sky130_fd_sc_hd__decap_6
XFILLER_0_65_113 VPWR VGND VPWR VGND sky130_ef_sc_hd__decap_12
XTAP_TAPCELL_ROW_26_447 VGND VPWR sky130_fd_sc_hd__tapvpwrvgnd_1
XFILLER_0_34_533 VGND VGND VPWR VPWR sky130_fd_sc_hd__decap_8
XPHY_EDGE_ROW_5_Left_98 VGND VGND VPWR VPWR sky130_fd_sc_hd__decap_3
XFILLER_0_56_124 VGND VGND VPWR VPWR sky130_fd_sc_hd__fill_1
XFILLER_0_60_26 VGND VGND VPWR VPWR sky130_fd_sc_hd__fill_2
XFILLER_0_60_37 VGND VGND VPWR VPWR sky130_fd_sc_hd__fill_2
XFILLER_0_84_477 VGND VGND VPWR VPWR sky130_fd_sc_hd__fill_1
XFILLER_0_37_393 VPWR VGND VPWR VGND sky130_ef_sc_hd__decap_12
X_3510_ _2930_ _2936_ _2949_ _2928_ VGND VGND VPWR VPWR _2951_ sky130_fd_sc_hd__a22o_1
XFILLER_0_52_363 VGND VGND VPWR VPWR sky130_fd_sc_hd__fill_1
X_4490_ _1061_ _1062_ _1063_ VGND VGND VPWR VPWR _1065_ sky130_fd_sc_hd__a21o_1
XFILLER_0_69_57 VGND VGND VPWR VPWR sky130_fd_sc_hd__decap_3
XFILLER_0_69_35 VPWR VGND VPWR VGND sky130_ef_sc_hd__decap_12
X_3441_ _2833_ u_interface.u_compute_core.mac_accum\[25\] VGND VGND VPWR VPWR _2892_
+ sky130_fd_sc_hd__xor2_1
X_3372_ _2832_ VGND VGND VPWR VPWR _2833_ sky130_fd_sc_hd__buf_2
X_6160_ clknet_leaf_1_clk _0073_ VGND VGND VPWR VPWR u_interface.u_compute_core.mac_accum\[14\]
+ sky130_fd_sc_hd__dfxtp_1
X_5111_ _1593_ _1676_ _1677_ VGND VGND VPWR VPWR _1678_ sky130_fd_sc_hd__nand3_1
X_6091_ clknet_leaf_5_clk _0004_ VGND VGND VPWR VPWR u_interface.u_compute_core.relu_data\[4\]
+ sky130_fd_sc_hd__dfxtp_1
XFILLER_0_85_89 VGND VGND VPWR VPWR sky130_fd_sc_hd__fill_1
X_5042_ _1608_ _1607_ _1445_ VGND VGND VPWR VPWR _1610_ sky130_fd_sc_hd__a21o_1
XTAP_TAPCELL_ROW_68_848 VGND VPWR sky130_fd_sc_hd__tapvpwrvgnd_1
XFILLER_0_18_83 VGND VGND VPWR VPWR sky130_fd_sc_hd__fill_1
XFILLER_0_75_400 VGND VGND VPWR VPWR sky130_fd_sc_hd__fill_1
X_5944_ u_interface.core_attn_out\[26\] u_interface.u_compute_core.u_av.product_reg\[29\]
+ VGND VGND VPWR VPWR _2476_ sky130_fd_sc_hd__and2_1
XTAP_TAPCELL_ROW_23_417 VGND VPWR sky130_fd_sc_hd__tapvpwrvgnd_1
X_5875_ u_interface.core_attn_out\[17\] u_interface.u_compute_core.u_av.product_reg\[20\]
+ VGND VGND VPWR VPWR _2416_ sky130_fd_sc_hd__nand2_1
X_4826_ _1394_ _1395_ _1275_ _1277_ VGND VGND VPWR VPWR _1397_ sky130_fd_sc_hd__o211a_4
XFILLER_0_75_488 VGND VGND VPWR VPWR sky130_fd_sc_hd__fill_1
XFILLER_0_35_319 VGND VGND VPWR VPWR sky130_fd_sc_hd__decap_4
XFILLER_0_90_436 VPWR VGND VPWR VGND sky130_ef_sc_hd__decap_12
XFILLER_0_16_533 VPWR VGND VPWR VGND sky130_ef_sc_hd__decap_12
XTAP_TAPCELL_ROW_31_494 VGND VPWR sky130_fd_sc_hd__tapvpwrvgnd_1
XFILLER_0_31_503 VGND VGND VPWR VPWR sky130_fd_sc_hd__fill_1
X_4757_ _1250_ _1252_ VGND VGND VPWR VPWR _1329_ sky130_fd_sc_hd__or2b_1
X_3708_ _2935_ net18 VGND VGND VPWR VPWR _0304_ sky130_fd_sc_hd__nand2_4
X_4688_ _0485_ net184 _1259_ _1260_ _0855_ VGND VGND VPWR VPWR _0123_ sky130_fd_sc_hd__o221a_1
X_3639_ _0234_ _0235_ _0208_ _3034_ VGND VGND VPWR VPWR _0237_ sky130_fd_sc_hd__a211oi_1
XFILLER_0_11_293 VPWR VGND VPWR VGND sky130_ef_sc_hd__decap_12
X_5309_ _1870_ _1872_ VGND VGND VPWR VPWR _1873_ sky130_fd_sc_hd__or2_1
X_6289_ clknet_leaf_15_clk _0202_ VGND VGND VPWR VPWR net51 sky130_fd_sc_hd__dfxtp_1
XTAP_TAPCELL_ROW_39_572 VGND VPWR sky130_fd_sc_hd__tapvpwrvgnd_1
XFILLER_0_85_219 VGND VGND VPWR VPWR sky130_fd_sc_hd__fill_1
XFILLER_0_78_293 VGND VGND VPWR VPWR sky130_fd_sc_hd__fill_1
XFILLER_0_81_447 VGND VGND VPWR VPWR sky130_fd_sc_hd__fill_1
XFILLER_0_81_425 VGND VGND VPWR VPWR sky130_fd_sc_hd__decap_3
XFILLER_0_34_363 VGND VGND VPWR VPWR sky130_fd_sc_hd__fill_1
XFILLER_0_61_193 VPWR VGND VPWR VGND sky130_ef_sc_hd__decap_12
XFILLER_0_39_27 VGND VGND VPWR VPWR sky130_fd_sc_hd__fill_1
XFILLER_0_55_15 VPWR VGND VPWR VGND sky130_ef_sc_hd__decap_12
XFILLER_0_89_503 VGND VGND VPWR VPWR sky130_fd_sc_hd__fill_1
XTAP_TAPCELL_ROW_65_818 VGND VPWR sky130_fd_sc_hd__tapvpwrvgnd_1
XFILLER_0_76_208 VGND VGND VPWR VPWR sky130_fd_sc_hd__fill_2
X_3990_ _0559_ _0555_ VGND VGND VPWR VPWR _0574_ sky130_fd_sc_hd__nand2_1
XTAP_TAPCELL_ROW_73_895 VGND VPWR sky130_fd_sc_hd__tapvpwrvgnd_1
XFILLER_0_71_69 VPWR VGND VPWR VGND sky130_ef_sc_hd__decap_12
XFILLER_0_29_113 VGND VGND VPWR VPWR sky130_fd_sc_hd__fill_1
XFILLER_0_72_403 VPWR VGND VPWR VGND sky130_ef_sc_hd__decap_12
X_5660_ _2148_ _2218_ _2161_ VGND VGND VPWR VPWR _2220_ sky130_fd_sc_hd__nor3_1
X_4611_ _1038_ _1037_ _1183_ _1184_ _1111_ VGND VGND VPWR VPWR _1185_ sky130_fd_sc_hd__a311o_4
X_5591_ _2141_ _2151_ VGND VGND VPWR VPWR _2152_ sky130_fd_sc_hd__xnor2_1
XFILLER_0_13_503 VGND VGND VPWR VPWR sky130_fd_sc_hd__fill_1
XFILLER_0_25_374 VGND VGND VPWR VPWR sky130_fd_sc_hd__fill_2
X_4542_ _0918_ _1106_ _1105_ VGND VGND VPWR VPWR _1116_ sky130_fd_sc_hd__o21bai_4
XFILLER_0_52_171 VPWR VGND VPWR VGND sky130_ef_sc_hd__decap_12
X_4473_ net124 _0492_ _0503_ net119 VGND VGND VPWR VPWR _1048_ sky130_fd_sc_hd__a22o_1
XFILLER_0_20_62 VPWR VGND VPWR VGND sky130_ef_sc_hd__decap_12
X_6212_ clknet_leaf_10_clk _0125_ VGND VGND VPWR VPWR u_interface.u_compute_core.u_av.product_reg\[19\]
+ sky130_fd_sc_hd__dfxtp_1
X_3424_ _2781_ _2876_ _2877_ _2867_ net151 VGND VGND VPWR VPWR _0081_ sky130_fd_sc_hd__a32o_1
XFILLER_0_0_441 VGND VGND VPWR VPWR sky130_fd_sc_hd__decap_3
X_6143_ clknet_leaf_21_clk _0056_ VGND VGND VPWR VPWR u_interface.u_compute_core.scaled_data\[27\]
+ sky130_fd_sc_hd__dfxtp_1
X_3355_ _2811_ _2814_ _2815_ _2812_ VGND VGND VPWR VPWR _2818_ sky130_fd_sc_hd__o31a_1
X_6074_ _2670_ _2570_ VGND VGND VPWR VPWR _2571_ sky130_fd_sc_hd__and2_1
X_3286_ _2749_ _2751_ _2747_ VGND VGND VPWR VPWR _2759_ sky130_fd_sc_hd__o21bai_1
X_5025_ _1445_ VGND VGND VPWR VPWR _1593_ sky130_fd_sc_hd__clkbuf_4
XFILLER_0_24_3 VPWR VGND VPWR VGND sky130_ef_sc_hd__decap_12
XTAP_TAPCELL_ROW_36_542 VGND VPWR sky130_fd_sc_hd__tapvpwrvgnd_1
XTAP_TAPCELL_ROW_0_189 VGND VPWR sky130_fd_sc_hd__tapvpwrvgnd_1
X_5927_ u_interface.core_attn_out\[24\] u_interface.u_compute_core.u_av.product_reg\[27\]
+ VGND VGND VPWR VPWR _2461_ sky130_fd_sc_hd__or2_1
XFILLER_0_48_433 VPWR VGND VPWR VGND sky130_ef_sc_hd__decap_12
XFILLER_0_0_83 VGND VGND VPWR VPWR sky130_fd_sc_hd__fill_1
XFILLER_0_48_477 VPWR VGND VPWR VGND sky130_ef_sc_hd__decap_12
X_5858_ u_interface.core_attn_out\[15\] u_interface.u_compute_core.u_av.product_reg\[18\]
+ VGND VGND VPWR VPWR _2401_ sky130_fd_sc_hd__nor2_1
X_4809_ _1291_ _1293_ _1292_ VGND VGND VPWR VPWR _1380_ sky130_fd_sc_hd__o21bai_1
X_5789_ u_interface.core_attn_out\[6\] u_interface.u_compute_core.u_av.product_reg\[9\]
+ VGND VGND VPWR VPWR _2341_ sky130_fd_sc_hd__nand2_1
XPHY_EDGE_ROW_17_Right_17 VGND VGND VPWR VPWR sky130_fd_sc_hd__decap_3
XFILLER_0_31_311 VGND VGND VPWR VPWR sky130_fd_sc_hd__decap_6
XTAP_TAPCELL_ROW_8_278 VGND VPWR sky130_fd_sc_hd__tapvpwrvgnd_1
XPHY_EDGE_ROW_26_Right_26 VGND VGND VPWR VPWR sky130_fd_sc_hd__decap_3
XFILLER_0_86_528 VGND VGND VPWR VPWR sky130_fd_sc_hd__decap_4
XFILLER_0_39_444 VGND VGND VPWR VPWR sky130_fd_sc_hd__decap_4
XFILLER_0_54_403 VGND VGND VPWR VPWR sky130_fd_sc_hd__decap_6
XTAP_TAPCELL_ROW_70_865 VGND VPWR sky130_fd_sc_hd__tapvpwrvgnd_1
XPHY_EDGE_ROW_35_Right_35 VGND VGND VPWR VPWR sky130_fd_sc_hd__decap_3
XFILLER_0_10_517 VPWR VGND VPWR VGND sky130_ef_sc_hd__decap_12
XFILLER_0_1_249 VPWR VGND VPWR VGND sky130_ef_sc_hd__decap_12
XFILLER_0_22_355 VGND VGND VPWR VPWR sky130_fd_sc_hd__decap_8
XFILLER_0_22_377 VGND VGND VPWR VPWR sky130_fd_sc_hd__fill_2
XPHY_EDGE_ROW_44_Right_44 VGND VGND VPWR VPWR sky130_fd_sc_hd__decap_3
X_3140_ u_interface.u_compute_core.scaled_data\[21\] _2583_ _2653_ _2586_ VGND VGND
+ VPWR VPWR _2654_ sky130_fd_sc_hd__o2bb2a_1
XTAP_TAPCELL_ROW_78_943 VGND VPWR sky130_fd_sc_hd__tapvpwrvgnd_1
X_3071_ u_interface.u_compute_core.relu_data\[5\] VGND VGND VPWR VPWR _2601_ sky130_fd_sc_hd__buf_8
XFILLER_0_82_68 VGND VGND VPWR VPWR sky130_fd_sc_hd__decap_3
XFILLER_0_49_208 VGND VGND VPWR VPWR sky130_fd_sc_hd__fill_1
XFILLER_0_15_73 VGND VGND VPWR VPWR sky130_fd_sc_hd__fill_2
XTAP_TAPCELL_ROW_33_512 VGND VPWR sky130_fd_sc_hd__tapvpwrvgnd_1
X_3973_ _0557_ VGND VGND VPWR VPWR _0558_ sky130_fd_sc_hd__clkbuf_4
XFILLER_0_15_95 VGND VGND VPWR VPWR sky130_fd_sc_hd__fill_1
X_5712_ _2269_ _2270_ VGND VGND VPWR VPWR _2271_ sky130_fd_sc_hd__xnor2_1
XPHY_EDGE_ROW_53_Right_53 VGND VGND VPWR VPWR sky130_fd_sc_hd__decap_3
X_5643_ _2134_ _2202_ VGND VGND VPWR VPWR _2203_ sky130_fd_sc_hd__xnor2_1
X_5574_ _2133_ _2134_ VGND VGND VPWR VPWR _2135_ sky130_fd_sc_hd__xnor2_1
X_4525_ _1097_ _1098_ _1045_ VGND VGND VPWR VPWR _1100_ sky130_fd_sc_hd__o21ai_1
XFILLER_0_53_491 VPWR VGND VPWR VGND sky130_ef_sc_hd__decap_12
X_4456_ _1030_ _1031_ VGND VGND VPWR VPWR _1032_ sky130_fd_sc_hd__xnor2_1
XPHY_EDGE_ROW_62_Right_62 VGND VGND VPWR VPWR sky130_fd_sc_hd__decap_3
X_4387_ _0962_ _0939_ _0963_ VGND VGND VPWR VPWR _0964_ sky130_fd_sc_hd__and3_4
X_3407_ u_interface.u_compute_core.mac_accum\[19\] u_interface.u_compute_core.mac_accum\[18\]
+ u_interface.u_compute_core.mac_accum\[17\] u_interface.u_compute_core.mac_accum\[16\]
+ _2832_ VGND VGND VPWR VPWR _2863_ sky130_fd_sc_hd__o41a_1
X_3338_ _2796_ _2802_ _2801_ VGND VGND VPWR VPWR _2804_ sky130_fd_sc_hd__o21ai_1
X_6126_ clknet_leaf_4_clk _0039_ VGND VGND VPWR VPWR u_interface.u_compute_core.scaled_data\[10\]
+ sky130_fd_sc_hd__dfxtp_1
XTAP_TAPCELL_ROW_5_248 VGND VPWR sky130_fd_sc_hd__tapvpwrvgnd_1
X_3269_ u_interface.u_compute_core.u_mac.product_reg\[0\] u_interface.u_compute_core.mac_accum\[0\]
+ _2742_ VGND VGND VPWR VPWR _2744_ sky130_fd_sc_hd__a21o_1
X_6057_ _2559_ VGND VGND VPWR VPWR _0193_ sky130_fd_sc_hd__clkbuf_1
X_5008_ u_interface.u_compute_core.relu_data\[21\] _0495_ _0557_ _2640_ VGND VGND
+ VPWR VPWR _1576_ sky130_fd_sc_hd__a22o_1
XPHY_EDGE_ROW_71_Right_71 VGND VGND VPWR VPWR sky130_fd_sc_hd__decap_3
XFILLER_0_51_417 VPWR VGND VPWR VGND sky130_ef_sc_hd__decap_12
XFILLER_0_44_491 VPWR VGND VPWR VGND sky130_ef_sc_hd__decap_12
XPHY_EDGE_ROW_80_Right_80 VGND VGND VPWR VPWR sky130_fd_sc_hd__decap_3
XTAP_TAPCELL_ROW_75_913 VGND VPWR sky130_fd_sc_hd__tapvpwrvgnd_1
XTAP_TAPCELL_ROW_47_648 VGND VPWR sky130_fd_sc_hd__tapvpwrvgnd_1
XFILLER_0_59_517 VGND VGND VPWR VPWR sky130_fd_sc_hd__fill_1
XFILLER_0_86_347 VPWR VGND VPWR VGND sky130_ef_sc_hd__decap_12
XFILLER_0_52_27 VGND VGND VPWR VPWR sky130_fd_sc_hd__fill_1
XTAP_TAPCELL_ROW_83_990 VGND VPWR sky130_fd_sc_hd__tapvpwrvgnd_1
XFILLER_0_82_531 VGND VGND VPWR VPWR sky130_fd_sc_hd__fill_1
XFILLER_0_54_288 VGND VGND VPWR VPWR sky130_fd_sc_hd__fill_2
XTAP_TAPCELL_ROW_10_294 VGND VPWR sky130_fd_sc_hd__tapvpwrvgnd_1
XFILLER_0_2_525 VGND VGND VPWR VPWR sky130_fd_sc_hd__decap_6
XFILLER_0_22_141 VGND VGND VPWR VPWR sky130_fd_sc_hd__fill_1
X_5290_ _1769_ _1771_ VGND VGND VPWR VPWR _1855_ sky130_fd_sc_hd__nor2_1
X_4310_ _0872_ net93 _0886_ _0887_ VGND VGND VPWR VPWR _0888_ sky130_fd_sc_hd__o211ai_2
XFILLER_0_77_79 VPWR VGND VPWR VGND sky130_ef_sc_hd__decap_12
XFILLER_0_77_57 VGND VGND VPWR VPWR sky130_fd_sc_hd__decap_4
XFILLER_0_10_358 VGND VGND VPWR VPWR sky130_fd_sc_hd__decap_6
X_4241_ _2604_ _0625_ _0819_ _2601_ VGND VGND VPWR VPWR _0820_ sky130_fd_sc_hd__a22o_1
X_4172_ _2589_ _0659_ _0704_ _0705_ _0657_ VGND VGND VPWR VPWR _0752_ sky130_fd_sc_hd__o32a_1
X_3123_ _2640_ VGND VGND VPWR VPWR _2641_ sky130_fd_sc_hd__inv_2
XTAP_TAPCELL_ROW_2_218 VGND VPWR sky130_fd_sc_hd__tapvpwrvgnd_1
X_3054_ _2582_ _2588_ VGND VGND VPWR VPWR _0000_ sky130_fd_sc_hd__nor2_1
XFILLER_0_89_185 VGND VGND VPWR VPWR sky130_fd_sc_hd__decap_4
XFILLER_0_26_94 VGND VGND VPWR VPWR sky130_fd_sc_hd__decap_8
XFILLER_0_9_113 VGND VGND VPWR VPWR sky130_fd_sc_hd__fill_1
XTAP_TAPCELL_ROW_18_372 VGND VPWR sky130_fd_sc_hd__tapvpwrvgnd_1
X_3956_ _0519_ _0540_ _0541_ VGND VGND VPWR VPWR _0542_ sky130_fd_sc_hd__and3_1
XFILLER_0_85_391 VGND VGND VPWR VPWR sky130_fd_sc_hd__fill_1
XFILLER_0_18_469 VGND VGND VPWR VPWR sky130_fd_sc_hd__decap_6
XFILLER_0_91_3 VPWR VGND VPWR VGND sky130_ef_sc_hd__decap_12
X_3887_ _0409_ _0410_ _0469_ _0467_ VGND VGND VPWR VPWR _0477_ sky130_fd_sc_hd__a31o_1
X_5626_ _2185_ _2186_ VGND VGND VPWR VPWR _2187_ sky130_fd_sc_hd__and2b_1
XFILLER_0_5_385 VGND VGND VPWR VPWR sky130_fd_sc_hd__decap_6
X_5557_ _2117_ _2036_ net108 VGND VGND VPWR VPWR _2119_ sky130_fd_sc_hd__nand3_1
X_4508_ _1080_ _1081_ _1010_ VGND VGND VPWR VPWR _1083_ sky130_fd_sc_hd__a21o_1
X_5488_ _2660_ _1644_ _0535_ _0558_ VGND VGND VPWR VPWR _2050_ sky130_fd_sc_hd__and4_1
X_4439_ _1012_ _1013_ _1010_ VGND VGND VPWR VPWR _1015_ sky130_fd_sc_hd__a21o_1
XFILLER_0_13_196 VPWR VGND VPWR VGND sky130_ef_sc_hd__decap_12
XTAP_TAPCELL_ROW_92_1079 VGND VPWR sky130_fd_sc_hd__tapvpwrvgnd_1
X_6109_ clknet_leaf_9_clk _0022_ VGND VGND VPWR VPWR u_interface.u_compute_core.relu_data\[22\]
+ sky130_fd_sc_hd__dfxtp_1
Xrebuffer60 _1256_ VGND VGND VPWR VPWR net125 sky130_fd_sc_hd__dlygate4sd1_1
XTAP_TAPCELL_ROW_44_618 VGND VPWR sky130_fd_sc_hd__tapvpwrvgnd_1
XTAP_TAPCELL_ROW_80_960 VGND VPWR sky130_fd_sc_hd__tapvpwrvgnd_1
XFILLER_0_64_531 VGND VGND VPWR VPWR sky130_fd_sc_hd__fill_1
XFILLER_0_36_233 VGND VGND VPWR VPWR sky130_fd_sc_hd__fill_2
XTAP_TAPCELL_ROW_52_695 VGND VPWR sky130_fd_sc_hd__tapvpwrvgnd_1
XFILLER_0_91_372 VGND VGND VPWR VPWR sky130_fd_sc_hd__decap_4
XFILLER_0_91_383 VGND VGND VPWR VPWR sky130_fd_sc_hd__fill_1
XFILLER_0_47_27 VGND VGND VPWR VPWR sky130_fd_sc_hd__decap_8
XFILLER_0_2_29 VPWR VGND VPWR VGND sky130_ef_sc_hd__decap_12
XFILLER_0_63_15 VPWR VGND VPWR VGND sky130_ef_sc_hd__decap_12
XFILLER_0_86_188 VGND VGND VPWR VPWR sky130_fd_sc_hd__decap_8
XFILLER_0_74_328 VGND VGND VPWR VPWR sky130_fd_sc_hd__fill_1
X_4790_ _2647_ _0493_ _0491_ _2637_ VGND VGND VPWR VPWR _1361_ sky130_fd_sc_hd__a22oi_1
XTAP_TAPCELL_ROW_15_342 VGND VPWR sky130_fd_sc_hd__tapvpwrvgnd_1
X_3810_ _0362_ _0365_ _0363_ VGND VGND VPWR VPWR _0403_ sky130_fd_sc_hd__o21ba_1
XFILLER_0_27_200 VGND VGND VPWR VPWR sky130_fd_sc_hd__decap_3
XFILLER_0_67_391 VGND VGND VPWR VPWR sky130_fd_sc_hd__fill_1
X_3741_ _0334_ _0335_ VGND VGND VPWR VPWR _0336_ sky130_fd_sc_hd__or2b_1
XFILLER_0_27_266 VGND VGND VPWR VPWR sky130_fd_sc_hd__decap_4
XFILLER_0_42_203 VGND VGND VPWR VPWR sky130_fd_sc_hd__fill_1
XFILLER_0_82_394 VGND VGND VPWR VPWR sky130_fd_sc_hd__fill_1
XFILLER_0_70_545 VGND VGND VPWR VPWR sky130_fd_sc_hd__fill_2
XFILLER_0_15_428 VGND VGND VPWR VPWR sky130_fd_sc_hd__fill_1
X_3672_ net24 _2930_ net18 VGND VGND VPWR VPWR _0269_ sky130_fd_sc_hd__o21ai_2
X_5411_ _1894_ _1896_ VGND VGND VPWR VPWR _1974_ sky130_fd_sc_hd__nand2_1
X_5342_ net71 _1834_ _1833_ VGND VGND VPWR VPWR _1906_ sky130_fd_sc_hd__a21bo_1
XFILLER_0_2_333 VPWR VGND VPWR VGND sky130_ef_sc_hd__decap_12
XFILLER_0_2_377 VPWR VGND VPWR VGND sky130_ef_sc_hd__decap_12
X_5273_ _1835_ _1836_ _1826_ VGND VGND VPWR VPWR _1838_ sky130_fd_sc_hd__a21o_1
X_4224_ _2622_ _2619_ _0502_ _0504_ VGND VGND VPWR VPWR _0803_ sky130_fd_sc_hd__and4_1
X_4155_ _2736_ _0734_ _0735_ net61 VGND VGND VPWR VPWR _0115_ sky130_fd_sc_hd__o211a_1
X_3106_ u_interface.u_compute_core.relu_data\[13\] VGND VGND VPWR VPWR _2628_ sky130_fd_sc_hd__buf_2
X_4086_ net82 _0498_ _0488_ net86 VGND VGND VPWR VPWR _0668_ sky130_fd_sc_hd__a22o_1
XFILLER_0_77_111 VGND VGND VPWR VPWR sky130_fd_sc_hd__fill_1
XFILLER_0_92_125 VPWR VGND VPWR VGND sky130_ef_sc_hd__decap_12
XFILLER_0_18_222 VGND VGND VPWR VPWR sky130_fd_sc_hd__decap_6
X_4988_ _1477_ _1478_ VGND VGND VPWR VPWR _1557_ sky130_fd_sc_hd__nand2_1
XFILLER_0_46_531 VGND VGND VPWR VPWR sky130_fd_sc_hd__fill_1
XFILLER_0_92_169 VPWR VGND VPWR VGND sky130_ef_sc_hd__decap_12
X_3939_ _0498_ VGND VGND VPWR VPWR _0525_ sky130_fd_sc_hd__clkbuf_4
XFILLER_0_61_501 VGND VGND VPWR VPWR sky130_fd_sc_hd__decap_3
XFILLER_0_33_225 VPWR VGND VPWR VGND sky130_ef_sc_hd__decap_12
XFILLER_0_61_545 VGND VGND VPWR VPWR sky130_fd_sc_hd__fill_2
X_5609_ _2168_ _2169_ VGND VGND VPWR VPWR _2170_ sky130_fd_sc_hd__nand2_1
XTAP_TAPCELL_ROW_57_743 VGND VPWR sky130_fd_sc_hd__tapvpwrvgnd_1
XTAP_TAPCELL_ROW_29_478 VGND VPWR sky130_fd_sc_hd__tapvpwrvgnd_1
XFILLER_0_56_317 VGND VGND VPWR VPWR sky130_fd_sc_hd__fill_1
XFILLER_0_83_147 VPWR VGND VPWR VGND sky130_ef_sc_hd__decap_12
XFILLER_0_83_169 VGND VGND VPWR VPWR sky130_fd_sc_hd__decap_3
XTAP_TAPCELL_ROW_12_312 VGND VPWR sky130_fd_sc_hd__tapvpwrvgnd_1
Xinput27 s_tvalid VGND VGND VPWR VPWR net27 sky130_fd_sc_hd__clkbuf_4
Xinput16 s_tdata[21] VGND VGND VPWR VPWR net16 sky130_fd_sc_hd__buf_1
XFILLER_0_52_545 VGND VGND VPWR VPWR sky130_fd_sc_hd__fill_2
XFILLER_0_24_247 VGND VGND VPWR VPWR sky130_fd_sc_hd__decap_4
XFILLER_0_20_431 VGND VGND VPWR VPWR sky130_fd_sc_hd__decap_8
XFILLER_0_58_15 VPWR VGND VPWR VGND sky130_ef_sc_hd__decap_12
XFILLER_0_20_475 VGND VGND VPWR VPWR sky130_fd_sc_hd__fill_1
XFILLER_0_74_25 VGND VGND VPWR VPWR sky130_fd_sc_hd__decap_3
X_5960_ u_interface.core_attn_out\[28\] u_interface.u_compute_core.u_av.product_reg\[31\]
+ VGND VGND VPWR VPWR _2490_ sky130_fd_sc_hd__and2_1
X_5891_ _2421_ _2424_ _2428_ _2429_ VGND VGND VPWR VPWR _2430_ sky130_fd_sc_hd__a22oi_1
X_4911_ _1328_ _1329_ _1403_ VGND VGND VPWR VPWR _1481_ sky130_fd_sc_hd__and3_1
XFILLER_0_47_317 VPWR VGND VPWR VGND sky130_ef_sc_hd__decap_12
X_4842_ _1310_ _1387_ VGND VGND VPWR VPWR _1412_ sky130_fd_sc_hd__and2_1
XFILLER_0_74_125 VGND VGND VPWR VPWR sky130_fd_sc_hd__fill_1
XFILLER_0_28_520 VPWR VGND VPWR VGND sky130_ef_sc_hd__decap_12
X_4773_ _1143_ _1286_ _1285_ VGND VGND VPWR VPWR _1344_ sky130_fd_sc_hd__a21o_1
XFILLER_0_7_447 VGND VGND VPWR VPWR sky130_fd_sc_hd__fill_1
XFILLER_0_55_350 VGND VGND VPWR VPWR sky130_fd_sc_hd__decap_8
XFILLER_0_62_309 VPWR VGND VPWR VGND sky130_ef_sc_hd__decap_12
XFILLER_0_15_225 VPWR VGND VPWR VGND sky130_ef_sc_hd__decap_12
X_3724_ _0317_ _0319_ VGND VGND VPWR VPWR _0320_ sky130_fd_sc_hd__xor2_1
XFILLER_0_70_353 VGND VGND VPWR VPWR sky130_fd_sc_hd__decap_8
X_3655_ _2936_ net8 _0250_ VGND VGND VPWR VPWR _0252_ sky130_fd_sc_hd__and3_1
XFILLER_0_2_163 VGND VGND VPWR VPWR sky130_fd_sc_hd__fill_1
X_3586_ _2988_ _3023_ VGND VGND VPWR VPWR _3024_ sky130_fd_sc_hd__xor2_1
X_5325_ _1509_ _0557_ _0702_ _2640_ VGND VGND VPWR VPWR _1889_ sky130_fd_sc_hd__a22oi_2
XFILLER_0_11_453 VGND VGND VPWR VPWR sky130_fd_sc_hd__fill_1
X_5256_ _1798_ _1819_ _1820_ VGND VGND VPWR VPWR _1821_ sky130_fd_sc_hd__and3_1
XFILLER_0_54_3 VPWR VGND VPWR VGND sky130_ef_sc_hd__decap_12
X_4207_ _0693_ _0729_ _0786_ VGND VGND VPWR VPWR _0787_ sky130_fd_sc_hd__a21o_1
X_5187_ _1750_ _1751_ _1669_ VGND VGND VPWR VPWR _1753_ sky130_fd_sc_hd__o21ai_1
X_4138_ _0716_ _0717_ _0653_ VGND VGND VPWR VPWR _0719_ sky130_fd_sc_hd__a21o_1
X_4069_ _0611_ _0639_ VGND VGND VPWR VPWR _0651_ sky130_fd_sc_hd__nand2_1
XTAP_TAPCELL_ROW_54_713 VGND VPWR sky130_fd_sc_hd__tapvpwrvgnd_1
XTAP_TAPCELL_ROW_26_448 VGND VPWR sky130_fd_sc_hd__tapvpwrvgnd_1
XFILLER_0_65_125 VGND VGND VPWR VPWR sky130_fd_sc_hd__decap_4
XFILLER_0_19_542 VGND VGND VPWR VPWR sky130_fd_sc_hd__fill_1
XFILLER_0_65_169 VPWR VGND VPWR VGND sky130_ef_sc_hd__decap_12
XTAP_TAPCELL_ROW_62_790 VGND VPWR sky130_fd_sc_hd__tapvpwrvgnd_1
XFILLER_0_21_206 VGND VGND VPWR VPWR sky130_fd_sc_hd__decap_6
XFILLER_0_21_217 VGND VGND VPWR VPWR sky130_fd_sc_hd__decap_6
XFILLER_0_28_29 VPWR VGND VPWR VGND sky130_ef_sc_hd__decap_12
XFILLER_0_84_434 VPWR VGND VPWR VGND sky130_ef_sc_hd__decap_12
XFILLER_0_44_309 VGND VGND VPWR VPWR sky130_fd_sc_hd__decap_3
XFILLER_0_69_47 VGND VGND VPWR VPWR sky130_fd_sc_hd__fill_2
X_3440_ _2834_ u_interface.u_compute_core.mac_accum\[24\] VGND VGND VPWR VPWR _2891_
+ sky130_fd_sc_hd__and2_1
XFILLER_0_52_397 VGND VGND VPWR VPWR sky130_fd_sc_hd__fill_2
X_3371_ u_interface.u_compute_core.u_mac.product_reg\[15\] VGND VGND VPWR VPWR _2832_
+ sky130_fd_sc_hd__clkbuf_4
X_5110_ _1673_ _1674_ _1675_ VGND VGND VPWR VPWR _1677_ sky130_fd_sc_hd__a21o_1
XFILLER_0_20_283 VGND VGND VPWR VPWR sky130_fd_sc_hd__decap_3
X_6090_ clknet_leaf_8_clk _0003_ VGND VGND VPWR VPWR u_interface.u_compute_core.relu_data\[3\]
+ sky130_fd_sc_hd__dfxtp_1
X_5041_ _1593_ _1607_ _1608_ VGND VGND VPWR VPWR _1609_ sky130_fd_sc_hd__nand3_1
XTAP_TAPCELL_ROW_68_849 VGND VPWR sky130_fd_sc_hd__tapvpwrvgnd_1
X_5943_ u_interface.core_attn_out\[26\] u_interface.u_compute_core.u_av.product_reg\[29\]
+ VGND VGND VPWR VPWR _2475_ sky130_fd_sc_hd__nor2_1
XFILLER_0_87_294 VGND VGND VPWR VPWR sky130_fd_sc_hd__decap_4
XTAP_TAPCELL_ROW_23_418 VGND VPWR sky130_fd_sc_hd__tapvpwrvgnd_1
X_5874_ u_interface.core_attn_out\[17\] u_interface.u_compute_core.u_av.product_reg\[20\]
+ VGND VGND VPWR VPWR _2415_ sky130_fd_sc_hd__or2_1
X_4825_ _1275_ _1277_ _1395_ _1394_ VGND VGND VPWR VPWR _1396_ sky130_fd_sc_hd__a211oi_1
XFILLER_0_16_501 VPWR VGND VPWR VGND sky130_ef_sc_hd__decap_12
XFILLER_0_47_169 VGND VGND VPWR VPWR sky130_fd_sc_hd__decap_8
XFILLER_0_90_448 VPWR VGND VPWR VGND sky130_ef_sc_hd__decap_12
XFILLER_0_28_394 VGND VGND VPWR VPWR sky130_fd_sc_hd__fill_1
XFILLER_0_50_60 VGND VGND VPWR VPWR sky130_fd_sc_hd__decap_6
XFILLER_0_7_299 VGND VGND VPWR VPWR sky130_fd_sc_hd__decap_3
XFILLER_0_16_545 VGND VGND VPWR VPWR sky130_fd_sc_hd__fill_2
XTAP_TAPCELL_ROW_31_495 VGND VPWR sky130_fd_sc_hd__tapvpwrvgnd_1
X_4756_ _0982_ _1327_ VGND VGND VPWR VPWR _1328_ sky130_fd_sc_hd__xnor2_2
XFILLER_0_50_82 VGND VGND VPWR VPWR sky130_fd_sc_hd__fill_2
X_3707_ _0301_ _0302_ VGND VGND VPWR VPWR _0303_ sky130_fd_sc_hd__nor2_1
X_4687_ _1257_ _1258_ _2735_ VGND VGND VPWR VPWR _1260_ sky130_fd_sc_hd__a21o_1
XFILLER_0_70_194 VGND VGND VPWR VPWR sky130_fd_sc_hd__fill_2
X_3638_ _0208_ _3034_ _0234_ _0235_ VGND VGND VPWR VPWR _0236_ sky130_fd_sc_hd__o211a_1
XFILLER_0_3_461 VPWR VGND VPWR VGND sky130_ef_sc_hd__decap_12
X_3569_ _3006_ _3007_ VGND VGND VPWR VPWR _3008_ sky130_fd_sc_hd__nor2_1
XFILLER_0_11_261 VPWR VGND VPWR VGND sky130_ef_sc_hd__decap_12
X_5308_ u_interface.u_compute_core.relu_data\[25\] _0494_ _1871_ VGND VGND VPWR VPWR
+ _1872_ sky130_fd_sc_hd__and3_1
X_6288_ clknet_leaf_14_clk _0201_ VGND VGND VPWR VPWR net49 sky130_fd_sc_hd__dfxtp_1
X_5239_ _1802_ _1803_ VGND VGND VPWR VPWR _1804_ sky130_fd_sc_hd__nor2_1
XTAP_TAPCELL_ROW_39_573 VGND VPWR sky130_fd_sc_hd__tapvpwrvgnd_1
XFILLER_0_78_261 VGND VGND VPWR VPWR sky130_fd_sc_hd__decap_3
XFILLER_0_66_456 VGND VGND VPWR VPWR sky130_fd_sc_hd__fill_1
XFILLER_0_26_309 VGND VGND VPWR VPWR sky130_fd_sc_hd__decap_4
XFILLER_0_38_169 VGND VGND VPWR VPWR sky130_fd_sc_hd__decap_4
XFILLER_0_55_27 VPWR VGND VPWR VGND sky130_ef_sc_hd__decap_12
XTAP_TAPCELL_ROW_65_819 VGND VPWR sky130_fd_sc_hd__tapvpwrvgnd_1
XFILLER_0_71_15 VPWR VGND VPWR VGND sky130_ef_sc_hd__decap_12
XTAP_TAPCELL_ROW_73_896 VGND VPWR sky130_fd_sc_hd__tapvpwrvgnd_1
XFILLER_0_84_253 VPWR VGND VPWR VGND sky130_ef_sc_hd__decap_12
XFILLER_0_29_169 VGND VGND VPWR VPWR sky130_fd_sc_hd__decap_4
XFILLER_0_57_467 VGND VGND VPWR VPWR sky130_fd_sc_hd__fill_2
XFILLER_0_72_415 VGND VGND VPWR VPWR sky130_fd_sc_hd__decap_4
X_4610_ _1035_ _1109_ VGND VGND VPWR VPWR _1184_ sky130_fd_sc_hd__nor2_1
X_5590_ _2142_ _2150_ VGND VGND VPWR VPWR _2151_ sky130_fd_sc_hd__xnor2_1
XFILLER_0_20_41 VGND VGND VPWR VPWR sky130_fd_sc_hd__decap_8
X_4541_ _0485_ net173 _0486_ _1115_ VGND VGND VPWR VPWR _0121_ sky130_fd_sc_hd__o211a_1
XFILLER_0_52_161 VGND VGND VPWR VPWR sky130_fd_sc_hd__fill_2
XFILLER_0_80_481 VGND VGND VPWR VPWR sky130_fd_sc_hd__fill_1
X_4472_ u_interface.u_compute_core.relu_data\[15\] u_interface.u_compute_core.relu_data\[14\]
+ _0492_ net14 VGND VGND VPWR VPWR _1047_ sky130_fd_sc_hd__and4_1
XFILLER_0_20_74 VGND VGND VPWR VPWR sky130_fd_sc_hd__decap_6
XFILLER_0_52_183 VPWR VGND VPWR VGND sky130_ef_sc_hd__decap_12
X_6211_ clknet_leaf_11_clk _0124_ VGND VGND VPWR VPWR u_interface.u_compute_core.u_av.product_reg\[18\]
+ sky130_fd_sc_hd__dfxtp_1
X_3423_ _2873_ _2875_ VGND VGND VPWR VPWR _2877_ sky130_fd_sc_hd__or2_1
X_6142_ clknet_leaf_18_clk _0055_ VGND VGND VPWR VPWR u_interface.u_compute_core.scaled_data\[26\]
+ sky130_fd_sc_hd__dfxtp_1
XFILLER_0_0_475 VGND VGND VPWR VPWR sky130_fd_sc_hd__fill_1
X_3354_ _2781_ _2816_ _2817_ _2746_ net171 VGND VGND VPWR VPWR _0071_ sky130_fd_sc_hd__a32o_1
X_6073_ net47 u_interface.core_attn_out\[27\] u_interface.core_valid_out VGND VGND
+ VPWR VPWR _2570_ sky130_fd_sc_hd__mux2_1
X_3285_ u_interface.u_compute_core.u_mac.product_reg\[3\] u_interface.u_compute_core.mac_accum\[3\]
+ VGND VGND VPWR VPWR _2758_ sky130_fd_sc_hd__or2_1
X_5024_ _1531_ _1533_ VGND VGND VPWR VPWR _1592_ sky130_fd_sc_hd__nand2_1
XTAP_TAPCELL_ROW_88_1040 VGND VPWR sky130_fd_sc_hd__tapvpwrvgnd_1
XFILLER_0_17_3 VGND VGND VPWR VPWR sky130_fd_sc_hd__fill_1
XFILLER_0_67_209 VGND VGND VPWR VPWR sky130_fd_sc_hd__fill_2
XTAP_TAPCELL_ROW_36_543 VGND VPWR sky130_fd_sc_hd__tapvpwrvgnd_1
XFILLER_0_45_93 VPWR VGND VPWR VGND sky130_ef_sc_hd__decap_12
X_5926_ u_interface.core_attn_out\[24\] u_interface.u_compute_core.u_av.product_reg\[27\]
+ VGND VGND VPWR VPWR _2460_ sky130_fd_sc_hd__nand2_1
XFILLER_0_48_445 VPWR VGND VPWR VGND sky130_ef_sc_hd__decap_12
XFILLER_0_8_531 VGND VGND VPWR VPWR sky130_fd_sc_hd__fill_1
X_5857_ _2387_ _2396_ _2395_ VGND VGND VPWR VPWR _2400_ sky130_fd_sc_hd__or3_1
XFILLER_0_48_489 VPWR VGND VPWR VGND sky130_ef_sc_hd__decap_12
X_4808_ _1376_ _1377_ _1375_ VGND VGND VPWR VPWR _1379_ sky130_fd_sc_hd__a21bo_1
X_5788_ _2334_ _2319_ _2339_ _2340_ _2581_ VGND VGND VPWR VPWR _0143_ sky130_fd_sc_hd__a221oi_1
X_4739_ _1213_ _1309_ VGND VGND VPWR VPWR _1311_ sky130_fd_sc_hd__nor2_1
XFILLER_0_43_150 VPWR VGND VPWR VGND sky130_ef_sc_hd__decap_12
XFILLER_0_16_397 VGND VGND VPWR VPWR sky130_fd_sc_hd__fill_2
XTAP_TAPCELL_ROW_8_279 VGND VPWR sky130_fd_sc_hd__tapvpwrvgnd_1
XFILLER_0_25_19 VGND VGND VPWR VPWR sky130_fd_sc_hd__fill_1
Xsplit21 u_interface.u_compute_core.relu_data\[5\] VGND VGND VPWR VPWR net86 sky130_fd_sc_hd__clkbuf_2
Xsplit54 u_interface.u_compute_core.relu_data\[14\] VGND VGND VPWR VPWR net119 sky130_fd_sc_hd__buf_6
XFILLER_0_66_253 VGND VGND VPWR VPWR sky130_fd_sc_hd__decap_4
XTAP_TAPCELL_ROW_70_866 VGND VPWR sky130_fd_sc_hd__tapvpwrvgnd_1
XFILLER_0_19_180 VGND VGND VPWR VPWR sky130_fd_sc_hd__fill_2
XFILLER_0_10_529 VGND VGND VPWR VPWR sky130_fd_sc_hd__decap_3
XFILLER_0_66_15 VPWR VGND VPWR VGND sky130_ef_sc_hd__decap_12
XTAP_TAPCELL_ROW_78_944 VGND VPWR sky130_fd_sc_hd__tapvpwrvgnd_1
X_3070_ _2582_ _2600_ VGND VGND VPWR VPWR _0004_ sky130_fd_sc_hd__nor2_1
X_3972_ _0556_ VGND VGND VPWR VPWR _0557_ sky130_fd_sc_hd__buf_6
XTAP_TAPCELL_ROW_33_513 VGND VPWR sky130_fd_sc_hd__tapvpwrvgnd_1
XFILLER_0_57_242 VPWR VGND VPWR VGND sky130_ef_sc_hd__decap_12
X_5711_ _1981_ _2146_ _2068_ VGND VGND VPWR VPWR _2270_ sky130_fd_sc_hd__mux2_1
XFILLER_0_72_212 VGND VGND VPWR VPWR sky130_fd_sc_hd__decap_6
XFILLER_0_45_437 VGND VGND VPWR VPWR sky130_fd_sc_hd__fill_2
X_5642_ _0648_ _2200_ _2201_ VGND VGND VPWR VPWR _2202_ sky130_fd_sc_hd__a21bo_1
XFILLER_0_32_109 VGND VGND VPWR VPWR sky130_fd_sc_hd__fill_1
XTAP_TAPCELL_ROW_41_590 VGND VPWR sky130_fd_sc_hd__tapvpwrvgnd_1
X_5573_ _2655_ _0648_ VGND VGND VPWR VPWR _2134_ sky130_fd_sc_hd__nand2_2
X_4524_ _1098_ _1097_ _1045_ VGND VGND VPWR VPWR _1099_ sky130_fd_sc_hd__or3_4
XFILLER_0_13_378 VGND VGND VPWR VPWR sky130_fd_sc_hd__decap_3
X_4455_ _0966_ _0968_ VGND VGND VPWR VPWR _1031_ sky130_fd_sc_hd__nand2_1
XFILLER_0_0_272 VGND VGND VPWR VPWR sky130_fd_sc_hd__decap_4
X_3406_ _2843_ _2845_ _2852_ _2855_ VGND VGND VPWR VPWR _2862_ sky130_fd_sc_hd__nor4b_1
X_4386_ _0960_ _0961_ _0940_ VGND VGND VPWR VPWR _0963_ sky130_fd_sc_hd__o21ai_1
XFILLER_0_0_294 VGND VGND VPWR VPWR sky130_fd_sc_hd__decap_3
X_3337_ _2796_ _2801_ _2802_ VGND VGND VPWR VPWR _2803_ sky130_fd_sc_hd__or3_1
X_6125_ clknet_leaf_4_clk _0038_ VGND VGND VPWR VPWR u_interface.u_compute_core.scaled_data\[9\]
+ sky130_fd_sc_hd__dfxtp_1
XTAP_TAPCELL_ROW_5_249 VGND VPWR sky130_fd_sc_hd__tapvpwrvgnd_1
X_3268_ u_interface.u_compute_core.u_mac.product_reg\[0\] u_interface.u_compute_core.mac_accum\[0\]
+ _2742_ VGND VGND VPWR VPWR _2743_ sky130_fd_sc_hd__nand3_1
X_6056_ _2539_ _2558_ VGND VGND VPWR VPWR _2559_ sky130_fd_sc_hd__and2_1
X_5007_ u_interface.u_compute_core.relu_data\[21\] _2640_ _0495_ _0557_ VGND VGND
+ VPWR VPWR _1575_ sky130_fd_sc_hd__and4_1
X_3199_ u_interface.u_compute_core.scaled_data\[10\] u_interface.u_compute_core.mac_accum\[13\]
+ _2691_ VGND VGND VPWR VPWR _2695_ sky130_fd_sc_hd__mux2_1
X_5909_ net191 _2309_ _2444_ _2445_ _0486_ VGND VGND VPWR VPWR _0159_ sky130_fd_sc_hd__o221a_1
XFILLER_0_63_223 VGND VGND VPWR VPWR sky130_fd_sc_hd__fill_1
XFILLER_0_63_289 VGND VGND VPWR VPWR sky130_fd_sc_hd__fill_2
XFILLER_0_63_278 VGND VGND VPWR VPWR sky130_fd_sc_hd__fill_2
XFILLER_0_51_429 VGND VGND VPWR VPWR sky130_fd_sc_hd__decap_8
XFILLER_0_6_3 VGND VGND VPWR VPWR sky130_fd_sc_hd__decap_8
XTAP_TAPCELL_ROW_75_914 VGND VPWR sky130_fd_sc_hd__tapvpwrvgnd_1
XTAP_TAPCELL_ROW_47_649 VGND VPWR sky130_fd_sc_hd__tapvpwrvgnd_1
XFILLER_0_86_359 VGND VGND VPWR VPWR sky130_fd_sc_hd__decap_4
XTAP_TAPCELL_ROW_83_991 VGND VPWR sky130_fd_sc_hd__tapvpwrvgnd_1
XTAP_TAPCELL_ROW_10_295 VGND VPWR sky130_fd_sc_hd__tapvpwrvgnd_1
XFILLER_0_22_164 VPWR VGND VPWR VGND sky130_ef_sc_hd__decap_12
X_4240_ _0594_ VGND VGND VPWR VPWR _0819_ sky130_fd_sc_hd__buf_6
XFILLER_0_22_197 VPWR VGND VPWR VGND sky130_ef_sc_hd__decap_12
X_4171_ _2592_ _0750_ _0704_ VGND VGND VPWR VPWR _0751_ sky130_fd_sc_hd__mux2_1
X_3122_ u_interface.u_compute_core.relu_data\[17\] VGND VGND VPWR VPWR _2640_ sky130_fd_sc_hd__buf_2
XTAP_TAPCELL_ROW_2_219 VGND VPWR sky130_fd_sc_hd__tapvpwrvgnd_1
X_3053_ u_interface.u_compute_core.scaled_data\[0\] _2584_ _2585_ _2587_ VGND VGND
+ VPWR VPWR _2588_ sky130_fd_sc_hd__o2bb2a_1
XFILLER_0_89_164 VGND VGND VPWR VPWR sky130_fd_sc_hd__fill_1
XTAP_TAPCELL_ROW_85_1010 VGND VPWR sky130_fd_sc_hd__tapvpwrvgnd_1
XTAP_TAPCELL_ROW_18_373 VGND VPWR sky130_fd_sc_hd__tapvpwrvgnd_1
X_3955_ _0509_ _0512_ _0539_ VGND VGND VPWR VPWR _0541_ sky130_fd_sc_hd__or3_1
XFILLER_0_42_83 VGND VGND VPWR VPWR sky130_fd_sc_hd__fill_1
XFILLER_0_45_223 VGND VGND VPWR VPWR sky130_fd_sc_hd__fill_1
X_3886_ _2741_ _0474_ _0475_ _0476_ VGND VGND VPWR VPWR _0105_ sky130_fd_sc_hd__a31o_1
X_5625_ _2122_ _2123_ _2184_ VGND VGND VPWR VPWR _2186_ sky130_fd_sc_hd__a21o_1
XFILLER_0_84_3 VPWR VGND VPWR VGND sky130_ef_sc_hd__decap_12
XFILLER_0_13_120 VPWR VGND VPWR VGND sky130_ef_sc_hd__decap_12
X_5556_ _2037_ _2036_ _2117_ VGND VGND VPWR VPWR _2118_ sky130_fd_sc_hd__a21o_1
X_4507_ _1010_ _1080_ _1081_ VGND VGND VPWR VPWR _1082_ sky130_fd_sc_hd__nand3_1
X_5487_ _2660_ _0536_ _0559_ _1644_ VGND VGND VPWR VPWR _2049_ sky130_fd_sc_hd__a22oi_1
XTAP_TAPCELL_ROW_92_1069 VGND VPWR sky130_fd_sc_hd__tapvpwrvgnd_1
X_4438_ _1010_ _1012_ _1013_ VGND VGND VPWR VPWR _1014_ sky130_fd_sc_hd__nand3_1
X_4369_ _2598_ _0633_ _0944_ _0945_ VGND VGND VPWR VPWR _0946_ sky130_fd_sc_hd__nand4_1
X_6108_ clknet_leaf_9_clk _0021_ VGND VGND VPWR VPWR u_interface.u_compute_core.relu_data\[21\]
+ sky130_fd_sc_hd__dfxtp_1
X_6039_ _2539_ _2547_ VGND VGND VPWR VPWR _2548_ sky130_fd_sc_hd__and2_1
Xrebuffer50 _1548_ VGND VGND VPWR VPWR net115 sky130_fd_sc_hd__buf_4
Xrebuffer61 _1566_ VGND VGND VPWR VPWR net126 sky130_fd_sc_hd__dlymetal6s2s_1
XTAP_TAPCELL_ROW_44_619 VGND VPWR sky130_fd_sc_hd__tapvpwrvgnd_1
XTAP_TAPCELL_ROW_80_961 VGND VPWR sky130_fd_sc_hd__tapvpwrvgnd_1
XTAP_TAPCELL_ROW_52_696 VGND VPWR sky130_fd_sc_hd__tapvpwrvgnd_1
XFILLER_0_51_248 VPWR VGND VPWR VGND sky130_ef_sc_hd__decap_12
XFILLER_0_32_473 VGND VGND VPWR VPWR sky130_fd_sc_hd__decap_3
XFILLER_0_63_27 VPWR VGND VPWR VGND sky130_ef_sc_hd__decap_12
XFILLER_0_74_307 VGND VGND VPWR VPWR sky130_fd_sc_hd__fill_1
XTAP_TAPCELL_ROW_15_343 VGND VPWR sky130_fd_sc_hd__tapvpwrvgnd_1
X_3740_ _0333_ _0327_ VGND VGND VPWR VPWR _0335_ sky130_fd_sc_hd__or2b_1
XFILLER_0_27_223 VGND VGND VPWR VPWR sky130_fd_sc_hd__fill_1
XFILLER_0_82_340 VGND VGND VPWR VPWR sky130_fd_sc_hd__fill_1
XFILLER_0_12_53 VGND VGND VPWR VPWR sky130_fd_sc_hd__decap_8
XFILLER_0_6_139 VGND VGND VPWR VPWR sky130_fd_sc_hd__fill_1
XFILLER_0_82_373 VPWR VGND VPWR VGND sky130_ef_sc_hd__decap_12
X_3671_ _2945_ _2961_ _0210_ _0212_ VGND VGND VPWR VPWR _0268_ sky130_fd_sc_hd__a31o_1
XFILLER_0_2_301 VGND VGND VPWR VPWR sky130_fd_sc_hd__decap_6
XFILLER_0_42_259 VGND VGND VPWR VPWR sky130_fd_sc_hd__decap_6
X_5410_ _1958_ _1972_ VGND VGND VPWR VPWR _1973_ sky130_fd_sc_hd__xor2_1
X_5341_ _1902_ _1903_ _1821_ VGND VGND VPWR VPWR _1905_ sky130_fd_sc_hd__a21oi_1
XFILLER_0_2_345 VPWR VGND VPWR VGND sky130_ef_sc_hd__decap_12
XFILLER_0_2_389 VPWR VGND VPWR VGND sky130_ef_sc_hd__decap_12
XFILLER_0_23_495 VGND VGND VPWR VPWR sky130_fd_sc_hd__fill_1
X_5272_ _1826_ _1835_ _1836_ VGND VGND VPWR VPWR _1837_ sky130_fd_sc_hd__nand3_1
XFILLER_0_10_145 VPWR VGND VPWR VGND sky130_ef_sc_hd__decap_12
X_4223_ _2622_ _0493_ _0496_ _2619_ VGND VGND VPWR VPWR _0802_ sky130_fd_sc_hd__a22o_1
XFILLER_0_10_178 VGND VGND VPWR VPWR sky130_fd_sc_hd__decap_4
X_4154_ _0521_ u_interface.u_compute_core.u_av.product_reg\[9\] VGND VGND VPWR VPWR
+ _0735_ sky130_fd_sc_hd__or2_1
X_3105_ _2609_ _2627_ VGND VGND VPWR VPWR _0012_ sky130_fd_sc_hd__nor2_1
X_4085_ _2604_ _2601_ _0498_ _0488_ VGND VGND VPWR VPWR _0667_ sky130_fd_sc_hd__nand4_1
XFILLER_0_77_167 VGND VGND VPWR VPWR sky130_fd_sc_hd__fill_1
XFILLER_0_92_137 VGND VGND VPWR VPWR sky130_fd_sc_hd__decap_3
X_4987_ _1554_ net109 VGND VGND VPWR VPWR _1556_ sky130_fd_sc_hd__nor2_1
X_3938_ _0501_ _0507_ VGND VGND VPWR VPWR _0524_ sky130_fd_sc_hd__nor2_1
X_3869_ _0371_ _0459_ VGND VGND VPWR VPWR _0460_ sky130_fd_sc_hd__or2_1
XFILLER_0_33_237 VGND VGND VPWR VPWR sky130_fd_sc_hd__decap_4
X_5608_ _1639_ _2087_ _2167_ VGND VGND VPWR VPWR _2169_ sky130_fd_sc_hd__nand3_1
X_5539_ _2094_ _2095_ _2100_ VGND VGND VPWR VPWR _2101_ sky130_fd_sc_hd__nor3_1
XFILLER_0_78_90 VGND VGND VPWR VPWR sky130_fd_sc_hd__decap_8
XTAP_TAPCELL_ROW_57_744 VGND VPWR sky130_fd_sc_hd__tapvpwrvgnd_1
XTAP_TAPCELL_ROW_29_479 VGND VPWR sky130_fd_sc_hd__tapvpwrvgnd_1
XFILLER_0_68_123 VGND VGND VPWR VPWR sky130_fd_sc_hd__decap_4
XFILLER_0_56_307 VGND VGND VPWR VPWR sky130_fd_sc_hd__fill_1
XFILLER_0_37_521 VPWR VGND VPWR VGND sky130_ef_sc_hd__decap_12
XFILLER_0_83_159 VGND VGND VPWR VPWR sky130_fd_sc_hd__decap_8
XFILLER_0_64_362 VGND VGND VPWR VPWR sky130_fd_sc_hd__fill_2
XTAP_TAPCELL_ROW_12_313 VGND VPWR sky130_fd_sc_hd__tapvpwrvgnd_1
XFILLER_0_91_181 VPWR VGND VPWR VGND sky130_ef_sc_hd__decap_12
XFILLER_0_64_384 VGND VGND VPWR VPWR sky130_fd_sc_hd__decap_3
Xinput17 s_tdata[22] VGND VGND VPWR VPWR net17 sky130_fd_sc_hd__dlymetal6s2s_1
XTAP_TAPCELL_ROW_20_390 VGND VPWR sky130_fd_sc_hd__tapvpwrvgnd_1
XFILLER_0_20_421 VGND VGND VPWR VPWR sky130_fd_sc_hd__fill_1
XFILLER_0_58_27 VGND VGND VPWR VPWR sky130_fd_sc_hd__fill_1
X_5890_ u_interface.core_attn_out\[19\] u_interface.u_compute_core.u_av.product_reg\[22\]
+ VGND VGND VPWR VPWR _2429_ sky130_fd_sc_hd__nand2_1
X_4910_ _1331_ _1404_ _1330_ _1403_ VGND VGND VPWR VPWR _1480_ sky130_fd_sc_hd__nand4bb_4
X_4841_ _1310_ _1387_ VGND VGND VPWR VPWR _1411_ sky130_fd_sc_hd__or2_1
XFILLER_0_47_329 VGND VGND VPWR VPWR sky130_fd_sc_hd__decap_6
X_4772_ _1191_ _1194_ VGND VGND VPWR VPWR _1343_ sky130_fd_sc_hd__and2_1
XFILLER_0_82_181 VGND VGND VPWR VPWR sky130_fd_sc_hd__decap_8
X_3723_ _0267_ _0271_ _0318_ VGND VGND VPWR VPWR _0319_ sky130_fd_sc_hd__a21oi_1
XFILLER_0_43_524 VPWR VGND VPWR VGND sky130_ef_sc_hd__decap_12
XFILLER_0_55_373 VPWR VGND VPWR VGND sky130_ef_sc_hd__decap_12
XFILLER_0_70_332 VGND VGND VPWR VPWR sky130_fd_sc_hd__fill_1
XFILLER_0_15_237 VPWR VGND VPWR VGND sky130_ef_sc_hd__decap_12
X_3654_ _2936_ net8 _0250_ VGND VGND VPWR VPWR _0251_ sky130_fd_sc_hd__a21oi_1
XFILLER_0_70_365 VPWR VGND VPWR VGND sky130_ef_sc_hd__decap_12
X_3585_ _3016_ _3022_ VGND VGND VPWR VPWR _3023_ sky130_fd_sc_hd__xnor2_1
XFILLER_0_23_281 VPWR VGND VPWR VGND sky130_ef_sc_hd__decap_12
X_5324_ _1655_ _1887_ VGND VGND VPWR VPWR _1888_ sky130_fd_sc_hd__xnor2_1
X_5255_ _1817_ _1818_ _1801_ VGND VGND VPWR VPWR _1820_ sky130_fd_sc_hd__a21o_1
X_4206_ _0694_ _0728_ VGND VGND VPWR VPWR _0786_ sky130_fd_sc_hd__nor2_1
XFILLER_0_47_3 VPWR VGND VPWR VGND sky130_ef_sc_hd__decap_12
XFILLER_0_48_93 VGND VGND VPWR VPWR sky130_fd_sc_hd__fill_2
X_5186_ _1669_ _1750_ _1751_ VGND VGND VPWR VPWR _1752_ sky130_fd_sc_hd__or3_4
XFILLER_0_3_51 VGND VGND VPWR VPWR sky130_fd_sc_hd__decap_4
X_4137_ _0653_ _0716_ _0717_ VGND VGND VPWR VPWR _0718_ sky130_fd_sc_hd__nand3_1
XFILLER_0_78_421 VPWR VGND VPWR VGND sky130_ef_sc_hd__decap_12
XFILLER_0_3_84 VGND VGND VPWR VPWR sky130_fd_sc_hd__fill_1
X_4068_ _0487_ _0648_ _0631_ _0649_ VGND VGND VPWR VPWR _0650_ sky130_fd_sc_hd__a31o_1
XTAP_TAPCELL_ROW_54_714 VGND VPWR sky130_fd_sc_hd__tapvpwrvgnd_1
XTAP_TAPCELL_ROW_26_449 VGND VPWR sky130_fd_sc_hd__tapvpwrvgnd_1
XFILLER_0_38_307 VGND VGND VPWR VPWR sky130_fd_sc_hd__fill_1
XFILLER_0_19_510 VPWR VGND VPWR VGND sky130_ef_sc_hd__decap_12
XTAP_TAPCELL_ROW_62_791 VGND VPWR sky130_fd_sc_hd__tapvpwrvgnd_1
XFILLER_0_73_181 VPWR VGND VPWR VGND sky130_ef_sc_hd__decap_12
XFILLER_0_44_29 VGND VGND VPWR VPWR sky130_fd_sc_hd__decap_6
XFILLER_0_84_446 VPWR VGND VPWR VGND sky130_ef_sc_hd__decap_12
XFILLER_0_84_468 VGND VGND VPWR VPWR sky130_fd_sc_hd__decap_4
XFILLER_0_56_159 VGND VGND VPWR VPWR sky130_fd_sc_hd__fill_1
XFILLER_0_25_513 VPWR VGND VPWR VGND sky130_ef_sc_hd__decap_12
XFILLER_0_8_29 VGND VGND VPWR VPWR sky130_fd_sc_hd__decap_8
XFILLER_0_52_321 VGND VGND VPWR VPWR sky130_fd_sc_hd__decap_4
XFILLER_0_69_15 VPWR VGND VPWR VGND sky130_ef_sc_hd__decap_12
XFILLER_0_52_365 VPWR VGND VPWR VGND sky130_ef_sc_hd__decap_12
XFILLER_0_20_251 VGND VGND VPWR VPWR sky130_fd_sc_hd__fill_1
X_3370_ u_interface.u_compute_core.u_mac.product_reg\[15\] u_interface.u_compute_core.mac_accum\[15\]
+ VGND VGND VPWR VPWR _2831_ sky130_fd_sc_hd__nand2_1
X_5040_ _1605_ _1604_ _1606_ VGND VGND VPWR VPWR _1608_ sky130_fd_sc_hd__a21o_1
XFILLER_0_20_295 VPWR VGND VPWR VGND sky130_ef_sc_hd__decap_12
XFILLER_0_18_85 VPWR VGND VPWR VGND sky130_ef_sc_hd__decap_12
XFILLER_0_79_229 VGND VGND VPWR VPWR sky130_fd_sc_hd__fill_1
X_5942_ u_interface.core_attn_out\[25\] u_interface.u_compute_core.u_av.product_reg\[28\]
+ VGND VGND VPWR VPWR _2474_ sky130_fd_sc_hd__or2_1
XFILLER_0_47_104 VGND VGND VPWR VPWR sky130_fd_sc_hd__fill_1
XFILLER_0_75_446 VGND VGND VPWR VPWR sky130_fd_sc_hd__fill_2
XFILLER_0_75_435 VGND VGND VPWR VPWR sky130_fd_sc_hd__fill_1
XFILLER_0_75_424 VGND VGND VPWR VPWR sky130_fd_sc_hd__fill_2
XTAP_TAPCELL_ROW_23_419 VGND VPWR sky130_fd_sc_hd__tapvpwrvgnd_1
X_5873_ _2320_ _2413_ _2414_ _2327_ VGND VGND VPWR VPWR _0154_ sky130_fd_sc_hd__o211a_1
X_4824_ _1392_ _1393_ net122 _1319_ VGND VGND VPWR VPWR _1395_ sky130_fd_sc_hd__a211oi_4
XFILLER_0_16_513 VPWR VGND VPWR VGND sky130_ef_sc_hd__decap_12
X_4755_ _1325_ _1326_ VGND VGND VPWR VPWR _1327_ sky130_fd_sc_hd__nor2_1
X_3706_ _2945_ _2970_ _2992_ _0300_ VGND VGND VPWR VPWR _0302_ sky130_fd_sc_hd__and4_1
XFILLER_0_70_162 VGND VGND VPWR VPWR sky130_fd_sc_hd__decap_3
XTAP_TAPCELL_ROW_31_496 VGND VPWR sky130_fd_sc_hd__tapvpwrvgnd_1
X_4686_ _1257_ _1258_ VGND VGND VPWR VPWR _1259_ sky130_fd_sc_hd__nor2_1
X_3637_ _0223_ _0233_ VGND VGND VPWR VPWR _0235_ sky130_fd_sc_hd__nand2_1
X_3568_ _3003_ _3004_ _3005_ VGND VGND VPWR VPWR _3007_ sky130_fd_sc_hd__o21a_1
XFILLER_0_3_473 VPWR VGND VPWR VGND sky130_ef_sc_hd__decap_12
XFILLER_0_11_273 VGND VGND VPWR VPWR sky130_fd_sc_hd__decap_6
X_5307_ u_interface.u_compute_core.relu_data\[26\] _0504_ VGND VGND VPWR VPWR _1871_
+ sky130_fd_sc_hd__and2_1
X_6287_ clknet_leaf_14_clk _0200_ VGND VGND VPWR VPWR net48 sky130_fd_sc_hd__dfxtp_1
X_3499_ _2929_ _2935_ _2939_ _2940_ VGND VGND VPWR VPWR _2941_ sky130_fd_sc_hd__a22o_1
X_5238_ _2650_ _2647_ _0558_ _0596_ VGND VGND VPWR VPWR _1803_ sky130_fd_sc_hd__and4_1
X_5169_ _1733_ _1734_ VGND VGND VPWR VPWR _1735_ sky130_fd_sc_hd__xor2_2
XTAP_TAPCELL_ROW_39_574 VGND VPWR sky130_fd_sc_hd__tapvpwrvgnd_1
XFILLER_0_81_416 VGND VGND VPWR VPWR sky130_fd_sc_hd__decap_3
XPHY_EDGE_ROW_49_Left_142 VGND VGND VPWR VPWR sky130_fd_sc_hd__decap_3
XFILLER_0_81_449 VGND VGND VPWR VPWR sky130_fd_sc_hd__decap_8
XFILLER_0_34_343 VGND VGND VPWR VPWR sky130_fd_sc_hd__decap_6
XFILLER_0_46_192 VGND VGND VPWR VPWR sky130_fd_sc_hd__decap_4
XFILLER_0_61_173 VGND VGND VPWR VPWR sky130_fd_sc_hd__fill_1
XPHY_EDGE_ROW_58_Left_151 VGND VGND VPWR VPWR sky130_fd_sc_hd__decap_3
XFILLER_0_89_505 VPWR VGND VPWR VGND sky130_ef_sc_hd__decap_12
XFILLER_0_55_39 VPWR VGND VPWR VGND sky130_ef_sc_hd__decap_12
XFILLER_0_71_27 VPWR VGND VPWR VGND sky130_ef_sc_hd__decap_12
XTAP_TAPCELL_ROW_73_897 VGND VPWR sky130_fd_sc_hd__tapvpwrvgnd_1
XFILLER_0_57_446 VGND VGND VPWR VPWR sky130_fd_sc_hd__fill_2
XFILLER_0_84_265 VGND VGND VPWR VPWR sky130_fd_sc_hd__decap_6
XPHY_EDGE_ROW_67_Left_160 VGND VGND VPWR VPWR sky130_fd_sc_hd__decap_3
XFILLER_0_44_107 VPWR VGND VPWR VGND sky130_ef_sc_hd__decap_12
XFILLER_0_4_215 VPWR VGND VPWR VGND sky130_ef_sc_hd__decap_12
XFILLER_0_25_321 VGND VGND VPWR VPWR sky130_fd_sc_hd__decap_3
X_4540_ _0521_ _1114_ VGND VGND VPWR VPWR _1115_ sky130_fd_sc_hd__nand2_1
Xclkbuf_leaf_10_clk clknet_1_1__leaf_clk VGND VGND VPWR VPWR clknet_leaf_10_clk sky130_fd_sc_hd__clkbuf_8
X_4471_ _2628_ _0499_ VGND VGND VPWR VPWR _1046_ sky130_fd_sc_hd__nand2_1
XFILLER_0_52_195 VGND VGND VPWR VPWR sky130_fd_sc_hd__fill_1
XFILLER_0_0_421 VPWR VGND VPWR VGND sky130_ef_sc_hd__decap_12
X_6210_ clknet_leaf_10_clk _0123_ VGND VGND VPWR VPWR u_interface.u_compute_core.u_av.product_reg\[17\]
+ sky130_fd_sc_hd__dfxtp_1
X_3422_ _2873_ _2875_ VGND VGND VPWR VPWR _2876_ sky130_fd_sc_hd__nand2_1
X_6141_ clknet_leaf_18_clk _0054_ VGND VGND VPWR VPWR u_interface.u_compute_core.scaled_data\[25\]
+ sky130_fd_sc_hd__dfxtp_1
X_3353_ _2811_ _2815_ _2814_ VGND VGND VPWR VPWR _2817_ sky130_fd_sc_hd__o21ai_1
X_6072_ _2569_ VGND VGND VPWR VPWR _0198_ sky130_fd_sc_hd__clkbuf_1
X_3284_ u_interface.u_compute_core.u_mac.product_reg\[3\] u_interface.u_compute_core.mac_accum\[3\]
+ VGND VGND VPWR VPWR _2757_ sky130_fd_sc_hd__nand2_1
X_5023_ _1570_ _1590_ VGND VGND VPWR VPWR _1591_ sky130_fd_sc_hd__xnor2_1
XTAP_TAPCELL_ROW_36_544 VGND VPWR sky130_fd_sc_hd__tapvpwrvgnd_1
XFILLER_0_75_221 VGND VGND VPWR VPWR sky130_fd_sc_hd__decap_3
XFILLER_0_0_41 VGND VGND VPWR VPWR sky130_fd_sc_hd__decap_4
X_5925_ net188 _2309_ _2458_ _2459_ _0486_ VGND VGND VPWR VPWR _0161_ sky130_fd_sc_hd__o221a_1
XFILLER_0_75_254 VGND VGND VPWR VPWR sky130_fd_sc_hd__fill_1
XFILLER_0_63_405 VPWR VGND VPWR VGND sky130_ef_sc_hd__decap_12
XFILLER_0_0_85 VGND VGND VPWR VPWR sky130_fd_sc_hd__fill_2
X_5856_ _2320_ _2398_ _2399_ _2327_ VGND VGND VPWR VPWR _0152_ sky130_fd_sc_hd__o211a_1
XFILLER_0_48_457 VPWR VGND VPWR VGND sky130_ef_sc_hd__decap_12
XFILLER_0_61_60 VPWR VGND VPWR VGND sky130_ef_sc_hd__decap_12
X_4807_ _1375_ _1376_ _1377_ VGND VGND VPWR VPWR _1378_ sky130_fd_sc_hd__nand3b_1
XPHY_EDGE_ROW_3_Right_3 VGND VGND VPWR VPWR sky130_fd_sc_hd__decap_3
X_5787_ _2335_ _2338_ _2308_ VGND VGND VPWR VPWR _2340_ sky130_fd_sc_hd__o21a_1
XFILLER_0_16_343 VGND VGND VPWR VPWR sky130_fd_sc_hd__decap_8
X_4738_ _1213_ _1309_ VGND VGND VPWR VPWR _1310_ sky130_fd_sc_hd__and2_1
XFILLER_0_16_365 VGND VGND VPWR VPWR sky130_fd_sc_hd__decap_4
XFILLER_0_43_162 VGND VGND VPWR VPWR sky130_fd_sc_hd__decap_6
X_4669_ _1241_ _1214_ VGND VGND VPWR VPWR _1242_ sky130_fd_sc_hd__xnor2_1
XFILLER_0_71_482 VGND VGND VPWR VPWR sky130_fd_sc_hd__fill_2
XFILLER_0_3_281 VPWR VGND VPWR VGND sky130_ef_sc_hd__decap_12
Xclkbuf_1_1__f_clk clknet_0_clk VGND VGND VPWR VPWR clknet_1_1__leaf_clk sky130_fd_sc_hd__clkbuf_16
XFILLER_0_81_213 VGND VGND VPWR VPWR sky130_fd_sc_hd__decap_3
XTAP_TAPCELL_ROW_70_867 VGND VPWR sky130_fd_sc_hd__tapvpwrvgnd_1
XFILLER_0_19_192 VGND VGND VPWR VPWR sky130_fd_sc_hd__fill_1
XFILLER_0_66_27 VGND VGND VPWR VPWR sky130_fd_sc_hd__fill_1
XTAP_TAPCELL_ROW_78_945 VGND VPWR sky130_fd_sc_hd__tapvpwrvgnd_1
XFILLER_0_82_15 VPWR VGND VPWR VGND sky130_ef_sc_hd__decap_12
XFILLER_0_15_31 VPWR VGND VPWR VGND sky130_ef_sc_hd__decap_12
X_3971_ net22 VGND VGND VPWR VPWR _0556_ sky130_fd_sc_hd__buf_6
XFILLER_0_85_541 VGND VGND VPWR VPWR sky130_fd_sc_hd__decap_6
XFILLER_0_9_329 VGND VGND VPWR VPWR sky130_fd_sc_hd__decap_4
XTAP_TAPCELL_ROW_33_514 VGND VPWR sky130_fd_sc_hd__tapvpwrvgnd_1
X_5710_ _2261_ _2268_ VGND VGND VPWR VPWR _2269_ sky130_fd_sc_hd__xnor2_1
XFILLER_0_57_254 VGND VGND VPWR VPWR sky130_fd_sc_hd__fill_2
XFILLER_0_45_405 VGND VGND VPWR VPWR sky130_fd_sc_hd__decap_6
X_5641_ _2660_ _0597_ _0648_ _1644_ VGND VGND VPWR VPWR _2201_ sky130_fd_sc_hd__a22o_1
XFILLER_0_72_279 VGND VGND VPWR VPWR sky130_fd_sc_hd__decap_3
XTAP_TAPCELL_ROW_41_591 VGND VPWR sky130_fd_sc_hd__tapvpwrvgnd_1
X_5572_ _2131_ _2132_ VGND VGND VPWR VPWR _2133_ sky130_fd_sc_hd__nor2_1
X_4523_ _1095_ _1096_ _1073_ VGND VGND VPWR VPWR _1098_ sky130_fd_sc_hd__a21oi_1
X_4454_ net80 _1029_ VGND VGND VPWR VPWR _1030_ sky130_fd_sc_hd__xnor2_2
XFILLER_0_21_390 VGND VGND VPWR VPWR sky130_fd_sc_hd__fill_2
X_3405_ _2859_ _2860_ VGND VGND VPWR VPWR _2861_ sky130_fd_sc_hd__nor2_1
X_4385_ _0940_ _0961_ _0960_ VGND VGND VPWR VPWR _0962_ sky130_fd_sc_hd__or3_4
X_3336_ _2794_ _2795_ VGND VGND VPWR VPWR _2802_ sky130_fd_sc_hd__nor2_1
X_6124_ clknet_leaf_4_clk _0037_ VGND VGND VPWR VPWR u_interface.u_compute_core.scaled_data\[8\]
+ sky130_fd_sc_hd__dfxtp_1
X_6055_ net41 u_interface.core_attn_out\[21\] _2544_ VGND VGND VPWR VPWR _2558_ sky130_fd_sc_hd__mux2_1
X_5006_ _1358_ _1573_ _1511_ VGND VGND VPWR VPWR _1574_ sky130_fd_sc_hd__nor3b_1
X_3267_ u_interface.u_compute_core.u_mac.product_reg\[1\] u_interface.u_compute_core.mac_accum\[1\]
+ VGND VGND VPWR VPWR _2742_ sky130_fd_sc_hd__xor2_1
XFILLER_0_56_71 VGND VGND VPWR VPWR sky130_fd_sc_hd__fill_2
X_3198_ _2580_ VGND VGND VPWR VPWR _2694_ sky130_fd_sc_hd__clkbuf_2
X_5908_ _2436_ _2438_ _2443_ _2318_ VGND VGND VPWR VPWR _2445_ sky130_fd_sc_hd__a31o_1
XFILLER_0_48_287 VPWR VGND VPWR VGND sky130_ef_sc_hd__decap_12
XFILLER_0_63_213 VGND VGND VPWR VPWR sky130_fd_sc_hd__fill_1
X_5839_ _2382_ _2384_ VGND VGND VPWR VPWR _2385_ sky130_fd_sc_hd__xor2_1
XFILLER_0_29_490 VGND VGND VPWR VPWR sky130_fd_sc_hd__fill_1
XFILLER_0_63_257 VGND VGND VPWR VPWR sky130_fd_sc_hd__fill_1
XTAP_TAPCELL_ROW_75_915 VGND VPWR sky130_fd_sc_hd__tapvpwrvgnd_1
XFILLER_0_52_29 VPWR VGND VPWR VGND sky130_ef_sc_hd__decap_12
XTAP_TAPCELL_ROW_83_992 VGND VPWR sky130_fd_sc_hd__tapvpwrvgnd_1
XFILLER_0_39_265 VGND VGND VPWR VPWR sky130_fd_sc_hd__decap_8
XFILLER_0_82_533 VPWR VGND VPWR VGND sky130_ef_sc_hd__decap_12
XFILLER_0_54_246 VGND VGND VPWR VPWR sky130_fd_sc_hd__decap_6
XTAP_TAPCELL_ROW_10_296 VGND VPWR sky130_fd_sc_hd__tapvpwrvgnd_1
XFILLER_0_22_154 VGND VGND VPWR VPWR sky130_fd_sc_hd__decap_4
XFILLER_0_22_176 VGND VGND VPWR VPWR sky130_fd_sc_hd__decap_4
XFILLER_0_50_474 VGND VGND VPWR VPWR sky130_fd_sc_hd__fill_2
X_4170_ _2592_ _0634_ VGND VGND VPWR VPWR _0750_ sky130_fd_sc_hd__nand2_1
X_3121_ _2609_ _2639_ VGND VGND VPWR VPWR _0016_ sky130_fd_sc_hd__nor2_1
X_3052_ _2586_ VGND VGND VPWR VPWR _2587_ sky130_fd_sc_hd__buf_2
XTAP_TAPCELL_ROW_85_1011 VGND VPWR sky130_fd_sc_hd__tapvpwrvgnd_1
XFILLER_0_26_85 VGND VGND VPWR VPWR sky130_fd_sc_hd__decap_4
XTAP_TAPCELL_ROW_18_374 VGND VPWR sky130_fd_sc_hd__tapvpwrvgnd_1
XFILLER_0_73_500 VGND VGND VPWR VPWR sky130_fd_sc_hd__decap_4
X_3954_ _0509_ _0512_ _0539_ VGND VGND VPWR VPWR _0540_ sky130_fd_sc_hd__o21ai_1
XFILLER_0_85_393 VPWR VGND VPWR VGND sky130_ef_sc_hd__decap_12
X_3885_ net223 _2745_ VGND VGND VPWR VPWR _0476_ sky130_fd_sc_hd__and2_1
XFILLER_0_42_95 VGND VGND VPWR VPWR sky130_fd_sc_hd__fill_2
X_5624_ _2122_ _2123_ _2184_ VGND VGND VPWR VPWR _2185_ sky130_fd_sc_hd__and3_1
XFILLER_0_13_132 VPWR VGND VPWR VGND sky130_ef_sc_hd__decap_12
X_5555_ _2115_ _2116_ VGND VGND VPWR VPWR _2117_ sky130_fd_sc_hd__nand2_1
X_4506_ _0947_ _0948_ _1079_ VGND VGND VPWR VPWR _1081_ sky130_fd_sc_hd__a21o_1
X_5486_ _1965_ _1968_ _1966_ VGND VGND VPWR VPWR _2048_ sky130_fd_sc_hd__o21ba_1
X_4437_ _0947_ _0948_ _1011_ VGND VGND VPWR VPWR _1013_ sky130_fd_sc_hd__a21o_1
X_6107_ clknet_leaf_9_clk _0020_ VGND VGND VPWR VPWR u_interface.u_compute_core.relu_data\[20\]
+ sky130_fd_sc_hd__dfxtp_1
X_4368_ u_interface.u_compute_core.relu_data\[6\] u_interface.u_compute_core.relu_data\[5\]
+ VGND VGND VPWR VPWR _0945_ sky130_fd_sc_hd__or2_1
X_4299_ _2604_ _2601_ _0595_ _0702_ VGND VGND VPWR VPWR _0877_ sky130_fd_sc_hd__nand4_1
X_3319_ _2781_ _2786_ _2787_ _2746_ net181 VGND VGND VPWR VPWR _0066_ sky130_fd_sc_hd__a32o_1
X_6038_ net34 u_interface.core_attn_out\[15\] _2544_ VGND VGND VPWR VPWR _2547_ sky130_fd_sc_hd__mux2_1
Xrebuffer62 net126 VGND VGND VPWR VPWR net127 sky130_fd_sc_hd__dlymetal6s2s_1
Xrebuffer40 _1706_ VGND VGND VPWR VPWR net105 sky130_fd_sc_hd__clkbuf_1
Xrebuffer51 net117 VGND VGND VPWR VPWR net116 sky130_fd_sc_hd__dlygate4sd1_1
XFILLER_0_83_308 VGND VGND VPWR VPWR sky130_fd_sc_hd__decap_6
XTAP_TAPCELL_ROW_80_962 VGND VPWR sky130_fd_sc_hd__tapvpwrvgnd_1
XFILLER_0_64_533 VPWR VGND VPWR VGND sky130_ef_sc_hd__decap_12
XFILLER_0_8_181 VGND VGND VPWR VPWR sky130_fd_sc_hd__decap_8
XFILLER_0_24_419 VGND VGND VPWR VPWR sky130_fd_sc_hd__fill_1
XTAP_TAPCELL_ROW_52_697 VGND VPWR sky130_fd_sc_hd__tapvpwrvgnd_1
XFILLER_0_63_39 VGND VGND VPWR VPWR sky130_fd_sc_hd__decap_8
XTAP_TAPCELL_ROW_15_344 VGND VPWR sky130_fd_sc_hd__tapvpwrvgnd_1
XFILLER_0_67_393 VPWR VGND VPWR VGND sky130_ef_sc_hd__decap_12
XFILLER_0_82_363 VGND VGND VPWR VPWR sky130_fd_sc_hd__fill_1
X_3670_ _2928_ _0265_ _0226_ _0266_ VGND VGND VPWR VPWR _0267_ sky130_fd_sc_hd__a31o_1
XFILLER_0_23_441 VGND VGND VPWR VPWR sky130_fd_sc_hd__decap_6
X_5340_ _1821_ _1902_ _1903_ VGND VGND VPWR VPWR _1904_ sky130_fd_sc_hd__and3_1
XFILLER_0_2_357 VGND VGND VPWR VPWR sky130_fd_sc_hd__decap_6
X_5271_ _1833_ _1834_ _1593_ VGND VGND VPWR VPWR _1836_ sky130_fd_sc_hd__a21o_1
XFILLER_0_10_135 VGND VGND VPWR VPWR sky130_fd_sc_hd__decap_4
XFILLER_0_10_157 VGND VGND VPWR VPWR sky130_fd_sc_hd__decap_8
X_4222_ _0800_ _0797_ VGND VGND VPWR VPWR _0801_ sky130_fd_sc_hd__xnor2_1
X_4153_ _0691_ _0733_ VGND VGND VPWR VPWR _0734_ sky130_fd_sc_hd__xnor2_1
X_3104_ u_interface.u_compute_core.scaled_data\[12\] _2618_ _2626_ _2613_ VGND VGND
+ VPWR VPWR _2627_ sky130_fd_sc_hd__o2bb2a_1
XFILLER_0_37_73 VGND VGND VPWR VPWR sky130_fd_sc_hd__decap_8
X_4084_ _2598_ _0586_ VGND VGND VPWR VPWR _0666_ sky130_fd_sc_hd__nand2_1
X_4986_ _1553_ _1551_ _1552_ VGND VGND VPWR VPWR _1555_ sky130_fd_sc_hd__and3_1
XFILLER_0_46_533 VPWR VGND VPWR VGND sky130_ef_sc_hd__decap_12
X_3937_ _2598_ _0492_ VGND VGND VPWR VPWR _0523_ sky130_fd_sc_hd__nand2_2
XFILLER_0_58_371 VGND VGND VPWR VPWR sky130_fd_sc_hd__fill_1
XFILLER_0_73_363 VGND VGND VPWR VPWR sky130_fd_sc_hd__decap_4
XFILLER_0_73_352 VGND VGND VPWR VPWR sky130_fd_sc_hd__decap_8
XFILLER_0_73_341 VGND VGND VPWR VPWR sky130_fd_sc_hd__fill_1
XPHY_EDGE_ROW_12_Left_105 VGND VGND VPWR VPWR sky130_fd_sc_hd__decap_3
X_3868_ _3013_ _3014_ _0265_ _0458_ VGND VGND VPWR VPWR _0459_ sky130_fd_sc_hd__a31o_1
XFILLER_0_61_525 VPWR VGND VPWR VGND sky130_ef_sc_hd__decap_12
XFILLER_0_5_151 VGND VGND VPWR VPWR sky130_fd_sc_hd__fill_2
X_3799_ _0356_ _0359_ _0392_ VGND VGND VPWR VPWR _0393_ sky130_fd_sc_hd__nand3_1
X_5607_ _2087_ _2167_ _1639_ VGND VGND VPWR VPWR _2168_ sky130_fd_sc_hd__a21o_1
XFILLER_0_5_195 VGND VGND VPWR VPWR sky130_fd_sc_hd__fill_2
X_5538_ _1935_ _2099_ VGND VGND VPWR VPWR _2100_ sky130_fd_sc_hd__xnor2_1
X_5469_ u_interface.u_compute_core.relu_valid net212 VGND VGND VPWR VPWR _2032_ sky130_fd_sc_hd__or2_1
XPHY_EDGE_ROW_21_Left_114 VGND VGND VPWR VPWR sky130_fd_sc_hd__decap_3
XTAP_TAPCELL_ROW_57_745 VGND VPWR sky130_fd_sc_hd__tapvpwrvgnd_1
XFILLER_0_83_127 VGND VGND VPWR VPWR sky130_fd_sc_hd__fill_1
XPHY_EDGE_ROW_30_Left_123 VGND VGND VPWR VPWR sky130_fd_sc_hd__decap_3
XFILLER_0_37_533 VPWR VGND VPWR VGND sky130_ef_sc_hd__decap_12
XFILLER_0_49_393 VPWR VGND VPWR VGND sky130_ef_sc_hd__decap_12
XTAP_TAPCELL_ROW_12_314 VGND VPWR sky130_fd_sc_hd__tapvpwrvgnd_1
Xinput18 s_tdata[23] VGND VGND VPWR VPWR net18 sky130_fd_sc_hd__clkbuf_2
XFILLER_0_52_525 VGND VGND VPWR VPWR sky130_fd_sc_hd__decap_6
XFILLER_0_91_193 VGND VGND VPWR VPWR sky130_fd_sc_hd__decap_8
XTAP_TAPCELL_ROW_20_391 VGND VPWR sky130_fd_sc_hd__tapvpwrvgnd_1
XFILLER_0_20_444 VGND VGND VPWR VPWR sky130_fd_sc_hd__decap_6
XFILLER_0_20_477 VGND VGND VPWR VPWR sky130_fd_sc_hd__decap_8
XFILLER_0_59_113 VGND VGND VPWR VPWR sky130_fd_sc_hd__fill_1
XFILLER_0_90_15 VPWR VGND VPWR VGND sky130_ef_sc_hd__decap_12
X_4840_ _1350_ _1352_ VGND VGND VPWR VPWR _1410_ sky130_fd_sc_hd__nand2_1
XFILLER_0_7_405 VPWR VGND VPWR VGND sky130_ef_sc_hd__decap_12
XFILLER_0_28_533 VPWR VGND VPWR VGND sky130_ef_sc_hd__decap_12
X_4771_ _1271_ _1273_ VGND VGND VPWR VPWR _1342_ sky130_fd_sc_hd__nand2_1
XFILLER_0_74_149 VGND VGND VPWR VPWR sky130_fd_sc_hd__fill_1
XFILLER_0_7_449 VPWR VGND VPWR VGND sky130_ef_sc_hd__decap_12
XFILLER_0_15_216 VGND VGND VPWR VPWR sky130_fd_sc_hd__fill_1
X_3722_ _0270_ _0268_ VGND VGND VPWR VPWR _0318_ sky130_fd_sc_hd__and2b_1
XFILLER_0_43_503 VGND VGND VPWR VPWR sky130_fd_sc_hd__fill_1
XFILLER_0_43_536 VGND VGND VPWR VPWR sky130_fd_sc_hd__decap_8
XFILLER_0_55_385 VGND VGND VPWR VPWR sky130_fd_sc_hd__decap_6
XFILLER_0_15_249 VGND VGND VPWR VPWR sky130_fd_sc_hd__decap_8
X_3653_ net11 net9 VGND VGND VPWR VPWR _0250_ sky130_fd_sc_hd__and2b_1
XFILLER_0_70_377 VGND VGND VPWR VPWR sky130_fd_sc_hd__decap_6
X_5323_ _1885_ _1886_ VGND VGND VPWR VPWR _1887_ sky130_fd_sc_hd__nor2_1
X_3584_ _3020_ _3021_ VGND VGND VPWR VPWR _3022_ sky130_fd_sc_hd__xor2_1
XFILLER_0_23_293 VGND VGND VPWR VPWR sky130_fd_sc_hd__fill_2
X_5254_ _1801_ _1817_ _1818_ VGND VGND VPWR VPWR _1819_ sky130_fd_sc_hd__nand3_1
X_5185_ _1599_ _1600_ _1749_ VGND VGND VPWR VPWR _1751_ sky130_fd_sc_hd__a21oi_1
X_4205_ _0783_ _0782_ _0736_ VGND VGND VPWR VPWR _0785_ sky130_fd_sc_hd__o21ai_2
XFILLER_0_48_83 VGND VGND VPWR VPWR sky130_fd_sc_hd__fill_1
X_4136_ _0714_ _0715_ _0713_ VGND VGND VPWR VPWR _0717_ sky130_fd_sc_hd__a21bo_1
XFILLER_0_3_96 VGND VGND VPWR VPWR sky130_fd_sc_hd__fill_2
X_4067_ _0630_ _0629_ VGND VGND VPWR VPWR _0649_ sky130_fd_sc_hd__and2b_1
XFILLER_0_78_433 VGND VGND VPWR VPWR sky130_fd_sc_hd__decap_6
XTAP_TAPCELL_ROW_54_715 VGND VPWR sky130_fd_sc_hd__tapvpwrvgnd_1
XFILLER_0_78_477 VGND VGND VPWR VPWR sky130_fd_sc_hd__fill_2
XFILLER_0_19_522 VPWR VGND VPWR VGND sky130_ef_sc_hd__decap_12
X_4969_ _1535_ _1536_ _1518_ VGND VGND VPWR VPWR _1538_ sky130_fd_sc_hd__a21oi_1
XFILLER_0_65_149 VPWR VGND VPWR VGND sky130_ef_sc_hd__decap_12
XTAP_TAPCELL_ROW_62_792 VGND VPWR sky130_fd_sc_hd__tapvpwrvgnd_1
XFILLER_0_46_363 VGND VGND VPWR VPWR sky130_fd_sc_hd__fill_1
XFILLER_0_61_322 VGND VGND VPWR VPWR sky130_fd_sc_hd__fill_2
XFILLER_0_60_18 VGND VGND VPWR VPWR sky130_fd_sc_hd__decap_8
XFILLER_0_84_458 VGND VGND VPWR VPWR sky130_fd_sc_hd__decap_6
XFILLER_0_37_341 VGND VGND VPWR VPWR sky130_fd_sc_hd__decap_8
XFILLER_0_56_149 VGND VGND VPWR VPWR sky130_fd_sc_hd__fill_1
XFILLER_0_60_29 VGND VGND VPWR VPWR sky130_fd_sc_hd__decap_8
XFILLER_0_64_160 VPWR VGND VPWR VGND sky130_ef_sc_hd__decap_12
XFILLER_0_25_503 VGND VGND VPWR VPWR sky130_fd_sc_hd__fill_1
XFILLER_0_25_525 VPWR VGND VPWR VGND sky130_ef_sc_hd__decap_12
XFILLER_0_37_385 VGND VGND VPWR VPWR sky130_fd_sc_hd__decap_6
XFILLER_0_64_193 VGND VGND VPWR VPWR sky130_fd_sc_hd__decap_3
XFILLER_0_4_419 VGND VGND VPWR VPWR sky130_fd_sc_hd__fill_1
XFILLER_0_69_27 VGND VGND VPWR VPWR sky130_fd_sc_hd__decap_4
XFILLER_0_12_208 VGND VGND VPWR VPWR sky130_fd_sc_hd__fill_1
XFILLER_0_52_377 VPWR VGND VPWR VGND sky130_ef_sc_hd__decap_12
XFILLER_0_85_15 VPWR VGND VPWR VGND sky130_ef_sc_hd__decap_12
XFILLER_0_18_97 VGND VGND VPWR VPWR sky130_fd_sc_hd__decap_4
X_5941_ _2320_ _2472_ _2473_ _2327_ VGND VGND VPWR VPWR _0163_ sky130_fd_sc_hd__o211a_1
XFILLER_0_87_241 VGND VGND VPWR VPWR sky130_fd_sc_hd__decap_4
XFILLER_0_34_41 VGND VGND VPWR VPWR sky130_fd_sc_hd__decap_8
X_5872_ u_interface.core_attn_out\[16\] _2308_ VGND VGND VPWR VPWR _2414_ sky130_fd_sc_hd__or2_1
XFILLER_0_34_85 VGND VGND VPWR VPWR sky130_fd_sc_hd__decap_4
X_4823_ _1319_ net122 _1392_ _1393_ VGND VGND VPWR VPWR _1394_ sky130_fd_sc_hd__o211a_4
XFILLER_0_28_341 VGND VGND VPWR VPWR sky130_fd_sc_hd__fill_2
X_4754_ _1323_ _1324_ _1261_ _1248_ VGND VGND VPWR VPWR _1326_ sky130_fd_sc_hd__o211a_1
XFILLER_0_16_525 VGND VGND VPWR VPWR sky130_fd_sc_hd__decap_6
XFILLER_0_28_363 VGND VGND VPWR VPWR sky130_fd_sc_hd__fill_1
XFILLER_0_28_374 VPWR VGND VPWR VGND sky130_ef_sc_hd__decap_12
XFILLER_0_43_311 VGND VGND VPWR VPWR sky130_fd_sc_hd__fill_2
XFILLER_0_7_279 VGND VGND VPWR VPWR sky130_fd_sc_hd__fill_1
X_3705_ _2970_ _2992_ _0300_ _2945_ VGND VGND VPWR VPWR _0301_ sky130_fd_sc_hd__a22oi_1
XFILLER_0_70_141 VGND VGND VPWR VPWR sky130_fd_sc_hd__decap_4
XTAP_TAPCELL_ROW_31_497 VGND VPWR sky130_fd_sc_hd__tapvpwrvgnd_1
X_4685_ _1182_ _1185_ net75 VGND VGND VPWR VPWR _1258_ sky130_fd_sc_hd__o21ba_1
XFILLER_0_43_355 VGND VGND VPWR VPWR sky130_fd_sc_hd__decap_4
X_3636_ _0223_ _0233_ VGND VGND VPWR VPWR _0234_ sky130_fd_sc_hd__or2_1
XFILLER_0_3_441 VGND VGND VPWR VPWR sky130_fd_sc_hd__decap_6
X_3567_ _3003_ _3004_ _3005_ VGND VGND VPWR VPWR _3006_ sky130_fd_sc_hd__nor3_1
XFILLER_0_3_485 VPWR VGND VPWR VGND sky130_ef_sc_hd__decap_12
X_6286_ clknet_leaf_14_clk _0199_ VGND VGND VPWR VPWR net47 sky130_fd_sc_hd__dfxtp_1
X_5306_ u_interface.u_compute_core.relu_data\[26\] _0494_ _0547_ _2663_ VGND VGND
+ VPWR VPWR _1870_ sky130_fd_sc_hd__o2bb2a_1
X_5237_ _2650_ _0558_ _0596_ _2647_ VGND VGND VPWR VPWR _1802_ sky130_fd_sc_hd__a22oi_1
X_3498_ _2937_ _2938_ _2933_ VGND VGND VPWR VPWR _2940_ sky130_fd_sc_hd__a21bo_1
X_5168_ _2644_ _0596_ VGND VGND VPWR VPWR _1734_ sky130_fd_sc_hd__nand2_1
X_5099_ _1643_ _1665_ VGND VGND VPWR VPWR _1666_ sky130_fd_sc_hd__xor2_1
XTAP_TAPCELL_ROW_67_840 VGND VPWR sky130_fd_sc_hd__tapvpwrvgnd_1
X_4119_ _0620_ _0621_ _0674_ net65 VGND VGND VPWR VPWR _0700_ sky130_fd_sc_hd__and4b_1
XFILLER_0_66_403 VGND VGND VPWR VPWR sky130_fd_sc_hd__fill_1
XFILLER_0_19_374 VGND VGND VPWR VPWR sky130_fd_sc_hd__fill_2
XFILLER_0_19_396 VPWR VGND VPWR VGND sky130_ef_sc_hd__decap_12
XFILLER_0_34_355 VGND VGND VPWR VPWR sky130_fd_sc_hd__decap_8
XFILLER_0_34_377 VGND VGND VPWR VPWR sky130_fd_sc_hd__fill_2
XFILLER_0_61_152 VGND VGND VPWR VPWR sky130_fd_sc_hd__decap_3
XFILLER_0_89_517 VPWR VGND VPWR VGND sky130_ef_sc_hd__decap_12
XFILLER_0_71_39 VGND VGND VPWR VPWR sky130_fd_sc_hd__decap_4
XFILLER_0_69_285 VGND VGND VPWR VPWR sky130_fd_sc_hd__decap_4
XFILLER_0_57_425 VGND VGND VPWR VPWR sky130_fd_sc_hd__fill_1
XFILLER_0_44_119 VGND VGND VPWR VPWR sky130_fd_sc_hd__decap_4
XFILLER_0_25_333 VGND VGND VPWR VPWR sky130_fd_sc_hd__decap_3
XFILLER_0_80_450 VGND VGND VPWR VPWR sky130_fd_sc_hd__fill_1
XFILLER_0_4_227 VPWR VGND VPWR VGND sky130_ef_sc_hd__decap_12
X_4470_ _1025_ _1026_ _1006_ VGND VGND VPWR VPWR _1045_ sky130_fd_sc_hd__or3b_4
X_3421_ _2865_ _2868_ _2874_ VGND VGND VPWR VPWR _2875_ sky130_fd_sc_hd__a21o_1
XFILLER_0_0_433 VGND VGND VPWR VPWR sky130_fd_sc_hd__decap_4
X_6140_ clknet_leaf_18_clk _0053_ VGND VGND VPWR VPWR u_interface.u_compute_core.scaled_data\[24\]
+ sky130_fd_sc_hd__dfxtp_1
X_3352_ _2811_ _2814_ _2815_ VGND VGND VPWR VPWR _2816_ sky130_fd_sc_hd__or3_1
XFILLER_0_0_477 VPWR VGND VPWR VGND sky130_ef_sc_hd__decap_12
X_6071_ _2670_ _2568_ VGND VGND VPWR VPWR _2569_ sky130_fd_sc_hd__and2_1
X_3283_ _2752_ _2755_ net144 _2756_ VGND VGND VPWR VPWR _0061_ sky130_fd_sc_hd__a2bb2o_1
X_5022_ _1588_ _1589_ VGND VGND VPWR VPWR _1590_ sky130_fd_sc_hd__and2b_1
XTAP_TAPCELL_ROW_88_1031 VGND VPWR sky130_fd_sc_hd__tapvpwrvgnd_1
XFILLER_0_45_40 VGND VGND VPWR VPWR sky130_fd_sc_hd__fill_1
XTAP_TAPCELL_ROW_64_810 VGND VPWR sky130_fd_sc_hd__tapvpwrvgnd_1
X_5924_ _2447_ _2452_ _2457_ _2318_ VGND VGND VPWR VPWR _2459_ sky130_fd_sc_hd__a31o_1
XTAP_TAPCELL_ROW_36_545 VGND VPWR sky130_fd_sc_hd__tapvpwrvgnd_1
X_5855_ u_interface.core_attn_out\[14\] _2308_ VGND VGND VPWR VPWR _2399_ sky130_fd_sc_hd__or2_1
XFILLER_0_48_469 VGND VGND VPWR VPWR sky130_fd_sc_hd__decap_6
X_4806_ _2634_ _0534_ _0625_ _2631_ VGND VGND VPWR VPWR _1377_ sky130_fd_sc_hd__a22o_1
XFILLER_0_63_417 VPWR VGND VPWR VGND sky130_ef_sc_hd__decap_12
XFILLER_0_8_533 VPWR VGND VPWR VGND sky130_ef_sc_hd__decap_12
XFILLER_0_0_97 VGND VGND VPWR VPWR sky130_fd_sc_hd__decap_4
XFILLER_0_35_108 VGND VGND VPWR VPWR sky130_fd_sc_hd__fill_1
XFILLER_0_61_72 VGND VGND VPWR VPWR sky130_fd_sc_hd__decap_6
X_5786_ _2335_ _2338_ VGND VGND VPWR VPWR _2339_ sky130_fd_sc_hd__nand2_1
X_4737_ _1307_ _1308_ VGND VGND VPWR VPWR _1309_ sky130_fd_sc_hd__nor2_1
X_4668_ _1240_ _1239_ VGND VGND VPWR VPWR _1241_ sky130_fd_sc_hd__nor2_4
XFILLER_0_9_84 VPWR VGND VPWR VGND sky130_ef_sc_hd__decap_12
XFILLER_0_16_388 VGND VGND VPWR VPWR sky130_fd_sc_hd__fill_1
XFILLER_0_31_325 VGND VGND VPWR VPWR sky130_fd_sc_hd__decap_3
X_3619_ net9 VGND VGND VPWR VPWR _0217_ sky130_fd_sc_hd__inv_2
X_4599_ _1170_ _1171_ _1097_ VGND VGND VPWR VPWR _1173_ sky130_fd_sc_hd__o21ba_4
XFILLER_0_3_293 VPWR VGND VPWR VGND sky130_ef_sc_hd__decap_12
XFILLER_0_86_80 VGND VGND VPWR VPWR sky130_fd_sc_hd__decap_4
X_6269_ clknet_leaf_16_clk _0182_ VGND VGND VPWR VPWR net29 sky130_fd_sc_hd__dfxtp_1
XTAP_TAPCELL_ROW_70_868 VGND VPWR sky130_fd_sc_hd__tapvpwrvgnd_1
XFILLER_0_81_225 VGND VGND VPWR VPWR sky130_fd_sc_hd__decap_4
XFILLER_0_34_141 VGND VGND VPWR VPWR sky130_fd_sc_hd__fill_1
XTAP_TAPCELL_ROW_7_270 VGND VPWR sky130_fd_sc_hd__tapvpwrvgnd_1
XPHY_EDGE_ROW_13_Right_13 VGND VGND VPWR VPWR sky130_fd_sc_hd__decap_3
XFILLER_0_82_27 VGND VGND VPWR VPWR sky130_fd_sc_hd__fill_1
XFILLER_0_15_65 VGND VGND VPWR VPWR sky130_fd_sc_hd__decap_8
XFILLER_0_15_43 VPWR VGND VPWR VGND sky130_ef_sc_hd__decap_12
X_3970_ _0553_ _0554_ VGND VGND VPWR VPWR _0555_ sky130_fd_sc_hd__xnor2_1
XTAP_TAPCELL_ROW_33_515 VGND VPWR sky130_fd_sc_hd__tapvpwrvgnd_1
XFILLER_0_5_503 VGND VGND VPWR VPWR sky130_fd_sc_hd__fill_1
X_5640_ _2660_ _1644_ _0597_ VGND VGND VPWR VPWR _2200_ sky130_fd_sc_hd__and3_1
XPHY_EDGE_ROW_22_Right_22 VGND VGND VPWR VPWR sky130_fd_sc_hd__decap_3
XTAP_TAPCELL_ROW_41_592 VGND VPWR sky130_fd_sc_hd__tapvpwrvgnd_1
X_5571_ _2660_ _1644_ _0559_ _0597_ VGND VGND VPWR VPWR _2132_ sky130_fd_sc_hd__and4_1
XFILLER_0_53_461 VGND VGND VPWR VPWR sky130_fd_sc_hd__fill_2
X_4522_ _1096_ _1095_ _1073_ VGND VGND VPWR VPWR _1097_ sky130_fd_sc_hd__and3_1
XFILLER_0_40_111 VGND VGND VPWR VPWR sky130_fd_sc_hd__decap_3
XFILLER_0_79_7 VPWR VGND VPWR VGND sky130_ef_sc_hd__decap_12
X_4453_ _0964_ _1028_ VGND VGND VPWR VPWR _1029_ sky130_fd_sc_hd__xnor2_2
X_3404_ u_interface.u_compute_core.u_mac.product_reg\[15\] u_interface.u_compute_core.mac_accum\[20\]
+ VGND VGND VPWR VPWR _2860_ sky130_fd_sc_hd__and2_1
XFILLER_0_21_380 VGND VGND VPWR VPWR sky130_fd_sc_hd__decap_3
X_4384_ _0958_ _0959_ _0813_ VGND VGND VPWR VPWR _0961_ sky130_fd_sc_hd__a21oi_1
X_3335_ _2799_ _2800_ VGND VGND VPWR VPWR _2801_ sky130_fd_sc_hd__nand2_1
X_6123_ clknet_leaf_4_clk _0036_ VGND VGND VPWR VPWR u_interface.u_compute_core.scaled_data\[7\]
+ sky130_fd_sc_hd__dfxtp_1
X_6054_ _2512_ net139 _2557_ VGND VGND VPWR VPWR _0192_ sky130_fd_sc_hd__o21a_1
XPHY_EDGE_ROW_31_Right_31 VGND VGND VPWR VPWR sky130_fd_sc_hd__decap_3
X_3266_ _2740_ VGND VGND VPWR VPWR _2741_ sky130_fd_sc_hd__clkbuf_4
X_5005_ _2644_ _0490_ VGND VGND VPWR VPWR _1573_ sky130_fd_sc_hd__nand2_1
XFILLER_0_22_3 VPWR VGND VPWR VGND sky130_ef_sc_hd__decap_12
X_3197_ _2693_ VGND VGND VPWR VPWR _0038_ sky130_fd_sc_hd__clkbuf_1
XFILLER_0_76_531 VGND VGND VPWR VPWR sky130_fd_sc_hd__fill_1
XFILLER_0_72_93 VGND VGND VPWR VPWR sky130_fd_sc_hd__decap_4
X_5907_ _2436_ _2438_ _2443_ VGND VGND VPWR VPWR _2444_ sky130_fd_sc_hd__a21oi_1
XFILLER_0_63_225 VPWR VGND VPWR VGND sky130_ef_sc_hd__decap_12
X_5838_ _2374_ _2383_ VGND VGND VPWR VPWR _2384_ sky130_fd_sc_hd__or2_1
XPHY_EDGE_ROW_40_Right_40 VGND VGND VPWR VPWR sky130_fd_sc_hd__decap_3
XFILLER_0_48_299 VGND VGND VPWR VPWR sky130_fd_sc_hd__decap_8
X_5769_ _2312_ _2314_ _2311_ VGND VGND VPWR VPWR _2324_ sky130_fd_sc_hd__a21bo_1
XFILLER_0_31_100 VPWR VGND VPWR VGND sky130_ef_sc_hd__decap_12
XPHY_EDGE_ROW_86_Left_179 VGND VGND VPWR VPWR sky130_fd_sc_hd__decap_3
XFILLER_0_31_166 VGND VGND VPWR VPWR sky130_fd_sc_hd__fill_2
XTAP_TAPCELL_ROW_4_240 VGND VPWR sky130_fd_sc_hd__tapvpwrvgnd_1
XTAP_TAPCELL_ROW_75_916 VGND VPWR sky130_fd_sc_hd__tapvpwrvgnd_1
XFILLER_0_82_501 VPWR VGND VPWR VGND sky130_ef_sc_hd__decap_12
XFILLER_0_82_545 VGND VGND VPWR VPWR sky130_fd_sc_hd__fill_2
XFILLER_0_54_225 VGND VGND VPWR VPWR sky130_fd_sc_hd__fill_1
XFILLER_0_54_269 VGND VGND VPWR VPWR sky130_fd_sc_hd__decap_4
XTAP_TAPCELL_ROW_10_297 VGND VPWR sky130_fd_sc_hd__tapvpwrvgnd_1
XFILLER_0_10_317 VGND VGND VPWR VPWR sky130_fd_sc_hd__fill_1
XFILLER_0_50_453 VGND VGND VPWR VPWR sky130_fd_sc_hd__decap_6
X_3120_ u_interface.u_compute_core.scaled_data\[16\] _2618_ _2638_ _2613_ VGND VGND
+ VPWR VPWR _2639_ sky130_fd_sc_hd__o2bb2a_1
XFILLER_0_89_111 VGND VGND VPWR VPWR sky130_fd_sc_hd__fill_1
X_3051_ u_interface.u_compute_core.scaled_valid VGND VGND VPWR VPWR _2586_ sky130_fd_sc_hd__clkbuf_2
XFILLER_0_89_133 VGND VGND VPWR VPWR sky130_fd_sc_hd__decap_3
XTAP_TAPCELL_ROW_46_640 VGND VPWR sky130_fd_sc_hd__tapvpwrvgnd_1
XTAP_TAPCELL_ROW_18_375 VGND VPWR sky130_fd_sc_hd__tapvpwrvgnd_1
XFILLER_0_58_531 VGND VGND VPWR VPWR sky130_fd_sc_hd__fill_1
XFILLER_0_92_309 VPWR VGND VPWR VGND sky130_ef_sc_hd__decap_12
X_3953_ _0523_ _0538_ VGND VGND VPWR VPWR _0539_ sky130_fd_sc_hd__xor2_1
X_3884_ _0452_ _0450_ _0473_ VGND VGND VPWR VPWR _0475_ sky130_fd_sc_hd__o21ai_1
XFILLER_0_42_85 VGND VGND VPWR VPWR sky130_fd_sc_hd__fill_2
XFILLER_0_45_225 VPWR VGND VPWR VGND sky130_ef_sc_hd__decap_12
XFILLER_0_33_409 VGND VGND VPWR VPWR sky130_fd_sc_hd__fill_2
X_5623_ _2182_ _2183_ VGND VGND VPWR VPWR _2184_ sky130_fd_sc_hd__nand2_1
XFILLER_0_13_111 VGND VGND VPWR VPWR sky130_fd_sc_hd__fill_1
XFILLER_0_41_420 VGND VGND VPWR VPWR sky130_fd_sc_hd__fill_2
X_5554_ _2112_ _2114_ VGND VGND VPWR VPWR _2116_ sky130_fd_sc_hd__nand2_1
XFILLER_0_53_291 VGND VGND VPWR VPWR sky130_fd_sc_hd__decap_4
X_4505_ _0947_ _0948_ _1079_ VGND VGND VPWR VPWR _1080_ sky130_fd_sc_hd__nand3_1
XFILLER_0_13_144 VGND VGND VPWR VPWR sky130_fd_sc_hd__fill_2
X_5485_ _2045_ _2046_ VGND VGND VPWR VPWR _2047_ sky130_fd_sc_hd__nor2_1
X_4436_ _0947_ _0948_ _1011_ VGND VGND VPWR VPWR _1012_ sky130_fd_sc_hd__nand3_1
X_4367_ u_interface.u_compute_core.relu_data\[6\] u_interface.u_compute_core.relu_data\[5\]
+ _0656_ VGND VGND VPWR VPWR _0944_ sky130_fd_sc_hd__nand3_2
X_6106_ clknet_leaf_9_clk _0019_ VGND VGND VPWR VPWR u_interface.u_compute_core.relu_data\[19\]
+ sky130_fd_sc_hd__dfxtp_2
XFILLER_0_6_85 VPWR VGND VPWR VGND sky130_ef_sc_hd__decap_12
X_3318_ _2782_ _2783_ _2784_ VGND VGND VPWR VPWR _2787_ sky130_fd_sc_hd__a21o_1
X_4298_ _2604_ _0595_ _0633_ net95 VGND VGND VPWR VPWR _0876_ sky130_fd_sc_hd__a22o_1
X_6037_ _2546_ VGND VGND VPWR VPWR _0186_ sky130_fd_sc_hd__clkbuf_1
X_3249_ u_interface.u_compute_core.scaled_data\[26\] u_interface.u_compute_core.mac_accum\[29\]
+ _2713_ VGND VGND VPWR VPWR _2729_ sky130_fd_sc_hd__mux2_1
XTAP_TAPCELL_ROW_1_210 VGND VPWR sky130_fd_sc_hd__tapvpwrvgnd_1
Xrebuffer41 _1472_ VGND VGND VPWR VPWR net106 sky130_fd_sc_hd__buf_6
Xrebuffer63 net127 VGND VGND VPWR VPWR net128 sky130_fd_sc_hd__buf_6
Xrebuffer52 _1699_ VGND VGND VPWR VPWR net117 sky130_fd_sc_hd__dlygate4sd1_1
XFILLER_0_64_501 VGND VGND VPWR VPWR sky130_fd_sc_hd__decap_8
XTAP_TAPCELL_ROW_80_963 VGND VPWR sky130_fd_sc_hd__tapvpwrvgnd_1
XFILLER_0_64_545 VGND VGND VPWR VPWR sky130_fd_sc_hd__fill_2
XFILLER_0_91_353 VGND VGND VPWR VPWR sky130_fd_sc_hd__fill_2
XFILLER_0_8_171 VGND VGND VPWR VPWR sky130_fd_sc_hd__decap_6
XFILLER_0_36_269 VPWR VGND VPWR VGND sky130_ef_sc_hd__decap_12
XTAP_TAPCELL_ROW_52_698 VGND VPWR sky130_fd_sc_hd__tapvpwrvgnd_1
XFILLER_0_17_461 VGND VGND VPWR VPWR sky130_fd_sc_hd__decap_8
XFILLER_0_17_494 VGND VGND VPWR VPWR sky130_fd_sc_hd__decap_8
XFILLER_0_51_239 VGND VGND VPWR VPWR sky130_fd_sc_hd__fill_1
XFILLER_0_32_486 VGND VGND VPWR VPWR sky130_fd_sc_hd__fill_1
XTAP_TAPCELL_ROW_43_610 VGND VPWR sky130_fd_sc_hd__tapvpwrvgnd_1
XFILLER_0_67_361 VGND VGND VPWR VPWR sky130_fd_sc_hd__decap_8
XTAP_TAPCELL_ROW_15_345 VGND VPWR sky130_fd_sc_hd__tapvpwrvgnd_1
XFILLER_0_27_225 VGND VGND VPWR VPWR sky130_fd_sc_hd__decap_4
XFILLER_0_27_236 VGND VGND VPWR VPWR sky130_fd_sc_hd__fill_2
XFILLER_0_55_512 VGND VGND VPWR VPWR sky130_fd_sc_hd__decap_8
XFILLER_0_42_228 VGND VGND VPWR VPWR sky130_fd_sc_hd__fill_1
XFILLER_0_88_15 VPWR VGND VPWR VGND sky130_ef_sc_hd__decap_12
XFILLER_0_42_239 VGND VGND VPWR VPWR sky130_fd_sc_hd__decap_6
X_5270_ _1593_ _1833_ _1834_ VGND VGND VPWR VPWR _1835_ sky130_fd_sc_hd__nand3_1
XFILLER_0_50_294 VGND VGND VPWR VPWR sky130_fd_sc_hd__fill_1
X_4221_ _0798_ _0799_ VGND VGND VPWR VPWR _0800_ sky130_fd_sc_hd__and2b_1
XTAP_TAPCELL_ROW_91_1060 VGND VPWR sky130_fd_sc_hd__tapvpwrvgnd_1
X_4152_ _0730_ _0732_ VGND VGND VPWR VPWR _0733_ sky130_fd_sc_hd__xor2_1
X_3103_ _2625_ VGND VGND VPWR VPWR _2626_ sky130_fd_sc_hd__inv_2
X_4083_ _0635_ _0664_ VGND VGND VPWR VPWR _0665_ sky130_fd_sc_hd__xnor2_1
XFILLER_0_77_103 VGND VGND VPWR VPWR sky130_fd_sc_hd__decap_8
XFILLER_0_77_125 VGND VGND VPWR VPWR sky130_fd_sc_hd__decap_4
XFILLER_0_53_51 VGND VGND VPWR VPWR sky130_fd_sc_hd__decap_4
X_4985_ _1551_ _1552_ _1553_ VGND VGND VPWR VPWR _1554_ sky130_fd_sc_hd__a21oi_1
XFILLER_0_53_73 VGND VGND VPWR VPWR sky130_fd_sc_hd__decap_3
X_3936_ _0485_ net214 _0486_ _0522_ VGND VGND VPWR VPWR _0109_ sky130_fd_sc_hd__o211a_1
XFILLER_0_58_383 VPWR VGND VPWR VGND sky130_ef_sc_hd__decap_12
XFILLER_0_46_545 VGND VGND VPWR VPWR sky130_fd_sc_hd__fill_2
XFILLER_0_73_375 VPWR VGND VPWR VGND sky130_ef_sc_hd__decap_12
X_3867_ _0300_ _0217_ _0427_ _0456_ _0457_ VGND VGND VPWR VPWR _0458_ sky130_fd_sc_hd__o311a_1
XFILLER_0_61_537 VGND VGND VPWR VPWR sky130_fd_sc_hd__decap_8
X_3798_ _0390_ _0391_ VGND VGND VPWR VPWR _0392_ sky130_fd_sc_hd__nand2_1
X_5606_ _2079_ _2089_ VGND VGND VPWR VPWR _2167_ sky130_fd_sc_hd__nand2_1
X_5537_ net130 _2098_ VGND VGND VPWR VPWR _2099_ sky130_fd_sc_hd__xor2_1
X_5468_ _2029_ _2030_ VGND VGND VPWR VPWR _2031_ sky130_fd_sc_hd__xnor2_1
X_4419_ u_interface.u_compute_core.relu_data\[12\] net19 _0488_ _0927_ VGND VGND VPWR
+ VPWR _0995_ sky130_fd_sc_hd__a22oi_2
XFILLER_0_1_391 VGND VGND VPWR VPWR sky130_fd_sc_hd__fill_1
X_5399_ _1959_ _1960_ u_interface.u_compute_core.relu_data\[25\] _0516_ VGND VGND
+ VPWR VPWR _1962_ sky130_fd_sc_hd__and4bb_1
XFILLER_0_68_158 VPWR VGND VPWR VGND sky130_ef_sc_hd__decap_12
XFILLER_0_49_361 VGND VGND VPWR VPWR sky130_fd_sc_hd__decap_6
XFILLER_0_56_309 VGND VGND VPWR VPWR sky130_fd_sc_hd__decap_8
XFILLER_0_64_342 VGND VGND VPWR VPWR sky130_fd_sc_hd__fill_2
XTAP_TAPCELL_ROW_12_315 VGND VPWR sky130_fd_sc_hd__tapvpwrvgnd_1
XFILLER_0_37_545 VGND VGND VPWR VPWR sky130_fd_sc_hd__fill_2
XFILLER_0_91_161 VGND VGND VPWR VPWR sky130_fd_sc_hd__decap_6
Xinput19 s_tdata[2] VGND VGND VPWR VPWR net19 sky130_fd_sc_hd__buf_2
XFILLER_0_52_504 VPWR VGND VPWR VGND sky130_ef_sc_hd__decap_12
XTAP_TAPCELL_ROW_20_392 VGND VPWR sky130_fd_sc_hd__tapvpwrvgnd_1
XFILLER_0_58_29 VGND VGND VPWR VPWR sky130_fd_sc_hd__decap_3
XFILLER_0_90_27 VGND VGND VPWR VPWR sky130_fd_sc_hd__fill_1
XTAP_TAPCELL_ROW_28_470 VGND VPWR sky130_fd_sc_hd__tapvpwrvgnd_1
XFILLER_0_74_139 VGND VGND VPWR VPWR sky130_fd_sc_hd__fill_1
XFILLER_0_23_43 VGND VGND VPWR VPWR sky130_fd_sc_hd__decap_3
X_4770_ _1205_ _1207_ _1321_ _1322_ VGND VGND VPWR VPWR _1341_ sky130_fd_sc_hd__a211o_1
XFILLER_0_7_417 VPWR VGND VPWR VGND sky130_ef_sc_hd__decap_12
XFILLER_0_23_76 VGND VGND VPWR VPWR sky130_fd_sc_hd__fill_1
XFILLER_0_28_545 VGND VGND VPWR VPWR sky130_fd_sc_hd__fill_2
XFILLER_0_15_206 VGND VGND VPWR VPWR sky130_fd_sc_hd__decap_3
X_3721_ _0315_ _0316_ VGND VGND VPWR VPWR _0317_ sky130_fd_sc_hd__nand2_1
X_3652_ net13 _3013_ VGND VGND VPWR VPWR _0249_ sky130_fd_sc_hd__nand2_1
X_3583_ _2935_ _2961_ VGND VGND VPWR VPWR _3021_ sky130_fd_sc_hd__nand2_1
X_5322_ _2650_ _2647_ _0596_ _0634_ VGND VGND VPWR VPWR _1886_ sky130_fd_sc_hd__and4_1
X_5253_ _1815_ _1816_ _1728_ VGND VGND VPWR VPWR _1818_ sky130_fd_sc_hd__a21o_1
X_5184_ _1598_ _1600_ _1749_ VGND VGND VPWR VPWR _1750_ sky130_fd_sc_hd__and3_1
X_4204_ _0736_ _0782_ _0783_ VGND VGND VPWR VPWR _0784_ sky130_fd_sc_hd__or3_1
X_4135_ _0713_ _0714_ _0715_ VGND VGND VPWR VPWR _0716_ sky130_fd_sc_hd__nand3b_1
X_4066_ _0634_ VGND VGND VPWR VPWR _0648_ sky130_fd_sc_hd__clkbuf_4
XFILLER_0_64_83 VGND VGND VPWR VPWR sky130_fd_sc_hd__fill_1
XTAP_TAPCELL_ROW_54_716 VGND VPWR sky130_fd_sc_hd__tapvpwrvgnd_1
X_4968_ _1518_ _1535_ _1536_ VGND VGND VPWR VPWR _1537_ sky130_fd_sc_hd__and3_1
XFILLER_0_19_534 VGND VGND VPWR VPWR sky130_fd_sc_hd__decap_8
XFILLER_0_58_191 VGND VGND VPWR VPWR sky130_fd_sc_hd__fill_2
XTAP_TAPCELL_ROW_62_793 VGND VPWR sky130_fd_sc_hd__tapvpwrvgnd_1
X_4899_ _1466_ _1467_ _1424_ VGND VGND VPWR VPWR _1469_ sky130_fd_sc_hd__a21oi_1
XFILLER_0_73_150 VGND VGND VPWR VPWR sky130_fd_sc_hd__decap_6
X_3919_ _2595_ _0493_ _0496_ _2592_ VGND VGND VPWR VPWR _0506_ sky130_fd_sc_hd__a22oi_1
XFILLER_0_14_250 VGND VGND VPWR VPWR sky130_fd_sc_hd__fill_2
XFILLER_0_69_423 VPWR VGND VPWR VGND sky130_ef_sc_hd__decap_12
XPHY_EDGE_ROW_69_Right_69 VGND VGND VPWR VPWR sky130_fd_sc_hd__decap_3
XTAP_TAPCELL_ROW_25_440 VGND VPWR sky130_fd_sc_hd__tapvpwrvgnd_1
XFILLER_0_56_139 VGND VGND VPWR VPWR sky130_fd_sc_hd__fill_1
XFILLER_0_71_109 VGND VGND VPWR VPWR sky130_fd_sc_hd__decap_3
XFILLER_0_64_172 VGND VGND VPWR VPWR sky130_fd_sc_hd__decap_6
XFILLER_0_25_537 VGND VGND VPWR VPWR sky130_fd_sc_hd__decap_6
XFILLER_0_52_389 VGND VGND VPWR VPWR sky130_fd_sc_hd__decap_8
XPHY_EDGE_ROW_78_Right_78 VGND VGND VPWR VPWR sky130_fd_sc_hd__decap_3
XFILLER_0_20_253 VGND VGND VPWR VPWR sky130_fd_sc_hd__decap_3
XFILLER_0_20_264 VGND VGND VPWR VPWR sky130_fd_sc_hd__fill_1
XFILLER_0_85_27 VPWR VGND VPWR VGND sky130_ef_sc_hd__decap_12
XFILLER_0_19_9 VGND VGND VPWR VPWR sky130_fd_sc_hd__fill_1
X_5940_ u_interface.core_attn_out\[25\] _2308_ VGND VGND VPWR VPWR _2473_ sky130_fd_sc_hd__or2_1
XPHY_EDGE_ROW_87_Right_87 VGND VGND VPWR VPWR sky130_fd_sc_hd__decap_3
XFILLER_0_75_404 VGND VGND VPWR VPWR sky130_fd_sc_hd__decap_8
X_5871_ _2411_ _2412_ VGND VGND VPWR VPWR _2413_ sky130_fd_sc_hd__and2_1
X_4822_ _1356_ _1357_ _1391_ VGND VGND VPWR VPWR _1393_ sky130_fd_sc_hd__a21o_1
XFILLER_0_83_470 VGND VGND VPWR VPWR sky130_fd_sc_hd__fill_2
X_4753_ _1261_ _1248_ _1323_ _1324_ VGND VGND VPWR VPWR _1325_ sky130_fd_sc_hd__a211oi_2
XFILLER_0_7_225 VPWR VGND VPWR VGND sky130_ef_sc_hd__decap_12
XFILLER_0_43_301 VGND VGND VPWR VPWR sky130_fd_sc_hd__decap_3
XFILLER_0_50_41 VPWR VGND VPWR VGND sky130_ef_sc_hd__decap_12
X_3704_ net17 VGND VGND VPWR VPWR _0300_ sky130_fd_sc_hd__clkbuf_2
XFILLER_0_28_386 VGND VGND VPWR VPWR sky130_fd_sc_hd__decap_8
XFILLER_0_43_323 VGND VGND VPWR VPWR sky130_fd_sc_hd__decap_6
XFILLER_0_50_85 VPWR VGND VPWR VGND sky130_ef_sc_hd__decap_12
XTAP_TAPCELL_ROW_31_498 VGND VPWR sky130_fd_sc_hd__tapvpwrvgnd_1
X_4684_ _1255_ net125 VGND VGND VPWR VPWR _1257_ sky130_fd_sc_hd__nor2_1
XFILLER_0_70_197 VPWR VGND VPWR VGND sky130_ef_sc_hd__decap_12
XFILLER_0_70_186 VGND VGND VPWR VPWR sky130_fd_sc_hd__decap_8
XFILLER_0_70_175 VGND VGND VPWR VPWR sky130_fd_sc_hd__decap_3
X_3635_ _3027_ _0232_ VGND VGND VPWR VPWR _0233_ sky130_fd_sc_hd__xnor2_1
XFILLER_0_43_389 VGND VGND VPWR VPWR sky130_fd_sc_hd__decap_3
X_3566_ _2948_ _2964_ _2967_ VGND VGND VPWR VPWR _3005_ sky130_fd_sc_hd__o21a_1
XFILLER_0_3_497 VGND VGND VPWR VPWR sky130_fd_sc_hd__decap_6
X_5305_ _1790_ _1797_ VGND VGND VPWR VPWR _1869_ sky130_fd_sc_hd__or2b_1
X_3497_ _2933_ _2937_ _2938_ VGND VGND VPWR VPWR _2939_ sky130_fd_sc_hd__nand3b_1
X_6285_ clknet_leaf_14_clk _0198_ VGND VGND VPWR VPWR net46 sky130_fd_sc_hd__dfxtp_1
X_5236_ _1799_ _1741_ _1800_ VGND VGND VPWR VPWR _1801_ sky130_fd_sc_hd__a21o_1
XFILLER_0_52_3 VPWR VGND VPWR VGND sky130_ef_sc_hd__decap_12
XFILLER_0_75_82 VPWR VGND VPWR VGND sky130_ef_sc_hd__decap_12
X_5167_ _2653_ _1731_ _1428_ _1732_ VGND VGND VPWR VPWR _1733_ sky130_fd_sc_hd__o31a_1
X_5098_ _1647_ _1664_ VGND VGND VPWR VPWR _1665_ sky130_fd_sc_hd__xor2_1
X_4118_ _0695_ _0698_ VGND VGND VPWR VPWR _0699_ sky130_fd_sc_hd__xnor2_2
XFILLER_0_78_220 VGND VGND VPWR VPWR sky130_fd_sc_hd__fill_1
X_4049_ s_tdata[7] VGND VGND VPWR VPWR _0632_ sky130_fd_sc_hd__buf_4
XFILLER_0_78_253 VGND VGND VPWR VPWR sky130_fd_sc_hd__decap_8
XFILLER_0_91_81 VPWR VGND VPWR VGND sky130_ef_sc_hd__decap_12
XFILLER_0_66_437 VGND VGND VPWR VPWR sky130_fd_sc_hd__decap_6
XFILLER_0_38_139 VGND VGND VPWR VPWR sky130_fd_sc_hd__fill_1
XTAP_TAPCELL_ROW_22_410 VGND VPWR sky130_fd_sc_hd__tapvpwrvgnd_1
XFILLER_0_53_109 VGND VGND VPWR VPWR sky130_fd_sc_hd__decap_3
XFILLER_0_46_183 VGND VGND VPWR VPWR sky130_fd_sc_hd__fill_2
XFILLER_0_61_131 VGND VGND VPWR VPWR sky130_fd_sc_hd__decap_8
XFILLER_0_89_529 VPWR VGND VPWR VGND sky130_ef_sc_hd__decap_12
XFILLER_0_69_220 VGND VGND VPWR VPWR sky130_fd_sc_hd__decap_4
XFILLER_0_29_139 VPWR VGND VPWR VGND sky130_ef_sc_hd__decap_12
XFILLER_0_72_429 VGND VGND VPWR VPWR sky130_fd_sc_hd__decap_3
XFILLER_0_4_239 VPWR VGND VPWR VGND sky130_ef_sc_hd__decap_12
XFILLER_0_80_495 VGND VGND VPWR VPWR sky130_fd_sc_hd__fill_2
XFILLER_0_0_401 VGND VGND VPWR VPWR sky130_fd_sc_hd__fill_1
X_3420_ u_interface.u_compute_core.mac_accum\[21\] u_interface.u_compute_core.mac_accum\[20\]
+ _2832_ VGND VGND VPWR VPWR _2874_ sky130_fd_sc_hd__o21a_1
XFILLER_0_52_197 VPWR VGND VPWR VGND sky130_ef_sc_hd__decap_12
X_3351_ _2796_ _2801_ _2802_ _2807_ _2799_ VGND VGND VPWR VPWR _2815_ sky130_fd_sc_hd__o311a_1
XFILLER_0_0_489 VPWR VGND VPWR VGND sky130_ef_sc_hd__decap_12
X_6070_ net46 u_interface.core_attn_out\[26\] u_interface.core_valid_out VGND VGND
+ VPWR VPWR _2568_ sky130_fd_sc_hd__mux2_1
X_3282_ _2745_ VGND VGND VPWR VPWR _2756_ sky130_fd_sc_hd__buf_2
X_5021_ _1572_ _1587_ _1574_ VGND VGND VPWR VPWR _1589_ sky130_fd_sc_hd__or3_1
XTAP_TAPCELL_ROW_88_1032 VGND VPWR sky130_fd_sc_hd__tapvpwrvgnd_1
XTAP_TAPCELL_ROW_64_811 VGND VPWR sky130_fd_sc_hd__tapvpwrvgnd_1
XFILLER_0_75_201 VPWR VGND VPWR VGND sky130_ef_sc_hd__decap_12
X_5923_ _2447_ _2452_ _2457_ VGND VGND VPWR VPWR _2458_ sky130_fd_sc_hd__a21oi_1
XTAP_TAPCELL_ROW_36_546 VGND VPWR sky130_fd_sc_hd__tapvpwrvgnd_1
XFILLER_0_8_501 VPWR VGND VPWR VGND sky130_ef_sc_hd__decap_12
X_5854_ _2395_ _2397_ VGND VGND VPWR VPWR _2398_ sky130_fd_sc_hd__xnor2_1
X_4805_ net123 _2631_ _0534_ _0625_ VGND VGND VPWR VPWR _1376_ sky130_fd_sc_hd__nand4_2
XFILLER_0_75_278 VGND VGND VPWR VPWR sky130_fd_sc_hd__fill_2
XFILLER_0_8_545 VGND VGND VPWR VPWR sky130_fd_sc_hd__fill_2
XFILLER_0_61_84 VGND VGND VPWR VPWR sky130_fd_sc_hd__decap_6
XFILLER_0_16_312 VPWR VGND VPWR VGND sky130_ef_sc_hd__decap_12
X_5785_ _2336_ _2337_ VGND VGND VPWR VPWR _2338_ sky130_fd_sc_hd__or2b_1
X_4736_ _2637_ _0516_ _1304_ _1306_ VGND VGND VPWR VPWR _1308_ sky130_fd_sc_hd__a22oi_1
XFILLER_0_28_194 VGND VGND VPWR VPWR sky130_fd_sc_hd__fill_2
X_4667_ _1237_ _1238_ _1215_ _1162_ VGND VGND VPWR VPWR _1240_ sky130_fd_sc_hd__a211oi_4
XFILLER_0_9_96 VPWR VGND VPWR VGND sky130_ef_sc_hd__decap_12
X_3618_ _2931_ net8 _2982_ net9 net10 VGND VGND VPWR VPWR _0216_ sky130_fd_sc_hd__a32o_1
XFILLER_0_3_261 VPWR VGND VPWR VGND sky130_ef_sc_hd__decap_12
XFILLER_0_43_197 VGND VGND VPWR VPWR sky130_fd_sc_hd__fill_2
X_4598_ _1171_ _1170_ _1097_ VGND VGND VPWR VPWR _1172_ sky130_fd_sc_hd__nor3b_4
X_3549_ _2982_ _2986_ _2987_ VGND VGND VPWR VPWR _2988_ sky130_fd_sc_hd__or3_1
X_6268_ clknet_leaf_16_clk _0181_ VGND VGND VPWR VPWR net59 sky130_fd_sc_hd__dfxtp_1
X_5219_ _1689_ _1717_ _1783_ VGND VGND VPWR VPWR _1784_ sky130_fd_sc_hd__o21a_1
X_6199_ clknet_leaf_19_clk _0112_ VGND VGND VPWR VPWR u_interface.u_compute_core.u_av.product_reg\[6\]
+ sky130_fd_sc_hd__dfxtp_1
XTAP_TAPCELL_ROW_70_869 VGND VPWR sky130_fd_sc_hd__tapvpwrvgnd_1
XFILLER_0_19_161 VGND VGND VPWR VPWR sky130_fd_sc_hd__decap_6
XFILLER_0_62_462 VGND VGND VPWR VPWR sky130_fd_sc_hd__decap_3
XFILLER_0_22_348 VGND VGND VPWR VPWR sky130_fd_sc_hd__decap_3
XFILLER_0_34_197 VGND VGND VPWR VPWR sky130_fd_sc_hd__fill_1
XFILLER_0_30_370 VGND VGND VPWR VPWR sky130_fd_sc_hd__decap_6
XFILLER_0_30_392 VPWR VGND VPWR VGND sky130_ef_sc_hd__decap_12
XFILLER_0_66_29 VPWR VGND VPWR VGND sky130_ef_sc_hd__decap_12
XTAP_TAPCELL_ROW_78_936 VGND VPWR sky130_fd_sc_hd__tapvpwrvgnd_1
XFILLER_0_89_337 VGND VGND VPWR VPWR sky130_fd_sc_hd__decap_6
XFILLER_0_15_55 VGND VGND VPWR VPWR sky130_fd_sc_hd__fill_1
XTAP_TAPCELL_ROW_33_516 VGND VPWR sky130_fd_sc_hd__tapvpwrvgnd_1
XFILLER_0_57_223 VGND VGND VPWR VPWR sky130_fd_sc_hd__fill_1
XFILLER_0_57_278 VGND VGND VPWR VPWR sky130_fd_sc_hd__fill_2
XFILLER_0_72_259 VPWR VGND VPWR VGND sky130_ef_sc_hd__decap_12
XFILLER_0_31_76 VPWR VGND VPWR VGND sky130_ef_sc_hd__decap_12
XTAP_TAPCELL_ROW_41_593 VGND VPWR sky130_fd_sc_hd__tapvpwrvgnd_1
X_5570_ _2660_ _0559_ _0597_ _1644_ VGND VGND VPWR VPWR _2131_ sky130_fd_sc_hd__a22oi_1
X_4521_ _1093_ _1094_ _1074_ VGND VGND VPWR VPWR _1096_ sky130_fd_sc_hd__a21o_1
X_4452_ _1006_ _1027_ VGND VGND VPWR VPWR _1028_ sky130_fd_sc_hd__xnor2_2
XFILLER_0_13_337 VGND VGND VPWR VPWR sky130_fd_sc_hd__fill_2
XFILLER_0_40_123 VGND VGND VPWR VPWR sky130_fd_sc_hd__decap_6
XFILLER_0_40_134 VGND VGND VPWR VPWR sky130_fd_sc_hd__decap_6
X_3403_ _2832_ u_interface.u_compute_core.mac_accum\[20\] VGND VGND VPWR VPWR _2859_
+ sky130_fd_sc_hd__nor2_1
XFILLER_0_40_167 VGND VGND VPWR VPWR sky130_fd_sc_hd__decap_4
XFILLER_0_0_253 VPWR VGND VPWR VGND sky130_ef_sc_hd__decap_12
X_4383_ _0813_ _0958_ _0959_ VGND VGND VPWR VPWR _0960_ sky130_fd_sc_hd__and3_1
X_3334_ u_interface.u_compute_core.u_mac.product_reg\[10\] u_interface.u_compute_core.mac_accum\[10\]
+ VGND VGND VPWR VPWR _2800_ sky130_fd_sc_hd__or2_1
X_6122_ clknet_leaf_4_clk _0035_ VGND VGND VPWR VPWR u_interface.u_compute_core.scaled_data\[6\]
+ sky130_fd_sc_hd__dfxtp_1
X_6053_ _2512_ _2434_ _2581_ VGND VGND VPWR VPWR _2557_ sky130_fd_sc_hd__a21oi_1
X_3265_ _2739_ VGND VGND VPWR VPWR _2740_ sky130_fd_sc_hd__buf_2
X_5004_ _1506_ _1571_ VGND VGND VPWR VPWR _1572_ sky130_fd_sc_hd__and2_1
XFILLER_0_56_51 VPWR VGND VPWR VGND sky130_ef_sc_hd__decap_12
X_3196_ _2672_ _2692_ VGND VGND VPWR VPWR _2693_ sky130_fd_sc_hd__and2_1
XFILLER_0_15_3 VPWR VGND VPWR VGND sky130_ef_sc_hd__decap_12
X_5906_ _2441_ _2442_ VGND VGND VPWR VPWR _2443_ sky130_fd_sc_hd__and2_1
XFILLER_0_48_223 VPWR VGND VPWR VGND sky130_ef_sc_hd__decap_12
XFILLER_0_48_267 VPWR VGND VPWR VGND sky130_ef_sc_hd__decap_12
XFILLER_0_63_237 VPWR VGND VPWR VGND sky130_ef_sc_hd__decap_12
X_5837_ _2361_ _2368_ _2370_ _2375_ _2367_ VGND VGND VPWR VPWR _2383_ sky130_fd_sc_hd__o311a_1
X_5768_ _2321_ _2322_ VGND VGND VPWR VPWR _2323_ sky130_fd_sc_hd__nand2_1
X_4719_ u_interface.u_compute_core.relu_data\[13\] _0556_ VGND VGND VPWR VPWR _1291_
+ sky130_fd_sc_hd__nand2_1
XFILLER_0_16_164 VPWR VGND VPWR VGND sky130_ef_sc_hd__decap_12
XFILLER_0_16_197 VPWR VGND VPWR VGND sky130_ef_sc_hd__decap_12
X_5699_ _2660_ _2655_ VGND VGND VPWR VPWR _2258_ sky130_fd_sc_hd__xor2_1
XFILLER_0_12_370 VGND VGND VPWR VPWR sky130_fd_sc_hd__fill_1
XFILLER_0_31_189 VPWR VGND VPWR VGND sky130_ef_sc_hd__decap_12
XTAP_TAPCELL_ROW_4_241 VGND VPWR sky130_fd_sc_hd__tapvpwrvgnd_1
XFILLER_0_86_307 VGND VGND VPWR VPWR sky130_fd_sc_hd__fill_1
XFILLER_0_39_223 VGND VGND VPWR VPWR sky130_fd_sc_hd__fill_1
XFILLER_0_27_418 VGND VGND VPWR VPWR sky130_fd_sc_hd__decap_3
XFILLER_0_82_513 VPWR VGND VPWR VGND sky130_ef_sc_hd__decap_12
XFILLER_0_39_289 VGND VGND VPWR VPWR sky130_fd_sc_hd__decap_8
XFILLER_0_50_421 VGND VGND VPWR VPWR sky130_fd_sc_hd__fill_2
XTAP_TAPCELL_ROW_10_298 VGND VPWR sky130_fd_sc_hd__tapvpwrvgnd_1
XFILLER_0_10_307 VGND VGND VPWR VPWR sky130_fd_sc_hd__fill_1
XFILLER_0_22_145 VGND VGND VPWR VPWR sky130_fd_sc_hd__decap_4
X_3050_ u_interface.u_compute_core.relu_data\[0\] VGND VGND VPWR VPWR _2585_ sky130_fd_sc_hd__inv_2
XTAP_TAPCELL_ROW_46_641 VGND VPWR sky130_fd_sc_hd__tapvpwrvgnd_1
XFILLER_0_85_340 VGND VGND VPWR VPWR sky130_fd_sc_hd__decap_8
XFILLER_0_18_407 VPWR VGND VPWR VGND sky130_ef_sc_hd__decap_12
X_3952_ _0533_ _0537_ VGND VGND VPWR VPWR _0538_ sky130_fd_sc_hd__xor2_2
X_3883_ _0452_ _0450_ _0473_ VGND VGND VPWR VPWR _0474_ sky130_fd_sc_hd__or3_1
XFILLER_0_45_237 VGND VGND VPWR VPWR sky130_fd_sc_hd__decap_3
X_5622_ _1860_ _2181_ VGND VGND VPWR VPWR _2183_ sky130_fd_sc_hd__or2_1
X_5553_ _2112_ _2114_ VGND VGND VPWR VPWR _2115_ sky130_fd_sc_hd__or2_1
X_4504_ _0988_ _0990_ _1078_ VGND VGND VPWR VPWR _1079_ sky130_fd_sc_hd__a21o_1
XFILLER_0_53_281 VGND VGND VPWR VPWR sky130_fd_sc_hd__fill_1
X_5484_ _2043_ _2044_ VGND VGND VPWR VPWR _2046_ sky130_fd_sc_hd__nor2_1
X_4435_ u_interface.u_compute_core.relu_data\[7\] _0595_ _0923_ _0922_ VGND VGND VPWR
+ VPWR _1011_ sky130_fd_sc_hd__a31o_1
XFILLER_0_41_487 VGND VGND VPWR VPWR sky130_fd_sc_hd__fill_1
XFILLER_0_41_498 VGND VGND VPWR VPWR sky130_fd_sc_hd__decap_6
X_4366_ _0877_ _0878_ VGND VGND VPWR VPWR _0943_ sky130_fd_sc_hd__nand2_1
XFILLER_0_6_64 VPWR VGND VPWR VGND sky130_ef_sc_hd__decap_12
X_6105_ clknet_leaf_7_clk _0018_ VGND VGND VPWR VPWR u_interface.u_compute_core.relu_data\[18\]
+ sky130_fd_sc_hd__dfxtp_2
XFILLER_0_6_97 VGND VGND VPWR VPWR sky130_fd_sc_hd__decap_4
X_3317_ _2785_ VGND VGND VPWR VPWR _2786_ sky130_fd_sc_hd__inv_2
X_4297_ _0612_ _0535_ _0799_ _0798_ VGND VGND VPWR VPWR _0875_ sky130_fd_sc_hd__a31o_1
X_6036_ _2539_ _2545_ VGND VGND VPWR VPWR _2546_ sky130_fd_sc_hd__and2_1
X_3248_ _2728_ VGND VGND VPWR VPWR _0054_ sky130_fd_sc_hd__clkbuf_1
Xrebuffer20 _1099_ VGND VGND VPWR VPWR net85 sky130_fd_sc_hd__clkbuf_2
XTAP_TAPCELL_ROW_1_211 VGND VPWR sky130_fd_sc_hd__tapvpwrvgnd_1
X_3179_ u_interface.u_compute_core.scaled_data\[4\] u_interface.u_compute_core.mac_accum\[7\]
+ _2669_ VGND VGND VPWR VPWR _2681_ sky130_fd_sc_hd__mux2_1
XFILLER_0_83_82 VPWR VGND VPWR VGND sky130_ef_sc_hd__decap_12
Xrebuffer64 net128 VGND VGND VPWR VPWR net129 sky130_fd_sc_hd__buf_2
Xrebuffer31 _0909_ VGND VGND VPWR VPWR net96 sky130_fd_sc_hd__dlygate4sd1_1
Xrebuffer42 _1180_ VGND VGND VPWR VPWR net107 sky130_fd_sc_hd__dlymetal6s4s_1
XFILLER_0_49_521 VPWR VGND VPWR VGND sky130_ef_sc_hd__decap_12
XTAP_TAPCELL_ROW_80_964 VGND VPWR sky130_fd_sc_hd__tapvpwrvgnd_1
XFILLER_0_91_376 VGND VGND VPWR VPWR sky130_fd_sc_hd__fill_1
XFILLER_0_51_207 VGND VGND VPWR VPWR sky130_fd_sc_hd__fill_1
XFILLER_0_32_432 VGND VGND VPWR VPWR sky130_fd_sc_hd__fill_1
XFILLER_0_32_465 VGND VGND VPWR VPWR sky130_fd_sc_hd__decap_8
XFILLER_0_4_3 VPWR VGND VPWR VGND sky130_ef_sc_hd__decap_12
XTAP_TAPCELL_ROW_43_611 VGND VPWR sky130_fd_sc_hd__tapvpwrvgnd_1
XFILLER_0_55_502 VGND VGND VPWR VPWR sky130_fd_sc_hd__fill_2
XFILLER_0_67_373 VGND VGND VPWR VPWR sky130_fd_sc_hd__decap_4
XTAP_TAPCELL_ROW_15_346 VGND VPWR sky130_fd_sc_hd__tapvpwrvgnd_1
XFILLER_0_55_546 VGND VGND VPWR VPWR sky130_fd_sc_hd__fill_1
XFILLER_0_82_365 VGND VGND VPWR VPWR sky130_fd_sc_hd__fill_1
XFILLER_0_88_27 VGND VGND VPWR VPWR sky130_fd_sc_hd__fill_1
XFILLER_0_35_281 VPWR VGND VPWR VGND sky130_ef_sc_hd__decap_12
X_4220_ _2615_ _0499_ _0489_ _2611_ VGND VGND VPWR VPWR _0799_ sky130_fd_sc_hd__a22o_1
XTAP_TAPCELL_ROW_91_1061 VGND VPWR sky130_fd_sc_hd__tapvpwrvgnd_1
X_4151_ _0611_ _0639_ _0682_ _0731_ VGND VGND VPWR VPWR _0732_ sky130_fd_sc_hd__a31o_1
X_3102_ u_interface.u_compute_core.relu_data\[12\] VGND VGND VPWR VPWR _2625_ sky130_fd_sc_hd__buf_6
X_4082_ _0662_ _0663_ VGND VGND VPWR VPWR _0664_ sky130_fd_sc_hd__xnor2_1
X_4984_ _1476_ _1042_ _1474_ VGND VGND VPWR VPWR _1553_ sky130_fd_sc_hd__a21o_1
X_3935_ _0519_ _0520_ _0521_ VGND VGND VPWR VPWR _0522_ sky130_fd_sc_hd__o21ai_1
XFILLER_0_58_395 VPWR VGND VPWR VGND sky130_ef_sc_hd__decap_12
XFILLER_0_73_332 VGND VGND VPWR VPWR sky130_fd_sc_hd__decap_4
XFILLER_0_73_387 VGND VGND VPWR VPWR sky130_fd_sc_hd__decap_4
X_3866_ _0217_ _0265_ _0398_ _0427_ VGND VGND VPWR VPWR _0457_ sky130_fd_sc_hd__o211ai_1
X_5605_ _2164_ _2165_ VGND VGND VPWR VPWR _2166_ sky130_fd_sc_hd__xor2_1
XFILLER_0_61_505 VGND VGND VPWR VPWR sky130_fd_sc_hd__decap_4
XFILLER_0_82_3 VPWR VGND VPWR VGND sky130_ef_sc_hd__decap_12
XFILLER_0_14_421 VGND VGND VPWR VPWR sky130_fd_sc_hd__decap_8
X_3797_ _0388_ _0389_ VGND VGND VPWR VPWR _0391_ sky130_fd_sc_hd__nand2_1
X_5536_ _2096_ _2097_ VGND VGND VPWR VPWR _2098_ sky130_fd_sc_hd__nand2_1
X_5467_ _1947_ _1951_ _1945_ VGND VGND VPWR VPWR _2030_ sky130_fd_sc_hd__o21a_1
XFILLER_0_78_82 VGND VGND VPWR VPWR sky130_fd_sc_hd__fill_2
X_4418_ net114 u_interface.u_compute_core.relu_data\[12\] net19 net20 VGND VGND VPWR
+ VPWR _0994_ sky130_fd_sc_hd__and4_1
X_5398_ u_interface.u_compute_core.relu_data\[25\] _0516_ _1959_ _1960_ VGND VGND
+ VPWR VPWR _1961_ sky130_fd_sc_hd__o2bb2a_1
X_4349_ _2619_ _0489_ VGND VGND VPWR VPWR _0926_ sky130_fd_sc_hd__nand2_1
X_6019_ _2516_ _2533_ VGND VGND VPWR VPWR _2534_ sky130_fd_sc_hd__and2_1
XFILLER_0_68_148 VGND VGND VPWR VPWR sky130_fd_sc_hd__decap_6
XFILLER_0_83_107 VGND VGND VPWR VPWR sky130_fd_sc_hd__decap_4
XTAP_TAPCELL_ROW_12_316 VGND VPWR sky130_fd_sc_hd__tapvpwrvgnd_1
XFILLER_0_64_376 VGND VGND VPWR VPWR sky130_fd_sc_hd__decap_8
XFILLER_0_64_354 VGND VGND VPWR VPWR sky130_fd_sc_hd__fill_1
XFILLER_0_52_516 VGND VGND VPWR VPWR sky130_fd_sc_hd__decap_6
XTAP_TAPCELL_ROW_20_393 VGND VPWR sky130_fd_sc_hd__tapvpwrvgnd_1
XFILLER_0_32_262 VGND VGND VPWR VPWR sky130_fd_sc_hd__fill_1
XFILLER_0_59_137 VGND VGND VPWR VPWR sky130_fd_sc_hd__fill_2
XFILLER_0_23_11 VGND VGND VPWR VPWR sky130_fd_sc_hd__fill_2
XFILLER_0_67_192 VGND VGND VPWR VPWR sky130_fd_sc_hd__decap_8
X_3720_ _0262_ _0273_ _0314_ VGND VGND VPWR VPWR _0316_ sky130_fd_sc_hd__or3_1
XFILLER_0_7_429 VPWR VGND VPWR VGND sky130_ef_sc_hd__decap_12
XFILLER_0_43_505 VGND VGND VPWR VPWR sky130_fd_sc_hd__decap_6
X_3651_ net9 _2982_ _3012_ _0220_ VGND VGND VPWR VPWR _0248_ sky130_fd_sc_hd__o31a_1
X_3582_ _3017_ _3019_ VGND VGND VPWR VPWR _3020_ sky130_fd_sc_hd__nand2_1
X_5321_ _2650_ _0596_ _0634_ _2647_ VGND VGND VPWR VPWR _1885_ sky130_fd_sc_hd__a22oi_1
XFILLER_0_2_156 VGND VGND VPWR VPWR sky130_fd_sc_hd__fill_1
X_5252_ _1728_ _1815_ _1816_ VGND VGND VPWR VPWR _1817_ sky130_fd_sc_hd__nand3_1
XFILLER_0_11_468 VPWR VGND VPWR VGND sky130_ef_sc_hd__decap_12
X_5183_ _1655_ _1657_ _1656_ VGND VGND VPWR VPWR _1749_ sky130_fd_sc_hd__o21bai_1
X_4203_ _0779_ _0780_ _0737_ VGND VGND VPWR VPWR _0783_ sky130_fd_sc_hd__a21boi_1
XFILLER_0_48_85 VGND VGND VPWR VPWR sky130_fd_sc_hd__decap_8
X_4134_ u_interface.u_compute_core.relu_data\[6\] net20 net21 net86 VGND VGND VPWR
+ VPWR _0715_ sky130_fd_sc_hd__a22o_1
X_4065_ _0485_ net158 _0486_ _0647_ VGND VGND VPWR VPWR _0113_ sky130_fd_sc_hd__o211a_1
XFILLER_0_78_446 VGND VGND VPWR VPWR sky130_fd_sc_hd__fill_2
XTAP_TAPCELL_ROW_54_717 VGND VPWR sky130_fd_sc_hd__tapvpwrvgnd_1
XFILLER_0_78_457 VGND VGND VPWR VPWR sky130_fd_sc_hd__fill_1
XFILLER_0_65_129 VGND VGND VPWR VPWR sky130_fd_sc_hd__fill_1
X_4967_ _1533_ _1534_ _1519_ VGND VGND VPWR VPWR _1536_ sky130_fd_sc_hd__a21o_1
XFILLER_0_46_321 VPWR VGND VPWR VGND sky130_ef_sc_hd__decap_12
X_4898_ _1466_ _1424_ _1467_ VGND VGND VPWR VPWR _1468_ sky130_fd_sc_hd__and3_1
XFILLER_0_46_365 VPWR VGND VPWR VGND sky130_ef_sc_hd__decap_12
X_3918_ _2595_ u_interface.u_compute_core.relu_data\[2\] _0502_ _0504_ VGND VGND VPWR
+ VPWR _0505_ sky130_fd_sc_hd__and4_1
X_3849_ _0426_ _0440_ VGND VGND VPWR VPWR _0441_ sky130_fd_sc_hd__and2b_1
XFILLER_0_89_81 VPWR VGND VPWR VGND sky130_ef_sc_hd__decap_12
X_5519_ _1989_ _1974_ VGND VGND VPWR VPWR _2081_ sky130_fd_sc_hd__or2b_1
XFILLER_0_69_402 VGND VGND VPWR VPWR sky130_fd_sc_hd__fill_1
XFILLER_0_69_435 VGND VGND VPWR VPWR sky130_fd_sc_hd__decap_4
XFILLER_0_69_446 VGND VGND VPWR VPWR sky130_fd_sc_hd__fill_2
XTAP_TAPCELL_ROW_25_441 VGND VPWR sky130_fd_sc_hd__tapvpwrvgnd_1
Xclkbuf_leaf_22_clk clknet_1_0__leaf_clk VGND VGND VPWR VPWR clknet_leaf_22_clk sky130_fd_sc_hd__clkbuf_8
XFILLER_0_37_376 VGND VGND VPWR VPWR sky130_fd_sc_hd__fill_2
XFILLER_0_40_519 VPWR VGND VPWR VGND sky130_ef_sc_hd__decap_12
XFILLER_0_20_221 VPWR VGND VPWR VGND sky130_ef_sc_hd__decap_12
XFILLER_0_85_39 VPWR VGND VPWR VGND sky130_ef_sc_hd__decap_12
XPHY_EDGE_ROW_0_Left_93 VGND VGND VPWR VPWR sky130_fd_sc_hd__decap_3
XFILLER_0_18_44 VPWR VGND VPWR VGND sky130_ef_sc_hd__decap_12
X_5870_ _2408_ _2410_ VGND VGND VPWR VPWR _2412_ sky130_fd_sc_hd__nand2_1
X_4821_ _1356_ _1357_ _1391_ VGND VGND VPWR VPWR _1392_ sky130_fd_sc_hd__nand3_4
XFILLER_0_75_416 VGND VGND VPWR VPWR sky130_fd_sc_hd__decap_8
XFILLER_0_34_65 VPWR VGND VPWR VGND sky130_ef_sc_hd__decap_12
XFILLER_0_87_298 VGND VGND VPWR VPWR sky130_fd_sc_hd__fill_1
XFILLER_0_75_449 VGND VGND VPWR VPWR sky130_fd_sc_hd__fill_1
XFILLER_0_90_419 VGND VGND VPWR VPWR sky130_fd_sc_hd__fill_1
X_4752_ _1321_ _1322_ _1205_ _1207_ VGND VGND VPWR VPWR _1324_ sky130_fd_sc_hd__o211a_1
XFILLER_0_7_237 VPWR VGND VPWR VGND sky130_ef_sc_hd__decap_12
Xclkbuf_leaf_13_clk clknet_1_1__leaf_clk VGND VGND VPWR VPWR clknet_leaf_13_clk sky130_fd_sc_hd__clkbuf_8
XFILLER_0_28_365 VGND VGND VPWR VPWR sky130_fd_sc_hd__decap_6
X_3703_ _0297_ _0298_ VGND VGND VPWR VPWR _0299_ sky130_fd_sc_hd__nand2_1
X_4683_ _1252_ _1254_ _1253_ VGND VGND VPWR VPWR _1256_ sky130_fd_sc_hd__and3_1
XFILLER_0_50_53 VGND VGND VPWR VPWR sky130_fd_sc_hd__decap_4
X_3634_ _0230_ _0231_ VGND VGND VPWR VPWR _0232_ sky130_fd_sc_hd__nor2_1
XFILLER_0_50_97 VGND VGND VPWR VPWR sky130_fd_sc_hd__decap_4
X_3565_ _2981_ _3002_ VGND VGND VPWR VPWR _3004_ sky130_fd_sc_hd__and2_1
X_5304_ _1843_ _1844_ _1847_ VGND VGND VPWR VPWR _1868_ sky130_fd_sc_hd__nor3_1
X_3496_ _2928_ _2936_ _2932_ VGND VGND VPWR VPWR _2938_ sky130_fd_sc_hd__nand3_1
X_6284_ clknet_leaf_13_clk _0197_ VGND VGND VPWR VPWR net45 sky130_fd_sc_hd__dfxtp_1
X_5235_ _1735_ _1736_ VGND VGND VPWR VPWR _1800_ sky130_fd_sc_hd__nor2_1
XFILLER_0_45_3 VPWR VGND VPWR VGND sky130_ef_sc_hd__decap_12
X_5166_ _1509_ _0489_ _0702_ _2640_ VGND VGND VPWR VPWR _1732_ sky130_fd_sc_hd__a22o_1
X_5097_ _1661_ _1663_ VGND VGND VPWR VPWR _1664_ sky130_fd_sc_hd__xnor2_1
X_4117_ _0696_ _0697_ VGND VGND VPWR VPWR _0698_ sky130_fd_sc_hd__or2b_1
XTAP_TAPCELL_ROW_39_566 VGND VPWR sky130_fd_sc_hd__tapvpwrvgnd_1
X_4048_ _0629_ _0630_ VGND VGND VPWR VPWR _0631_ sky130_fd_sc_hd__xnor2_1
XFILLER_0_91_93 VPWR VGND VPWR VGND sky130_ef_sc_hd__decap_12
X_5999_ _2520_ VGND VGND VPWR VPWR _0174_ sky130_fd_sc_hd__clkbuf_1
XFILLER_0_81_408 VGND VGND VPWR VPWR sky130_fd_sc_hd__decap_8
XTAP_TAPCELL_ROW_22_411 VGND VPWR sky130_fd_sc_hd__tapvpwrvgnd_1
XFILLER_0_61_110 VGND VGND VPWR VPWR sky130_fd_sc_hd__fill_2
XPHY_EDGE_ROW_18_Left_111 VGND VGND VPWR VPWR sky130_fd_sc_hd__decap_3
XFILLER_0_30_530 VGND VGND VPWR VPWR sky130_fd_sc_hd__fill_2
XPHY_EDGE_ROW_27_Left_120 VGND VGND VPWR VPWR sky130_fd_sc_hd__decap_3
XFILLER_0_57_405 VPWR VGND VPWR VGND sky130_ef_sc_hd__decap_12
XFILLER_0_84_235 VPWR VGND VPWR VGND sky130_ef_sc_hd__decap_12
XTAP_TAPCELL_ROW_73_889 VGND VPWR sky130_fd_sc_hd__tapvpwrvgnd_1
XFILLER_0_57_438 VGND VGND VPWR VPWR sky130_fd_sc_hd__fill_1
XFILLER_0_57_449 VPWR VGND VPWR VGND sky130_ef_sc_hd__decap_12
XFILLER_0_72_419 VGND VGND VPWR VPWR sky130_fd_sc_hd__fill_1
XFILLER_0_25_313 VGND VGND VPWR VPWR sky130_fd_sc_hd__decap_4
XFILLER_0_80_474 VGND VGND VPWR VPWR sky130_fd_sc_hd__fill_2
XFILLER_0_40_305 VGND VGND VPWR VPWR sky130_fd_sc_hd__decap_3
XFILLER_0_0_413 VGND VGND VPWR VPWR sky130_fd_sc_hd__decap_6
X_3350_ _2812_ _2813_ VGND VGND VPWR VPWR _2814_ sky130_fd_sc_hd__nand2_1
XFILLER_0_29_21 VGND VGND VPWR VPWR sky130_fd_sc_hd__fill_1
X_5020_ _1572_ _1574_ _1587_ VGND VGND VPWR VPWR _1588_ sky130_fd_sc_hd__o21a_1
X_3281_ _2749_ _2751_ _2754_ VGND VGND VPWR VPWR _2755_ sky130_fd_sc_hd__a21o_1
Xclkbuf_leaf_2_clk clknet_1_0__leaf_clk VGND VGND VPWR VPWR clknet_leaf_2_clk sky130_fd_sc_hd__clkbuf_8
XTAP_TAPCELL_ROW_88_1033 VGND VPWR sky130_fd_sc_hd__tapvpwrvgnd_1
XTAP_TAPCELL_ROW_64_812 VGND VPWR sky130_fd_sc_hd__tapvpwrvgnd_1
XFILLER_0_75_213 VGND VGND VPWR VPWR sky130_fd_sc_hd__decap_8
X_5922_ _2455_ _2456_ VGND VGND VPWR VPWR _2457_ sky130_fd_sc_hd__and2_1
XFILLER_0_48_416 VGND VGND VPWR VPWR sky130_fd_sc_hd__decap_4
XFILLER_0_75_246 VGND VGND VPWR VPWR sky130_fd_sc_hd__decap_8
XFILLER_0_8_513 VPWR VGND VPWR VGND sky130_ef_sc_hd__decap_12
XFILLER_0_0_77 VGND VGND VPWR VPWR sky130_fd_sc_hd__decap_3
XFILLER_0_0_55 VGND VGND VPWR VPWR sky130_fd_sc_hd__fill_1
X_5853_ _2387_ _2396_ VGND VGND VPWR VPWR _2397_ sky130_fd_sc_hd__nor2_1
X_4804_ u_interface.u_compute_core.relu_data\[13\] _0595_ VGND VGND VPWR VPWR _1375_
+ sky130_fd_sc_hd__nand2_1
XFILLER_0_75_268 VGND VGND VPWR VPWR sky130_fd_sc_hd__fill_1
X_5784_ u_interface.core_attn_out\[5\] u_interface.u_compute_core.u_av.product_reg\[8\]
+ VGND VGND VPWR VPWR _2337_ sky130_fd_sc_hd__nand2_1
X_4735_ _2637_ _0500_ _1304_ _1306_ VGND VGND VPWR VPWR _1307_ sky130_fd_sc_hd__and4_1
XFILLER_0_16_324 VGND VGND VPWR VPWR sky130_fd_sc_hd__decap_3
X_4666_ _1215_ _1162_ _1237_ _1238_ VGND VGND VPWR VPWR _1239_ sky130_fd_sc_hd__o211a_4
XFILLER_0_9_75 VGND VGND VPWR VPWR sky130_fd_sc_hd__fill_1
X_4597_ _1136_ _1137_ _1169_ VGND VGND VPWR VPWR _1171_ sky130_fd_sc_hd__a21oi_2
X_3617_ _0213_ _0214_ VGND VGND VPWR VPWR _0215_ sky130_fd_sc_hd__nor2_1
X_3548_ _2983_ _2985_ net4 _2949_ VGND VGND VPWR VPWR _2987_ sky130_fd_sc_hd__and4bb_1
XFILLER_0_3_273 VGND VGND VPWR VPWR sky130_fd_sc_hd__decap_6
X_6267_ clknet_leaf_16_clk _0180_ VGND VGND VPWR VPWR net58 sky130_fd_sc_hd__dfxtp_1
X_3479_ _2920_ _2921_ _2918_ VGND VGND VPWR VPWR _2924_ sky130_fd_sc_hd__o21a_1
X_5218_ net127 _1716_ VGND VGND VPWR VPWR _1783_ sky130_fd_sc_hd__or2b_1
X_6198_ clknet_leaf_18_clk _0111_ VGND VGND VPWR VPWR u_interface.u_compute_core.u_av.product_reg\[5\]
+ sky130_fd_sc_hd__dfxtp_1
X_5149_ _1689_ _1691_ _1714_ VGND VGND VPWR VPWR _1715_ sky130_fd_sc_hd__o21a_1
XFILLER_0_66_246 VGND VGND VPWR VPWR sky130_fd_sc_hd__decap_6
XFILLER_0_39_449 VPWR VGND VPWR VGND sky130_ef_sc_hd__decap_12
XFILLER_0_66_257 VGND VGND VPWR VPWR sky130_fd_sc_hd__fill_1
XFILLER_0_54_419 VGND VGND VPWR VPWR sky130_fd_sc_hd__fill_1
XFILLER_0_74_290 VGND VGND VPWR VPWR sky130_fd_sc_hd__decap_8
XFILLER_0_62_441 VGND VGND VPWR VPWR sky130_fd_sc_hd__decap_8
XTAP_TAPCELL_ROW_78_937 VGND VPWR sky130_fd_sc_hd__tapvpwrvgnd_1
XFILLER_0_82_29 VPWR VGND VPWR VGND sky130_ef_sc_hd__decap_12
XTAP_TAPCELL_ROW_33_517 VGND VPWR sky130_fd_sc_hd__tapvpwrvgnd_1
XFILLER_0_5_505 VPWR VGND VPWR VGND sky130_ef_sc_hd__decap_12
XFILLER_0_25_143 VGND VGND VPWR VPWR sky130_fd_sc_hd__decap_3
X_4520_ _1074_ _1093_ _1094_ VGND VGND VPWR VPWR _1095_ sky130_fd_sc_hd__nand3_2
XFILLER_0_31_88 VPWR VGND VPWR VGND sky130_ef_sc_hd__decap_12
X_4451_ _1025_ _1026_ VGND VGND VPWR VPWR _1027_ sky130_fd_sc_hd__or2_1
XFILLER_0_25_198 VGND VGND VPWR VPWR sky130_fd_sc_hd__fill_1
X_3402_ u_interface.u_compute_core.mac_accum\[19\] net27 _2858_ net61 VGND VGND VPWR
+ VPWR _0078_ sky130_fd_sc_hd__o211a_1
X_6121_ clknet_leaf_4_clk _0034_ VGND VGND VPWR VPWR u_interface.u_compute_core.scaled_data\[5\]
+ sky130_fd_sc_hd__dfxtp_1
X_4382_ _0956_ _0957_ _0884_ _0886_ VGND VGND VPWR VPWR _0959_ sky130_fd_sc_hd__o211ai_2
XFILLER_0_0_265 VGND VGND VPWR VPWR sky130_fd_sc_hd__decap_4
XFILLER_0_0_287 VGND VGND VPWR VPWR sky130_fd_sc_hd__decap_3
XFILLER_0_21_393 VGND VGND VPWR VPWR sky130_fd_sc_hd__decap_8
X_3333_ u_interface.u_compute_core.u_mac.product_reg\[10\] u_interface.u_compute_core.mac_accum\[10\]
+ VGND VGND VPWR VPWR _2799_ sky130_fd_sc_hd__nand2_1
XPHY_EDGE_ROW_7_Right_7 VGND VGND VPWR VPWR sky130_fd_sc_hd__decap_3
X_6052_ _2556_ VGND VGND VPWR VPWR _0191_ sky130_fd_sc_hd__clkbuf_1
X_3264_ _2579_ net27 VGND VGND VPWR VPWR _2739_ sky130_fd_sc_hd__and2_1
XFILLER_0_56_41 VGND VGND VPWR VPWR sky130_fd_sc_hd__fill_2
X_5003_ _1512_ VGND VGND VPWR VPWR _1571_ sky130_fd_sc_hd__inv_2
XFILLER_0_56_63 VGND VGND VPWR VPWR sky130_fd_sc_hd__decap_8
X_3195_ u_interface.u_compute_core.scaled_data\[9\] u_interface.u_compute_core.mac_accum\[12\]
+ _2691_ VGND VGND VPWR VPWR _2692_ sky130_fd_sc_hd__mux2_1
XFILLER_0_56_85 VPWR VGND VPWR VGND sky130_ef_sc_hd__decap_12
XTAP_TAPCELL_ROW_49_661 VGND VPWR sky130_fd_sc_hd__tapvpwrvgnd_1
XFILLER_0_76_533 VPWR VGND VPWR VGND sky130_ef_sc_hd__decap_12
X_5905_ u_interface.core_attn_out\[21\] u_interface.u_compute_core.u_av.product_reg\[24\]
+ VGND VGND VPWR VPWR _2442_ sky130_fd_sc_hd__nand2_1
XFILLER_0_48_235 VPWR VGND VPWR VGND sky130_ef_sc_hd__decap_12
XFILLER_0_91_503 VGND VGND VPWR VPWR sky130_fd_sc_hd__fill_1
XFILLER_0_36_419 VGND VGND VPWR VPWR sky130_fd_sc_hd__fill_1
X_5836_ _2380_ _2381_ VGND VGND VPWR VPWR _2382_ sky130_fd_sc_hd__nand2_1
XFILLER_0_48_279 VGND VGND VPWR VPWR sky130_fd_sc_hd__decap_3
XFILLER_0_63_205 VGND VGND VPWR VPWR sky130_fd_sc_hd__decap_8
XFILLER_0_63_249 VGND VGND VPWR VPWR sky130_fd_sc_hd__decap_8
X_5767_ u_interface.core_attn_out\[3\] u_interface.u_compute_core.u_av.product_reg\[6\]
+ VGND VGND VPWR VPWR _2322_ sky130_fd_sc_hd__or2_1
XFILLER_0_56_290 VGND VGND VPWR VPWR sky130_fd_sc_hd__decap_8
X_4718_ _2628_ _0587_ _1232_ _1231_ VGND VGND VPWR VPWR _1290_ sky130_fd_sc_hd__a31o_1
XFILLER_0_16_176 VPWR VGND VPWR VGND sky130_ef_sc_hd__decap_12
XFILLER_0_44_463 VPWR VGND VPWR VGND sky130_ef_sc_hd__decap_12
XFILLER_0_44_485 VGND VGND VPWR VPWR sky130_fd_sc_hd__fill_1
X_5698_ _2193_ _2196_ _2194_ VGND VGND VPWR VPWR _2257_ sky130_fd_sc_hd__o21ba_1
X_4649_ u_interface.u_compute_core.relu_data\[10\] _0632_ VGND VGND VPWR VPWR _1222_
+ sky130_fd_sc_hd__and2_1
XFILLER_0_31_113 VGND VGND VPWR VPWR sky130_fd_sc_hd__decap_4
XTAP_TAPCELL_ROW_4_242 VGND VPWR sky130_fd_sc_hd__tapvpwrvgnd_1
XTAP_TAPCELL_ROW_83_984 VGND VPWR sky130_fd_sc_hd__tapvpwrvgnd_1
XFILLER_0_79_393 VPWR VGND VPWR VGND sky130_ef_sc_hd__decap_12
XFILLER_0_82_525 VGND VGND VPWR VPWR sky130_fd_sc_hd__decap_6
XFILLER_0_54_205 VPWR VGND VPWR VGND sky130_ef_sc_hd__decap_12
XFILLER_0_62_260 VPWR VGND VPWR VGND sky130_ef_sc_hd__decap_12
XTAP_TAPCELL_ROW_10_299 VGND VPWR sky130_fd_sc_hd__tapvpwrvgnd_1
XFILLER_0_50_477 VPWR VGND VPWR VGND sky130_ef_sc_hd__decap_12
XFILLER_0_89_113 VGND VGND VPWR VPWR sky130_fd_sc_hd__decap_4
XFILLER_0_26_11 VGND VGND VPWR VPWR sky130_fd_sc_hd__fill_1
XTAP_TAPCELL_ROW_85_1003 VGND VPWR sky130_fd_sc_hd__tapvpwrvgnd_1
XFILLER_0_58_500 VPWR VGND VPWR VGND sky130_ef_sc_hd__decap_12
XTAP_TAPCELL_ROW_18_366 VGND VPWR sky130_fd_sc_hd__tapvpwrvgnd_1
X_3951_ _0487_ _0536_ VGND VGND VPWR VPWR _0537_ sky130_fd_sc_hd__nand2_1
XFILLER_0_58_533 VPWR VGND VPWR VGND sky130_ef_sc_hd__decap_12
XFILLER_0_18_419 VGND VGND VPWR VPWR sky130_fd_sc_hd__fill_1
X_3882_ _0471_ _0472_ VGND VGND VPWR VPWR _0473_ sky130_fd_sc_hd__and2_1
XFILLER_0_42_65 VGND VGND VPWR VPWR sky130_fd_sc_hd__fill_2
X_5621_ _1860_ _2181_ VGND VGND VPWR VPWR _2182_ sky130_fd_sc_hd__nand2_1
XFILLER_0_5_335 VGND VGND VPWR VPWR sky130_fd_sc_hd__fill_1
X_5552_ _1860_ _2024_ _2113_ VGND VGND VPWR VPWR _2114_ sky130_fd_sc_hd__a21oi_1
XFILLER_0_53_260 VPWR VGND VPWR VGND sky130_ef_sc_hd__decap_12
X_4503_ _2615_ _2611_ _0625_ _0819_ VGND VGND VPWR VPWR _1078_ sky130_fd_sc_hd__and4_1
XFILLER_0_13_113 VGND VGND VPWR VPWR sky130_fd_sc_hd__decap_4
X_5483_ _2043_ _2044_ VGND VGND VPWR VPWR _2045_ sky130_fd_sc_hd__and2_1
X_4434_ _0944_ _0947_ VGND VGND VPWR VPWR _1010_ sky130_fd_sc_hd__nand2_4
XFILLER_0_1_541 VGND VGND VPWR VPWR sky130_fd_sc_hd__decap_6
X_4365_ _0861_ _0868_ _0867_ VGND VGND VPWR VPWR _0942_ sky130_fd_sc_hd__a21o_1
X_6104_ clknet_leaf_7_clk _0017_ VGND VGND VPWR VPWR u_interface.u_compute_core.relu_data\[17\]
+ sky130_fd_sc_hd__dfxtp_1
XFILLER_0_6_76 VGND VGND VPWR VPWR sky130_fd_sc_hd__decap_8
X_3316_ _2782_ _2783_ _2784_ VGND VGND VPWR VPWR _2785_ sky130_fd_sc_hd__and3_1
X_6035_ net33 u_interface.core_attn_out\[14\] _2544_ VGND VGND VPWR VPWR _2545_ sky130_fd_sc_hd__mux2_1
X_4296_ _0821_ _0822_ VGND VGND VPWR VPWR _0874_ sky130_fd_sc_hd__nand2_1
X_3247_ _2716_ _2727_ VGND VGND VPWR VPWR _2728_ sky130_fd_sc_hd__and2_1
XTAP_TAPCELL_ROW_1_212 VGND VPWR sky130_fd_sc_hd__tapvpwrvgnd_1
X_3178_ _2680_ VGND VGND VPWR VPWR _0032_ sky130_fd_sc_hd__clkbuf_1
Xrebuffer10 _1180_ VGND VGND VPWR VPWR net75 sky130_fd_sc_hd__dlygate4sd1_1
XFILLER_0_83_94 VGND VGND VPWR VPWR sky130_fd_sc_hd__decap_3
XFILLER_0_83_72 VGND VGND VPWR VPWR sky130_fd_sc_hd__decap_6
Xrebuffer43 _2037_ VGND VGND VPWR VPWR net108 sky130_fd_sc_hd__dlymetal6s4s_1
Xrebuffer32 _0845_ VGND VGND VPWR VPWR net97 sky130_fd_sc_hd__buf_6
XFILLER_0_49_500 VGND VGND VPWR VPWR sky130_fd_sc_hd__decap_4
Xrebuffer65 net129 VGND VGND VPWR VPWR net130 sky130_fd_sc_hd__dlygate4sd1_1
XFILLER_0_49_533 VPWR VGND VPWR VGND sky130_ef_sc_hd__decap_12
X_5819_ u_interface.core_attn_out\[10\] u_interface.u_compute_core.u_av.product_reg\[13\]
+ VGND VGND VPWR VPWR _2367_ sky130_fd_sc_hd__nand2_1
XTAP_TAPCELL_ROW_52_689 VGND VPWR sky130_fd_sc_hd__tapvpwrvgnd_1
XFILLER_0_44_260 VPWR VGND VPWR VGND sky130_ef_sc_hd__decap_12
XFILLER_0_32_477 VGND VGND VPWR VPWR sky130_fd_sc_hd__decap_4
XFILLER_0_86_127 VGND VGND VPWR VPWR sky130_fd_sc_hd__decap_8
XTAP_TAPCELL_ROW_43_612 VGND VPWR sky130_fd_sc_hd__tapvpwrvgnd_1
XFILLER_0_82_322 VPWR VGND VPWR VGND sky130_ef_sc_hd__decap_12
XFILLER_0_27_249 VGND VGND VPWR VPWR sky130_fd_sc_hd__fill_1
XFILLER_0_82_388 VGND VGND VPWR VPWR sky130_fd_sc_hd__decap_6
XFILLER_0_23_433 VGND VGND VPWR VPWR sky130_fd_sc_hd__fill_2
XFILLER_0_35_271 VGND VGND VPWR VPWR sky130_fd_sc_hd__fill_1
XFILLER_0_35_293 VGND VGND VPWR VPWR sky130_fd_sc_hd__decap_8
XFILLER_0_50_263 VGND VGND VPWR VPWR sky130_fd_sc_hd__decap_4
XTAP_TAPCELL_ROW_91_1062 VGND VPWR sky130_fd_sc_hd__tapvpwrvgnd_1
X_4150_ _0683_ _0650_ VGND VGND VPWR VPWR _0731_ sky130_fd_sc_hd__and2b_1
X_3101_ _2609_ _2624_ VGND VGND VPWR VPWR _0011_ sky130_fd_sc_hd__nor2_1
XFILLER_0_37_43 VGND VGND VPWR VPWR sky130_fd_sc_hd__fill_1
X_4081_ _0624_ _0627_ _0626_ VGND VGND VPWR VPWR _0663_ sky130_fd_sc_hd__o21ba_1
XFILLER_0_37_98 VPWR VGND VPWR VGND sky130_ef_sc_hd__decap_12
X_4983_ _1550_ _1549_ _0982_ VGND VGND VPWR VPWR _1552_ sky130_fd_sc_hd__o21ai_1
X_3934_ u_interface.u_compute_core.relu_valid VGND VGND VPWR VPWR _0521_ sky130_fd_sc_hd__buf_2
XFILLER_0_58_363 VGND VGND VPWR VPWR sky130_fd_sc_hd__fill_1
X_3865_ _0398_ _0429_ VGND VGND VPWR VPWR _0456_ sky130_fd_sc_hd__or2b_1
X_5604_ _2076_ _2091_ VGND VGND VPWR VPWR _2165_ sky130_fd_sc_hd__and2b_1
X_3796_ _0388_ _0389_ VGND VGND VPWR VPWR _0390_ sky130_fd_sc_hd__or2_1
X_5535_ _1994_ _2005_ VGND VGND VPWR VPWR _2097_ sky130_fd_sc_hd__nand2_1
XFILLER_0_75_3 VPWR VGND VPWR VGND sky130_ef_sc_hd__decap_12
XFILLER_0_14_477 VGND VGND VPWR VPWR sky130_fd_sc_hd__fill_2
XFILLER_0_41_252 VGND VGND VPWR VPWR sky130_fd_sc_hd__decap_4
XFILLER_0_41_263 VGND VGND VPWR VPWR sky130_fd_sc_hd__decap_6
X_5466_ _2025_ _2028_ VGND VGND VPWR VPWR _2029_ sky130_fd_sc_hd__xnor2_1
X_4417_ u_interface.u_compute_core.relu_data\[10\] _0586_ VGND VGND VPWR VPWR _0993_
+ sky130_fd_sc_hd__nand2_1
XFILLER_0_1_393 VPWR VGND VPWR VGND sky130_ef_sc_hd__decap_12
X_5397_ u_interface.u_compute_core.relu_data\[27\] _0493_ _1871_ VGND VGND VPWR VPWR
+ _1960_ sky130_fd_sc_hd__and3_1
X_4348_ _0921_ _0924_ VGND VGND VPWR VPWR _0925_ sky130_fd_sc_hd__xnor2_1
X_4279_ _0612_ _0558_ VGND VGND VPWR VPWR _0857_ sky130_fd_sc_hd__nand2_1
X_6018_ net59 u_interface.core_attn_out\[9\] _2521_ VGND VGND VPWR VPWR _2533_ sky130_fd_sc_hd__mux2_1
XTAP_TAPCELL_ROW_57_737 VGND VPWR sky130_fd_sc_hd__tapvpwrvgnd_1
XFILLER_0_37_503 VGND VGND VPWR VPWR sky130_fd_sc_hd__fill_1
XTAP_TAPCELL_ROW_12_317 VGND VPWR sky130_fd_sc_hd__tapvpwrvgnd_1
XFILLER_0_9_460 VPWR VGND VPWR VGND sky130_ef_sc_hd__decap_12
XFILLER_0_20_414 VGND VGND VPWR VPWR sky130_fd_sc_hd__decap_3
XTAP_TAPCELL_ROW_20_394 VGND VPWR sky130_fd_sc_hd__tapvpwrvgnd_1
XFILLER_0_90_29 VPWR VGND VPWR VGND sky130_ef_sc_hd__decap_12
XFILLER_0_87_447 VGND VGND VPWR VPWR sky130_fd_sc_hd__fill_1
XTAP_TAPCELL_ROW_28_461 VGND VPWR sky130_fd_sc_hd__tapvpwrvgnd_1
XFILLER_0_67_160 VGND VGND VPWR VPWR sky130_fd_sc_hd__decap_4
XFILLER_0_55_322 VPWR VGND VPWR VGND sky130_ef_sc_hd__decap_12
XFILLER_0_70_303 VGND VGND VPWR VPWR sky130_fd_sc_hd__decap_4
X_3650_ _0209_ _0222_ VGND VGND VPWR VPWR _0247_ sky130_fd_sc_hd__or2b_1
X_3581_ _3018_ VGND VGND VPWR VPWR _3019_ sky130_fd_sc_hd__inv_2
Xrebuffer1 net94 VGND VGND VPWR VPWR net66 sky130_fd_sc_hd__dlygate4sd1_1
X_5320_ _1795_ _1796_ VGND VGND VPWR VPWR _1884_ sky130_fd_sc_hd__and2_1
XFILLER_0_23_274 VGND VGND VPWR VPWR sky130_fd_sc_hd__decap_6
X_5251_ _1813_ _1814_ _1805_ VGND VGND VPWR VPWR _1816_ sky130_fd_sc_hd__a21o_1
X_4202_ _0781_ VGND VGND VPWR VPWR _0782_ sky130_fd_sc_hd__clkbuf_2
X_5182_ _1661_ _1663_ VGND VGND VPWR VPWR _1748_ sky130_fd_sc_hd__or2_1
X_4133_ net82 u_interface.u_compute_core.relu_data\[5\] net20 _0586_ VGND VGND VPWR
+ VPWR _0714_ sky130_fd_sc_hd__nand4_2
XFILLER_0_3_55 VGND VGND VPWR VPWR sky130_fd_sc_hd__fill_1
X_4064_ _0645_ _0646_ _0521_ VGND VGND VPWR VPWR _0647_ sky130_fd_sc_hd__o21ai_1
XFILLER_0_64_41 VGND VGND VPWR VPWR sky130_fd_sc_hd__decap_3
XFILLER_0_64_96 VGND VGND VPWR VPWR sky130_fd_sc_hd__decap_8
XFILLER_0_64_85 VGND VGND VPWR VPWR sky130_fd_sc_hd__fill_2
XFILLER_0_78_469 VGND VGND VPWR VPWR sky130_fd_sc_hd__fill_1
X_4966_ _1519_ _1533_ _1534_ VGND VGND VPWR VPWR _1535_ sky130_fd_sc_hd__nand3_1
XFILLER_0_46_333 VPWR VGND VPWR VGND sky130_ef_sc_hd__decap_12
XTAP_TAPCELL_ROW_62_784 VGND VPWR sky130_fd_sc_hd__tapvpwrvgnd_1
X_4897_ net74 _1465_ _1425_ VGND VGND VPWR VPWR _1467_ sky130_fd_sc_hd__o21ai_1
XFILLER_0_34_517 VPWR VGND VPWR VGND sky130_ef_sc_hd__decap_12
XFILLER_0_46_377 VPWR VGND VPWR VGND sky130_ef_sc_hd__decap_12
X_3917_ _0503_ VGND VGND VPWR VPWR _0504_ sky130_fd_sc_hd__clkbuf_4
X_3848_ _0414_ _0439_ VGND VGND VPWR VPWR _0440_ sky130_fd_sc_hd__xnor2_1
XFILLER_0_61_314 VGND VGND VPWR VPWR sky130_fd_sc_hd__decap_8
XFILLER_0_14_230 VPWR VGND VPWR VGND sky130_ef_sc_hd__decap_12
X_3779_ _0368_ _0371_ VGND VGND VPWR VPWR _0373_ sky130_fd_sc_hd__nand2_1
XFILLER_0_61_347 VPWR VGND VPWR VGND sky130_ef_sc_hd__decap_12
XFILLER_0_89_93 VPWR VGND VPWR VGND sky130_ef_sc_hd__decap_12
X_5518_ _1975_ _1988_ VGND VGND VPWR VPWR _2080_ sky130_fd_sc_hd__or2_1
XFILLER_0_14_285 VGND VGND VPWR VPWR sky130_fd_sc_hd__decap_3
X_5449_ net129 _2011_ VGND VGND VPWR VPWR _2012_ sky130_fd_sc_hd__xnor2_1
XFILLER_0_92_461 VPWR VGND VPWR VGND sky130_ef_sc_hd__decap_12
XFILLER_0_64_141 VGND VGND VPWR VPWR sky130_fd_sc_hd__fill_1
XFILLER_0_52_303 VGND VGND VPWR VPWR sky130_fd_sc_hd__decap_4
XFILLER_0_52_347 VPWR VGND VPWR VGND sky130_ef_sc_hd__decap_12
XFILLER_0_20_233 VGND VGND VPWR VPWR sky130_fd_sc_hd__decap_4
XFILLER_0_18_56 VPWR VGND VPWR VGND sky130_ef_sc_hd__decap_12
X_4820_ _1317_ _1390_ VGND VGND VPWR VPWR _1391_ sky130_fd_sc_hd__xnor2_1
X_4751_ _1205_ _1207_ _1321_ _1322_ VGND VGND VPWR VPWR _1323_ sky130_fd_sc_hd__a211oi_1
XFILLER_0_7_249 VPWR VGND VPWR VGND sky130_ef_sc_hd__decap_12
X_3702_ _0296_ _0290_ VGND VGND VPWR VPWR _0298_ sky130_fd_sc_hd__or2b_1
X_4682_ _1252_ _1253_ _1254_ VGND VGND VPWR VPWR _1255_ sky130_fd_sc_hd__a21oi_1
XFILLER_0_70_133 VGND VGND VPWR VPWR sky130_fd_sc_hd__decap_6
X_3633_ _0224_ _0229_ VGND VGND VPWR VPWR _0231_ sky130_fd_sc_hd__nor2_1
X_3564_ _2981_ _3002_ VGND VGND VPWR VPWR _3003_ sky130_fd_sc_hd__nor2_1
XFILLER_0_51_391 VGND VGND VPWR VPWR sky130_fd_sc_hd__fill_1
X_5303_ _1852_ _1853_ _1855_ VGND VGND VPWR VPWR _1867_ sky130_fd_sc_hd__or3_2
X_3495_ _2928_ _2936_ _2932_ VGND VGND VPWR VPWR _2937_ sky130_fd_sc_hd__a21o_1
X_6283_ clknet_leaf_12_clk _0196_ VGND VGND VPWR VPWR net44 sky130_fd_sc_hd__dfxtp_1
XFILLER_0_59_74 VGND VGND VPWR VPWR sky130_fd_sc_hd__fill_2
X_5234_ _1735_ _1736_ VGND VGND VPWR VPWR _1799_ sky130_fd_sc_hd__nand2_1
X_5165_ _0633_ VGND VGND VPWR VPWR _1731_ sky130_fd_sc_hd__inv_2
XFILLER_0_38_3 VPWR VGND VPWR VGND sky130_ef_sc_hd__decap_12
X_4116_ u_interface.u_compute_core.relu_data\[9\] net3 net14 _2610_ VGND VGND VPWR
+ VPWR _0697_ sky130_fd_sc_hd__a22o_1
X_5096_ _1581_ _1586_ _1662_ VGND VGND VPWR VPWR _1663_ sky130_fd_sc_hd__o21a_1
XTAP_TAPCELL_ROW_67_832 VGND VPWR sky130_fd_sc_hd__tapvpwrvgnd_1
Xclone6 net121 VGND VGND VPWR VPWR net71 sky130_fd_sc_hd__buf_2
XTAP_TAPCELL_ROW_39_567 VGND VPWR sky130_fd_sc_hd__tapvpwrvgnd_1
X_4047_ _0588_ _0590_ _0585_ VGND VGND VPWR VPWR _0630_ sky130_fd_sc_hd__o21ba_1
X_5998_ _2516_ _2519_ VGND VGND VPWR VPWR _2520_ sky130_fd_sc_hd__and2_1
XFILLER_0_59_480 VGND VGND VPWR VPWR sky130_fd_sc_hd__decap_8
X_4949_ _1456_ _1458_ VGND VGND VPWR VPWR _1518_ sky130_fd_sc_hd__nand2_1
XFILLER_0_74_450 VGND VGND VPWR VPWR sky130_fd_sc_hd__fill_1
XTAP_TAPCELL_ROW_22_412 VGND VPWR sky130_fd_sc_hd__tapvpwrvgnd_1
XFILLER_0_46_141 VGND VGND VPWR VPWR sky130_fd_sc_hd__decap_3
XFILLER_0_74_472 VGND VGND VPWR VPWR sky130_fd_sc_hd__decap_4
XFILLER_0_34_303 VGND VGND VPWR VPWR sky130_fd_sc_hd__decap_4
XFILLER_0_34_325 VGND VGND VPWR VPWR sky130_fd_sc_hd__fill_2
XFILLER_0_34_369 VGND VGND VPWR VPWR sky130_fd_sc_hd__decap_8
XFILLER_0_57_417 VGND VGND VPWR VPWR sky130_fd_sc_hd__decap_8
XFILLER_0_84_247 VGND VGND VPWR VPWR sky130_fd_sc_hd__decap_4
XFILLER_0_69_299 VPWR VGND VPWR VGND sky130_ef_sc_hd__decap_12
XFILLER_0_65_461 VPWR VGND VPWR VGND sky130_ef_sc_hd__decap_12
XFILLER_0_21_542 VGND VGND VPWR VPWR sky130_fd_sc_hd__fill_1
XFILLER_0_0_469 VGND VGND VPWR VPWR sky130_fd_sc_hd__decap_6
X_3280_ _2753_ VGND VGND VPWR VPWR _2754_ sky130_fd_sc_hd__clkbuf_4
XTAP_TAPCELL_ROW_88_1034 VGND VPWR sky130_fd_sc_hd__tapvpwrvgnd_1
XFILLER_0_88_531 VGND VGND VPWR VPWR sky130_fd_sc_hd__fill_1
X_5921_ u_interface.core_attn_out\[23\] u_interface.u_compute_core.u_av.product_reg\[26\]
+ VGND VGND VPWR VPWR _2456_ sky130_fd_sc_hd__nand2_1
XTAP_TAPCELL_ROW_36_537 VGND VPWR sky130_fd_sc_hd__tapvpwrvgnd_1
X_5852_ _2374_ _2383_ _2382_ _2388_ _2381_ VGND VGND VPWR VPWR _2396_ sky130_fd_sc_hd__o311a_1
X_4803_ _1143_ _1373_ VGND VGND VPWR VPWR _1374_ sky130_fd_sc_hd__xor2_2
XFILLER_0_8_525 VGND VGND VPWR VPWR sky130_fd_sc_hd__decap_6
X_5783_ u_interface.core_attn_out\[5\] u_interface.u_compute_core.u_av.product_reg\[8\]
+ VGND VGND VPWR VPWR _2336_ sky130_fd_sc_hd__nor2_1
XFILLER_0_28_141 VPWR VGND VPWR VGND sky130_ef_sc_hd__decap_12
X_4734_ _1210_ _1305_ VGND VGND VPWR VPWR _1306_ sky130_fd_sc_hd__or2_1
XFILLER_0_43_133 VGND VGND VPWR VPWR sky130_fd_sc_hd__decap_4
X_4665_ _1227_ _1236_ VGND VGND VPWR VPWR _1238_ sky130_fd_sc_hd__nand2_1
XFILLER_0_16_369 VGND VGND VPWR VPWR sky130_fd_sc_hd__fill_1
X_4596_ _1169_ _1137_ _1136_ VGND VGND VPWR VPWR _1170_ sky130_fd_sc_hd__and3_4
X_3616_ _0212_ net15 _2945_ _0210_ VGND VGND VPWR VPWR _0214_ sky130_fd_sc_hd__and4b_1
X_3547_ _2935_ _2949_ _2983_ _2985_ VGND VGND VPWR VPWR _2986_ sky130_fd_sc_hd__o2bb2a_1
XFILLER_0_86_61 VGND VGND VPWR VPWR sky130_fd_sc_hd__decap_3
X_6266_ clknet_leaf_16_clk _0179_ VGND VGND VPWR VPWR net57 sky130_fd_sc_hd__dfxtp_1
X_3478_ net186 net27 _2923_ net61 VGND VGND VPWR VPWR _0089_ sky130_fd_sc_hd__o211a_1
X_6197_ clknet_leaf_18_clk _0110_ VGND VGND VPWR VPWR u_interface.u_compute_core.u_av.product_reg\[4\]
+ sky130_fd_sc_hd__dfxtp_1
X_5217_ _0571_ _1781_ _1782_ _1337_ VGND VGND VPWR VPWR _0130_ sky130_fd_sc_hd__o211a_1
X_5148_ net126 _1690_ VGND VGND VPWR VPWR _1714_ sky130_fd_sc_hd__or2b_1
X_5079_ _1644_ _2655_ _0515_ _0496_ VGND VGND VPWR VPWR _1646_ sky130_fd_sc_hd__and4_1
Xsplit59 u_interface.u_compute_core.relu_data\[15\] VGND VGND VPWR VPWR net124 sky130_fd_sc_hd__buf_1
XFILLER_0_54_409 VGND VGND VPWR VPWR sky130_fd_sc_hd__fill_1
XFILLER_0_47_461 VPWR VGND VPWR VGND sky130_ef_sc_hd__decap_12
XFILLER_0_74_280 VGND VGND VPWR VPWR sky130_fd_sc_hd__decap_3
XFILLER_0_34_111 VGND VGND VPWR VPWR sky130_fd_sc_hd__fill_1
XFILLER_0_34_133 VGND VGND VPWR VPWR sky130_fd_sc_hd__fill_2
XFILLER_0_62_475 VGND VGND VPWR VPWR sky130_fd_sc_hd__fill_1
XFILLER_0_15_391 VGND VGND VPWR VPWR sky130_fd_sc_hd__fill_1
XTAP_TAPCELL_ROW_7_262 VGND VPWR sky130_fd_sc_hd__tapvpwrvgnd_1
XTAP_TAPCELL_ROW_78_938 VGND VPWR sky130_fd_sc_hd__tapvpwrvgnd_1
XFILLER_0_57_225 VGND VGND VPWR VPWR sky130_fd_sc_hd__fill_1
XFILLER_0_57_236 VGND VGND VPWR VPWR sky130_fd_sc_hd__fill_2
XFILLER_0_38_450 VPWR VGND VPWR VGND sky130_ef_sc_hd__decap_12
XFILLER_0_5_517 VPWR VGND VPWR VGND sky130_ef_sc_hd__decap_12
XFILLER_0_53_442 VGND VGND VPWR VPWR sky130_fd_sc_hd__decap_6
XFILLER_0_80_250 VGND VGND VPWR VPWR sky130_fd_sc_hd__fill_2
XFILLER_0_80_283 VGND VGND VPWR VPWR sky130_fd_sc_hd__fill_1
X_4450_ _1023_ _1024_ _1007_ VGND VGND VPWR VPWR _1026_ sky130_fd_sc_hd__a21oi_1
X_3401_ _2753_ _2856_ _2857_ VGND VGND VPWR VPWR _2858_ sky130_fd_sc_hd__or3_1
XFILLER_0_40_158 VGND VGND VPWR VPWR sky130_fd_sc_hd__decap_3
X_4381_ _0884_ _0886_ _0957_ _0956_ VGND VGND VPWR VPWR _0958_ sky130_fd_sc_hd__a211o_1
XFILLER_0_21_372 VGND VGND VPWR VPWR sky130_fd_sc_hd__decap_8
X_3332_ net190 _2756_ _2798_ _2741_ VGND VGND VPWR VPWR _0068_ sky130_fd_sc_hd__a22o_1
X_6120_ clknet_leaf_4_clk _0033_ VGND VGND VPWR VPWR u_interface.u_compute_core.scaled_data\[4\]
+ sky130_fd_sc_hd__dfxtp_1
X_6051_ _2539_ _2555_ VGND VGND VPWR VPWR _2556_ sky130_fd_sc_hd__and2_1
X_3263_ _2737_ _2738_ VGND VGND VPWR VPWR _0059_ sky130_fd_sc_hd__nor2_1
X_5002_ u_interface.u_compute_core.relu_data\[22\] _0493_ VGND VGND VPWR VPWR _1570_
+ sky130_fd_sc_hd__nand2_1
X_3194_ u_interface.u_compute_core.mac_last VGND VGND VPWR VPWR _2691_ sky130_fd_sc_hd__clkbuf_4
XFILLER_0_56_97 VPWR VGND VPWR VGND sky130_ef_sc_hd__decap_12
XTAP_TAPCELL_ROW_49_662 VGND VPWR sky130_fd_sc_hd__tapvpwrvgnd_1
XFILLER_0_76_545 VGND VGND VPWR VPWR sky130_fd_sc_hd__fill_2
XFILLER_0_72_74 VGND VGND VPWR VPWR sky130_fd_sc_hd__decap_4
X_5904_ u_interface.core_attn_out\[21\] u_interface.u_compute_core.u_av.product_reg\[24\]
+ VGND VGND VPWR VPWR _2441_ sky130_fd_sc_hd__or2_1
X_5835_ u_interface.core_attn_out\[12\] u_interface.u_compute_core.u_av.product_reg\[15\]
+ VGND VGND VPWR VPWR _2381_ sky130_fd_sc_hd__nand2_1
XPHY_EDGE_ROW_46_Left_139 VGND VGND VPWR VPWR sky130_fd_sc_hd__decap_3
XFILLER_0_63_217 VGND VGND VPWR VPWR sky130_fd_sc_hd__decap_6
X_5766_ u_interface.core_attn_out\[3\] u_interface.u_compute_core.u_av.product_reg\[6\]
+ VGND VGND VPWR VPWR _2321_ sky130_fd_sc_hd__nand2_1
X_4717_ _1229_ _1234_ VGND VGND VPWR VPWR _1289_ sky130_fd_sc_hd__and2_1
XFILLER_0_44_475 VGND VGND VPWR VPWR sky130_fd_sc_hd__fill_1
X_5697_ _2210_ _2212_ _2255_ VGND VGND VPWR VPWR _2256_ sky130_fd_sc_hd__o21a_1
X_4648_ _2625_ _2622_ _0625_ _0819_ VGND VGND VPWR VPWR _1221_ sky130_fd_sc_hd__nand4_1
XFILLER_0_16_188 VGND VGND VPWR VPWR sky130_fd_sc_hd__decap_8
XFILLER_0_31_125 VPWR VGND VPWR VGND sky130_ef_sc_hd__decap_12
XFILLER_0_31_169 VPWR VGND VPWR VGND sky130_ef_sc_hd__decap_12
X_4579_ _1152_ net120 VGND VGND VPWR VPWR _1153_ sky130_fd_sc_hd__xnor2_2
XPHY_EDGE_ROW_55_Left_148 VGND VGND VPWR VPWR sky130_fd_sc_hd__decap_3
X_6249_ clknet_leaf_12_clk _0162_ VGND VGND VPWR VPWR u_interface.core_attn_out\[24\]
+ sky130_fd_sc_hd__dfxtp_1
XTAP_TAPCELL_ROW_75_908 VGND VPWR sky130_fd_sc_hd__tapvpwrvgnd_1
XFILLER_0_86_309 VPWR VGND VPWR VGND sky130_ef_sc_hd__decap_12
XFILLER_0_67_501 VGND VGND VPWR VPWR sky130_fd_sc_hd__decap_3
XTAP_TAPCELL_ROW_83_985 VGND VPWR sky130_fd_sc_hd__tapvpwrvgnd_1
XPHY_EDGE_ROW_64_Left_157 VGND VGND VPWR VPWR sky130_fd_sc_hd__decap_3
XFILLER_0_39_225 VPWR VGND VPWR VGND sky130_ef_sc_hd__decap_12
XFILLER_0_67_545 VGND VGND VPWR VPWR sky130_fd_sc_hd__fill_2
XFILLER_0_54_217 VGND VGND VPWR VPWR sky130_fd_sc_hd__decap_8
XFILLER_0_35_431 VGND VGND VPWR VPWR sky130_fd_sc_hd__fill_2
XFILLER_0_62_250 VGND VGND VPWR VPWR sky130_fd_sc_hd__fill_2
XFILLER_0_62_272 VPWR VGND VPWR VGND sky130_ef_sc_hd__decap_12
XFILLER_0_22_158 VGND VGND VPWR VPWR sky130_fd_sc_hd__fill_1
XFILLER_0_77_19 VPWR VGND VPWR VGND sky130_ef_sc_hd__decap_12
XPHY_EDGE_ROW_73_Left_166 VGND VGND VPWR VPWR sky130_fd_sc_hd__decap_3
XFILLER_0_10_309 VGND VGND VPWR VPWR sky130_fd_sc_hd__fill_1
XFILLER_0_50_489 VGND VGND VPWR VPWR sky130_fd_sc_hd__decap_4
XFILLER_0_89_147 VGND VGND VPWR VPWR sky130_fd_sc_hd__fill_2
XTAP_TAPCELL_ROW_85_1004 VGND VPWR sky130_fd_sc_hd__tapvpwrvgnd_1
XFILLER_0_26_56 VPWR VGND VPWR VGND sky130_ef_sc_hd__decap_12
Xhold90 u_interface.u_compute_core.u_av.product_reg\[5\] VGND VGND VPWR VPWR net155
+ sky130_fd_sc_hd__dlygate4sd3_1
XFILLER_0_89_169 VGND VGND VPWR VPWR sky130_fd_sc_hd__fill_1
XPHY_EDGE_ROW_82_Left_175 VGND VGND VPWR VPWR sky130_fd_sc_hd__decap_3
XFILLER_0_26_89 VGND VGND VPWR VPWR sky130_fd_sc_hd__fill_1
XTAP_TAPCELL_ROW_46_632 VGND VPWR sky130_fd_sc_hd__tapvpwrvgnd_1
X_3950_ _0535_ VGND VGND VPWR VPWR _0536_ sky130_fd_sc_hd__clkbuf_4
XTAP_TAPCELL_ROW_18_367 VGND VPWR sky130_fd_sc_hd__tapvpwrvgnd_1
XFILLER_0_42_11 VGND VGND VPWR VPWR sky130_fd_sc_hd__decap_3
XFILLER_0_58_512 VGND VGND VPWR VPWR sky130_fd_sc_hd__decap_8
XFILLER_0_9_108 VGND VGND VPWR VPWR sky130_fd_sc_hd__decap_4
XFILLER_0_58_545 VGND VGND VPWR VPWR sky130_fd_sc_hd__fill_2
XFILLER_0_85_375 VGND VGND VPWR VPWR sky130_fd_sc_hd__fill_2
X_3881_ _0441_ _0445_ _0470_ VGND VGND VPWR VPWR _0472_ sky130_fd_sc_hd__or3_1
XFILLER_0_45_217 VGND VGND VPWR VPWR sky130_fd_sc_hd__decap_6
X_5620_ _2179_ _2180_ VGND VGND VPWR VPWR _2181_ sky130_fd_sc_hd__xnor2_1
XFILLER_0_26_464 VGND VGND VPWR VPWR sky130_fd_sc_hd__decap_8
XFILLER_0_26_475 VGND VGND VPWR VPWR sky130_fd_sc_hd__fill_1
XFILLER_0_60_209 VGND VGND VPWR VPWR sky130_fd_sc_hd__decap_6
X_5551_ _2022_ _2023_ VGND VGND VPWR VPWR _2113_ sky130_fd_sc_hd__nor2_1
X_4502_ _1000_ _0992_ _0999_ VGND VGND VPWR VPWR _1077_ sky130_fd_sc_hd__a21o_1
XFILLER_0_53_272 VGND VGND VPWR VPWR sky130_fd_sc_hd__fill_1
XPHY_EDGE_ROW_91_Left_184 VGND VGND VPWR VPWR sky130_fd_sc_hd__decap_3
XFILLER_0_77_7 VPWR VGND VPWR VGND sky130_ef_sc_hd__decap_12
X_5482_ u_interface.u_compute_core.relu_data\[25\] _0491_ VGND VGND VPWR VPWR _2044_
+ sky130_fd_sc_hd__nand2_1
X_4433_ _0925_ _0934_ _0933_ VGND VGND VPWR VPWR _1009_ sky130_fd_sc_hd__a21o_1
XFILLER_0_6_11 VGND VGND VPWR VPWR sky130_fd_sc_hd__fill_2
X_4364_ _0880_ _0882_ VGND VGND VPWR VPWR _0941_ sky130_fd_sc_hd__nand2_1
X_6103_ clknet_leaf_7_clk _0016_ VGND VGND VPWR VPWR u_interface.u_compute_core.relu_data\[16\]
+ sky130_fd_sc_hd__dfxtp_2
X_3315_ _2769_ _2777_ _2775_ _2776_ VGND VGND VPWR VPWR _2784_ sky130_fd_sc_hd__a31o_1
X_4295_ _0824_ _0826_ VGND VGND VPWR VPWR _0873_ sky130_fd_sc_hd__nand2_1
X_6034_ u_interface.core_valid_out VGND VGND VPWR VPWR _2544_ sky130_fd_sc_hd__clkbuf_4
X_3246_ u_interface.u_compute_core.scaled_data\[25\] u_interface.u_compute_core.mac_accum\[28\]
+ _2713_ VGND VGND VPWR VPWR _2727_ sky130_fd_sc_hd__mux2_1
Xrebuffer11 _1468_ VGND VGND VPWR VPWR net76 sky130_fd_sc_hd__clkbuf_1
XTAP_TAPCELL_ROW_1_213 VGND VPWR sky130_fd_sc_hd__tapvpwrvgnd_1
XFILLER_0_20_3 VPWR VGND VPWR VGND sky130_ef_sc_hd__decap_12
X_3177_ _2672_ _2679_ VGND VGND VPWR VPWR _2680_ sky130_fd_sc_hd__and2_1
Xrebuffer22 _1394_ VGND VGND VPWR VPWR net87 sky130_fd_sc_hd__dlygate4sd1_1
Xrebuffer33 _0851_ VGND VGND VPWR VPWR net98 sky130_fd_sc_hd__dlygate4sd1_1
Xrebuffer44 _1555_ VGND VGND VPWR VPWR net109 sky130_fd_sc_hd__dlygate4sd1_1
Xrebuffer66 net126 VGND VGND VPWR VPWR net131 sky130_fd_sc_hd__dlygate4sd1_1
XFILLER_0_49_545 VGND VGND VPWR VPWR sky130_fd_sc_hd__fill_2
XTAP_TAPCELL_ROW_80_955 VGND VPWR sky130_fd_sc_hd__tapvpwrvgnd_1
XFILLER_0_91_345 VGND VGND VPWR VPWR sky130_fd_sc_hd__fill_1
X_5818_ u_interface.core_attn_out\[10\] u_interface.u_compute_core.u_av.product_reg\[13\]
+ VGND VGND VPWR VPWR _2366_ sky130_fd_sc_hd__or2_1
XFILLER_0_8_141 VGND VGND VPWR VPWR sky130_fd_sc_hd__decap_4
XFILLER_0_91_389 VGND VGND VPWR VPWR sky130_fd_sc_hd__decap_3
X_5749_ u_interface.core_attn_out\[0\] u_interface.u_compute_core.u_av.product_reg\[3\]
+ _2305_ VGND VGND VPWR VPWR _2306_ sky130_fd_sc_hd__and3_1
XFILLER_0_32_401 VGND VGND VPWR VPWR sky130_fd_sc_hd__decap_3
XFILLER_0_44_272 VGND VGND VPWR VPWR sky130_fd_sc_hd__decap_3
XFILLER_0_27_217 VGND VGND VPWR VPWR sky130_fd_sc_hd__decap_6
XFILLER_0_82_334 VGND VGND VPWR VPWR sky130_fd_sc_hd__decap_6
XFILLER_0_23_401 VPWR VGND VPWR VGND sky130_ef_sc_hd__decap_12
XFILLER_0_88_29 VPWR VGND VPWR VGND sky130_ef_sc_hd__decap_12
XFILLER_0_23_456 VGND VGND VPWR VPWR sky130_fd_sc_hd__fill_1
XFILLER_0_10_139 VGND VGND VPWR VPWR sky130_fd_sc_hd__fill_1
XTAP_TAPCELL_ROW_91_1063 VGND VPWR sky130_fd_sc_hd__tapvpwrvgnd_1
X_3100_ u_interface.u_compute_core.scaled_data\[11\] _2618_ _2623_ _2613_ VGND VGND
+ VPWR VPWR _2624_ sky130_fd_sc_hd__o2bb2a_1
X_4080_ _0657_ _0661_ VGND VGND VPWR VPWR _0662_ sky130_fd_sc_hd__xnor2_1
XFILLER_0_77_139 VPWR VGND VPWR VGND sky130_ef_sc_hd__decap_12
X_4982_ _0918_ _1549_ _1550_ VGND VGND VPWR VPWR _1551_ sky130_fd_sc_hd__or3_4
XFILLER_0_92_109 VGND VGND VPWR VPWR sky130_fd_sc_hd__decap_3
X_3933_ _0487_ _0517_ _0518_ _0514_ VGND VGND VPWR VPWR _0520_ sky130_fd_sc_hd__a31oi_1
X_3864_ _0414_ _0453_ _0454_ VGND VGND VPWR VPWR _0455_ sky130_fd_sc_hd__a21oi_1
XFILLER_0_18_228 VGND VGND VPWR VPWR sky130_fd_sc_hd__fill_1
XFILLER_0_73_367 VGND VGND VPWR VPWR sky130_fd_sc_hd__fill_1
XFILLER_0_5_111 VGND VGND VPWR VPWR sky130_fd_sc_hd__fill_1
X_5603_ _2155_ _2163_ VGND VGND VPWR VPWR _2164_ sky130_fd_sc_hd__xor2_1
X_3795_ _0311_ _0353_ _0351_ VGND VGND VPWR VPWR _0389_ sky130_fd_sc_hd__a21oi_1
XFILLER_0_26_250 VGND VGND VPWR VPWR sky130_fd_sc_hd__fill_2
X_5534_ _1995_ _2004_ VGND VGND VPWR VPWR _2096_ sky130_fd_sc_hd__or2_1
XFILLER_0_26_294 VPWR VGND VPWR VGND sky130_ef_sc_hd__decap_12
X_5465_ _2026_ _2027_ VGND VGND VPWR VPWR _2028_ sky130_fd_sc_hd__nand2_1
X_4416_ _0988_ _0991_ VGND VGND VPWR VPWR _0992_ sky130_fd_sc_hd__xnor2_1
XFILLER_0_68_3 VPWR VGND VPWR VGND sky130_ef_sc_hd__decap_12
XFILLER_0_1_361 VPWR VGND VPWR VGND sky130_ef_sc_hd__decap_12
X_5396_ u_interface.u_compute_core.relu_data\[27\] _0494_ _1871_ VGND VGND VPWR VPWR
+ _1959_ sky130_fd_sc_hd__a21oi_1
X_4347_ _0922_ _0923_ VGND VGND VPWR VPWR _0924_ sky130_fd_sc_hd__and2b_1
X_4278_ _0808_ _0834_ _0836_ VGND VGND VPWR VPWR _0856_ sky130_fd_sc_hd__nand3_1
X_6017_ _2532_ VGND VGND VPWR VPWR _0180_ sky130_fd_sc_hd__clkbuf_1
X_3229_ _2715_ VGND VGND VPWR VPWR _0048_ sky130_fd_sc_hd__clkbuf_1
XTAP_TAPCELL_ROW_57_738 VGND VPWR sky130_fd_sc_hd__tapvpwrvgnd_1
XFILLER_0_68_139 VGND VGND VPWR VPWR sky130_fd_sc_hd__fill_1
XFILLER_0_76_172 VPWR VGND VPWR VGND sky130_ef_sc_hd__decap_12
XTAP_TAPCELL_ROW_12_318 VGND VPWR sky130_fd_sc_hd__tapvpwrvgnd_1
XFILLER_0_91_131 VGND VGND VPWR VPWR sky130_fd_sc_hd__decap_3
XFILLER_0_9_472 VPWR VGND VPWR VGND sky130_ef_sc_hd__decap_12
XTAP_TAPCELL_ROW_28_462 VGND VPWR sky130_fd_sc_hd__tapvpwrvgnd_1
XFILLER_0_23_57 VGND VGND VPWR VPWR sky130_fd_sc_hd__decap_8
XFILLER_0_55_334 VGND VGND VPWR VPWR sky130_fd_sc_hd__fill_2
XFILLER_0_82_153 VPWR VGND VPWR VGND sky130_ef_sc_hd__decap_12
XFILLER_0_55_367 VGND VGND VPWR VPWR sky130_fd_sc_hd__fill_2
XFILLER_0_82_197 VGND VGND VPWR VPWR sky130_fd_sc_hd__decap_8
XFILLER_0_2_103 VGND VGND VPWR VPWR sky130_fd_sc_hd__fill_1
X_3580_ net5 net13 _2984_ VGND VGND VPWR VPWR _3018_ sky130_fd_sc_hd__and3_1
Xrebuffer2 _1701_ VGND VGND VPWR VPWR net67 sky130_fd_sc_hd__dlygate4sd1_1
XFILLER_0_23_264 VGND VGND VPWR VPWR sky130_fd_sc_hd__fill_1
X_5250_ _1805_ _1813_ _1814_ VGND VGND VPWR VPWR _1815_ sky130_fd_sc_hd__nand3_1
X_4201_ _0737_ _0779_ _0780_ VGND VGND VPWR VPWR _0781_ sky130_fd_sc_hd__and3b_1
XFILLER_0_48_43 VPWR VGND VPWR VGND sky130_ef_sc_hd__decap_12
X_5181_ _1676_ _1678_ VGND VGND VPWR VPWR _1747_ sky130_fd_sc_hd__nand2_1
X_4132_ u_interface.u_compute_core.relu_data\[4\] _0556_ VGND VGND VPWR VPWR _0713_
+ sky130_fd_sc_hd__nand2_1
X_4063_ _0609_ _0606_ _0644_ VGND VGND VPWR VPWR _0646_ sky130_fd_sc_hd__and3_1
XTAP_TAPCELL_ROW_54_708 VGND VPWR sky130_fd_sc_hd__tapvpwrvgnd_1
X_4965_ _1531_ _1532_ _1445_ VGND VGND VPWR VPWR _1534_ sky130_fd_sc_hd__a21o_1
XFILLER_0_80_41 VGND VGND VPWR VPWR sky130_fd_sc_hd__decap_4
XFILLER_0_86_470 VGND VGND VPWR VPWR sky130_fd_sc_hd__fill_1
X_3916_ net14 VGND VGND VPWR VPWR _0503_ sky130_fd_sc_hd__buf_2
XFILLER_0_73_120 VPWR VGND VPWR VGND sky130_ef_sc_hd__decap_12
XTAP_TAPCELL_ROW_62_785 VGND VPWR sky130_fd_sc_hd__tapvpwrvgnd_1
X_4896_ _1425_ _1465_ _1464_ VGND VGND VPWR VPWR _1466_ sky130_fd_sc_hd__or3_4
XFILLER_0_46_345 VPWR VGND VPWR VGND sky130_ef_sc_hd__decap_12
X_3847_ _0436_ _0438_ VGND VGND VPWR VPWR _0439_ sky130_fd_sc_hd__xor2_1
XFILLER_0_34_529 VGND VGND VPWR VPWR sky130_fd_sc_hd__decap_3
XFILLER_0_46_389 VPWR VGND VPWR VGND sky130_ef_sc_hd__decap_12
X_3778_ _0368_ _0371_ VGND VGND VPWR VPWR _0372_ sky130_fd_sc_hd__or2_1
XFILLER_0_6_475 VGND VGND VPWR VPWR sky130_fd_sc_hd__fill_1
XFILLER_0_61_359 VPWR VGND VPWR VGND sky130_ef_sc_hd__decap_12
X_5517_ _1996_ _2003_ _2078_ VGND VGND VPWR VPWR _2079_ sky130_fd_sc_hd__o21ai_2
XFILLER_0_14_253 VPWR VGND VPWR VGND sky130_ef_sc_hd__decap_12
XFILLER_0_14_242 VGND VGND VPWR VPWR sky130_fd_sc_hd__decap_8
X_5448_ _1920_ _1922_ VGND VGND VPWR VPWR _2011_ sky130_fd_sc_hd__nor2_1
X_5379_ _1940_ _1942_ VGND VGND VPWR VPWR _1943_ sky130_fd_sc_hd__xnor2_2
XPHY_EDGE_ROW_29_Right_29 VGND VGND VPWR VPWR sky130_fd_sc_hd__decap_3
XFILLER_0_84_407 VGND VGND VPWR VPWR sky130_fd_sc_hd__decap_3
XFILLER_0_64_131 VGND VGND VPWR VPWR sky130_fd_sc_hd__decap_4
XFILLER_0_92_473 VGND VGND VPWR VPWR sky130_fd_sc_hd__decap_3
XFILLER_0_9_291 VGND VGND VPWR VPWR sky130_fd_sc_hd__decap_3
XPHY_EDGE_ROW_38_Right_38 VGND VGND VPWR VPWR sky130_fd_sc_hd__decap_3
XFILLER_0_52_359 VGND VGND VPWR VPWR sky130_fd_sc_hd__decap_4
XFILLER_0_20_278 VGND VGND VPWR VPWR sky130_fd_sc_hd__fill_2
XFILLER_0_18_68 VGND VGND VPWR VPWR sky130_fd_sc_hd__decap_3
XPHY_EDGE_ROW_47_Right_47 VGND VGND VPWR VPWR sky130_fd_sc_hd__decap_3
XFILLER_0_18_79 VGND VGND VPWR VPWR sky130_fd_sc_hd__decap_4
XFILLER_0_87_223 VGND VGND VPWR VPWR sky130_fd_sc_hd__fill_1
XFILLER_0_34_89 VGND VGND VPWR VPWR sky130_fd_sc_hd__fill_1
XFILLER_0_87_289 VGND VGND VPWR VPWR sky130_fd_sc_hd__fill_2
XFILLER_0_83_440 VGND VGND VPWR VPWR sky130_fd_sc_hd__decap_8
X_4750_ _1319_ _1320_ _1262_ net72 VGND VGND VPWR VPWR _1322_ sky130_fd_sc_hd__o211a_1
XPHY_EDGE_ROW_56_Right_56 VGND VGND VPWR VPWR sky130_fd_sc_hd__decap_3
XFILLER_0_83_462 VGND VGND VPWR VPWR sky130_fd_sc_hd__decap_8
X_3701_ _0290_ _0296_ VGND VGND VPWR VPWR _0297_ sky130_fd_sc_hd__or2b_1
X_4681_ _0918_ net100 _1176_ VGND VGND VPWR VPWR _1254_ sky130_fd_sc_hd__o21bai_1
XFILLER_0_70_145 VGND VGND VPWR VPWR sky130_fd_sc_hd__fill_1
X_3632_ _0224_ _0229_ VGND VGND VPWR VPWR _0230_ sky130_fd_sc_hd__and2_1
XFILLER_0_11_201 VGND VGND VPWR VPWR sky130_fd_sc_hd__decap_3
X_3563_ _3000_ _3001_ VGND VGND VPWR VPWR _3002_ sky130_fd_sc_hd__or2_1
X_5302_ _0571_ _1865_ _1866_ _1337_ VGND VGND VPWR VPWR _0131_ sky130_fd_sc_hd__o211a_1
X_3494_ net12 VGND VGND VPWR VPWR _2936_ sky130_fd_sc_hd__buf_2
X_6282_ clknet_leaf_12_clk _0195_ VGND VGND VPWR VPWR net43 sky130_fd_sc_hd__dfxtp_1
X_5233_ _1790_ _1797_ VGND VGND VPWR VPWR _1798_ sky130_fd_sc_hd__xnor2_1
XPHY_EDGE_ROW_65_Right_65 VGND VGND VPWR VPWR sky130_fd_sc_hd__decap_3
X_5164_ _1728_ _1729_ VGND VGND VPWR VPWR _1730_ sky130_fd_sc_hd__or2_1
X_4115_ u_interface.u_compute_core.relu_data\[9\] _2610_ net3 net14 VGND VGND VPWR
+ VPWR _0696_ sky130_fd_sc_hd__and4_1
X_5095_ _1579_ _1580_ VGND VGND VPWR VPWR _1662_ sky130_fd_sc_hd__nand2_1
XTAP_TAPCELL_ROW_67_833 VGND VPWR sky130_fd_sc_hd__tapvpwrvgnd_1
XFILLER_0_78_212 VGND VGND VPWR VPWR sky130_fd_sc_hd__decap_8
XTAP_TAPCELL_ROW_39_568 VGND VPWR sky130_fd_sc_hd__tapvpwrvgnd_1
X_4046_ _0624_ _0628_ VGND VGND VPWR VPWR _0629_ sky130_fd_sc_hd__xnor2_1
XFILLER_0_91_51 VGND VGND VPWR VPWR sky130_fd_sc_hd__decap_4
XFILLER_0_38_109 VPWR VGND VPWR VGND sky130_ef_sc_hd__decap_12
XFILLER_0_78_289 VGND VGND VPWR VPWR sky130_fd_sc_hd__decap_4
XPHY_EDGE_ROW_74_Right_74 VGND VGND VPWR VPWR sky130_fd_sc_hd__decap_3
X_5997_ net50 u_interface.core_attn_out\[2\] _2512_ VGND VGND VPWR VPWR _2519_ sky130_fd_sc_hd__mux2_1
XFILLER_0_59_492 VGND VGND VPWR VPWR sky130_fd_sc_hd__decap_4
X_4948_ _1515_ _1516_ VGND VGND VPWR VPWR _1517_ sky130_fd_sc_hd__or2_1
XFILLER_0_19_356 VPWR VGND VPWR VGND sky130_ef_sc_hd__decap_12
XTAP_TAPCELL_ROW_22_413 VGND VPWR sky130_fd_sc_hd__tapvpwrvgnd_1
XFILLER_0_46_120 VGND VGND VPWR VPWR sky130_fd_sc_hd__decap_3
X_4879_ _2634_ _0557_ _0819_ _2631_ VGND VGND VPWR VPWR _1449_ sky130_fd_sc_hd__a22o_1
XFILLER_0_46_197 VGND VGND VPWR VPWR sky130_fd_sc_hd__decap_8
XFILLER_0_42_392 VGND VGND VPWR VPWR sky130_fd_sc_hd__decap_3
XPHY_EDGE_ROW_83_Right_83 VGND VGND VPWR VPWR sky130_fd_sc_hd__decap_3
XPHY_EDGE_ROW_92_Right_92 VGND VGND VPWR VPWR sky130_fd_sc_hd__decap_3
XFILLER_0_65_473 VPWR VGND VPWR VGND sky130_ef_sc_hd__decap_12
XFILLER_0_37_153 VPWR VGND VPWR VGND sky130_ef_sc_hd__decap_12
XFILLER_0_92_281 VPWR VGND VPWR VGND sky130_ef_sc_hd__decap_12
XFILLER_0_25_337 VGND VGND VPWR VPWR sky130_fd_sc_hd__fill_1
XFILLER_0_52_123 VGND VGND VPWR VPWR sky130_fd_sc_hd__decap_4
XFILLER_0_40_318 VGND VGND VPWR VPWR sky130_fd_sc_hd__fill_2
XTAP_TAPCELL_ROW_88_1035 VGND VPWR sky130_fd_sc_hd__tapvpwrvgnd_1
XTAP_TAPCELL_ROW_64_803 VGND VPWR sky130_fd_sc_hd__tapvpwrvgnd_1
X_5920_ u_interface.core_attn_out\[23\] u_interface.u_compute_core.u_av.product_reg\[26\]
+ VGND VGND VPWR VPWR _2455_ sky130_fd_sc_hd__or2_1
XTAP_TAPCELL_ROW_36_538 VGND VPWR sky130_fd_sc_hd__tapvpwrvgnd_1
XFILLER_0_48_407 VGND VGND VPWR VPWR sky130_fd_sc_hd__fill_2
XFILLER_0_0_57 VPWR VGND VPWR VGND sky130_ef_sc_hd__decap_12
X_5851_ _2393_ _2394_ VGND VGND VPWR VPWR _2395_ sky130_fd_sc_hd__nand2_1
X_4802_ _1371_ _1372_ VGND VGND VPWR VPWR _1373_ sky130_fd_sc_hd__xnor2_1
XTAP_TAPCELL_ROW_72_880 VGND VPWR sky130_fd_sc_hd__tapvpwrvgnd_1
X_5782_ _2330_ _2331_ _2328_ VGND VGND VPWR VPWR _2335_ sky130_fd_sc_hd__o21ai_1
XFILLER_0_28_120 VGND VGND VPWR VPWR sky130_fd_sc_hd__fill_1
XFILLER_0_61_54 VGND VGND VPWR VPWR sky130_fd_sc_hd__fill_2
XFILLER_0_90_229 VGND VGND VPWR VPWR sky130_fd_sc_hd__decap_4
XFILLER_0_83_270 VGND VGND VPWR VPWR sky130_fd_sc_hd__decap_6
X_4733_ u_interface.u_compute_core.relu_data\[18\] _0504_ VGND VGND VPWR VPWR _1305_
+ sky130_fd_sc_hd__nand2_1
XFILLER_0_28_153 VGND VGND VPWR VPWR sky130_fd_sc_hd__decap_6
XFILLER_0_61_98 VPWR VGND VPWR VGND sky130_ef_sc_hd__decap_12
XFILLER_0_83_281 VGND VGND VPWR VPWR sky130_fd_sc_hd__fill_1
XFILLER_0_56_495 VGND VGND VPWR VPWR sky130_fd_sc_hd__fill_1
X_4664_ _1236_ _1227_ VGND VGND VPWR VPWR _1237_ sky130_fd_sc_hd__or2_4
X_4595_ _1167_ _1168_ VGND VGND VPWR VPWR _1169_ sky130_fd_sc_hd__and2_4
X_3615_ _2945_ net15 _0211_ _0212_ VGND VGND VPWR VPWR _0213_ sky130_fd_sc_hd__o2bb2a_1
XFILLER_0_43_189 VGND VGND VPWR VPWR sky130_fd_sc_hd__decap_8
X_3546_ _2931_ net5 _2984_ VGND VGND VPWR VPWR _2985_ sky130_fd_sc_hd__and3_1
X_6265_ clknet_leaf_16_clk _0178_ VGND VGND VPWR VPWR net56 sky130_fd_sc_hd__dfxtp_1
XFILLER_0_86_73 VGND VGND VPWR VPWR sky130_fd_sc_hd__fill_1
X_3477_ _2754_ _2922_ VGND VGND VPWR VPWR _2923_ sky130_fd_sc_hd__or2_1
X_5216_ _0915_ net217 VGND VGND VPWR VPWR _1782_ sky130_fd_sc_hd__or2_1
XFILLER_0_50_3 VPWR VGND VPWR VGND sky130_ef_sc_hd__decap_12
X_6196_ clknet_leaf_18_clk _0109_ VGND VGND VPWR VPWR u_interface.u_compute_core.u_av.product_reg\[3\]
+ sky130_fd_sc_hd__dfxtp_1
X_5147_ _1641_ _1696_ _1695_ VGND VGND VPWR VPWR _1713_ sky130_fd_sc_hd__o21ba_1
X_5078_ _1644_ _0515_ _0547_ _2656_ VGND VGND VPWR VPWR _1645_ sky130_fd_sc_hd__o2bb2a_1
XFILLER_0_79_521 VPWR VGND VPWR VGND sky130_ef_sc_hd__decap_12
X_4029_ u_interface.u_compute_core.relu_data\[7\] VGND VGND VPWR VPWR _0612_ sky130_fd_sc_hd__clkbuf_4
XFILLER_0_81_229 VGND VGND VPWR VPWR sky130_fd_sc_hd__fill_1
XFILLER_0_47_473 VPWR VGND VPWR VGND sky130_ef_sc_hd__decap_12
XFILLER_0_62_421 VPWR VGND VPWR VGND sky130_ef_sc_hd__decap_12
XFILLER_0_22_307 VGND VGND VPWR VPWR sky130_fd_sc_hd__fill_1
XFILLER_0_30_362 VGND VGND VPWR VPWR sky130_fd_sc_hd__fill_2
XTAP_TAPCELL_ROW_7_263 VGND VPWR sky130_fd_sc_hd__tapvpwrvgnd_1
XTAP_TAPCELL_ROW_78_939 VGND VPWR sky130_fd_sc_hd__tapvpwrvgnd_1
XFILLER_0_85_502 VGND VGND VPWR VPWR sky130_fd_sc_hd__fill_2
XFILLER_0_72_218 VGND VGND VPWR VPWR sky130_fd_sc_hd__fill_1
XFILLER_0_38_462 VPWR VGND VPWR VGND sky130_ef_sc_hd__decap_12
XFILLER_0_5_529 VPWR VGND VPWR VGND sky130_ef_sc_hd__decap_12
XFILLER_0_53_432 VGND VGND VPWR VPWR sky130_fd_sc_hd__decap_3
XTAP_TAPCELL_ROW_41_585 VGND VPWR sky130_fd_sc_hd__tapvpwrvgnd_1
X_4380_ _0954_ _0955_ _0941_ VGND VGND VPWR VPWR _0957_ sky130_fd_sc_hd__a21oi_2
XFILLER_0_21_340 VGND VGND VPWR VPWR sky130_fd_sc_hd__decap_4
X_3400_ _2851_ _2853_ _2855_ VGND VGND VPWR VPWR _2857_ sky130_fd_sc_hd__and3_1
X_3331_ _2794_ _2797_ VGND VGND VPWR VPWR _2798_ sky130_fd_sc_hd__xnor2_1
X_3262_ u_interface.u_compute_core.u_mac.product_reg\[0\] u_interface.u_compute_core.mac_accum\[0\]
+ net27 _2581_ VGND VGND VPWR VPWR _2738_ sky130_fd_sc_hd__a31o_1
X_6050_ net38 u_interface.core_attn_out\[19\] _2544_ VGND VGND VPWR VPWR _2555_ sky130_fd_sc_hd__mux2_1
X_5001_ _1564_ _1568_ VGND VGND VPWR VPWR _1569_ sky130_fd_sc_hd__xor2_1
X_3193_ _2690_ VGND VGND VPWR VPWR _0037_ sky130_fd_sc_hd__clkbuf_1
XFILLER_0_56_76 VGND VGND VPWR VPWR sky130_fd_sc_hd__decap_8
XTAP_TAPCELL_ROW_49_663 VGND VPWR sky130_fd_sc_hd__tapvpwrvgnd_1
XFILLER_0_76_513 VPWR VGND VPWR VGND sky130_ef_sc_hd__decap_12
X_5903_ _2434_ _2319_ _2581_ _2440_ VGND VGND VPWR VPWR _0158_ sky130_fd_sc_hd__a211oi_1
X_5834_ u_interface.core_attn_out\[12\] u_interface.u_compute_core.u_av.product_reg\[15\]
+ VGND VGND VPWR VPWR _2380_ sky130_fd_sc_hd__or2_1
XFILLER_0_91_505 VPWR VGND VPWR VGND sky130_ef_sc_hd__decap_12
XFILLER_0_29_473 VGND VGND VPWR VPWR sky130_fd_sc_hd__decap_3
XFILLER_0_16_101 VPWR VGND VPWR VGND sky130_ef_sc_hd__decap_12
X_5765_ _2319_ VGND VGND VPWR VPWR _2320_ sky130_fd_sc_hd__clkbuf_4
X_4716_ net120 _1287_ VGND VGND VPWR VPWR _1288_ sky130_fd_sc_hd__xnor2_1
X_5696_ _2147_ _2211_ VGND VGND VPWR VPWR _2255_ sky130_fd_sc_hd__or2_1
X_4647_ _1217_ _1218_ _1219_ VGND VGND VPWR VPWR _1220_ sky130_fd_sc_hd__or3b_4
XFILLER_0_71_284 VGND VGND VPWR VPWR sky130_fd_sc_hd__fill_2
XFILLER_0_31_137 VGND VGND VPWR VPWR sky130_fd_sc_hd__decap_6
X_4578_ _1150_ _1151_ VGND VGND VPWR VPWR _1152_ sky130_fd_sc_hd__and2b_1
XFILLER_0_12_384 VPWR VGND VPWR VGND sky130_ef_sc_hd__decap_12
X_3529_ _2935_ _2936_ VGND VGND VPWR VPWR _2969_ sky130_fd_sc_hd__nand2_1
X_6248_ clknet_leaf_12_clk _0161_ VGND VGND VPWR VPWR u_interface.core_attn_out\[23\]
+ sky130_fd_sc_hd__dfxtp_1
XTAP_TAPCELL_ROW_4_233 VGND VPWR sky130_fd_sc_hd__tapvpwrvgnd_1
X_6179_ clknet_leaf_22_clk _0092_ VGND VGND VPWR VPWR u_interface.u_compute_core.u_mac.product_reg\[1\]
+ sky130_fd_sc_hd__dfxtp_1
XTAP_TAPCELL_ROW_75_909 VGND VPWR sky130_fd_sc_hd__tapvpwrvgnd_1
XTAP_TAPCELL_ROW_83_986 VGND VPWR sky130_fd_sc_hd__tapvpwrvgnd_1
XFILLER_0_79_384 VGND VGND VPWR VPWR sky130_fd_sc_hd__decap_8
XFILLER_0_67_513 VGND VGND VPWR VPWR sky130_fd_sc_hd__decap_3
XFILLER_0_39_237 VPWR VGND VPWR VGND sky130_ef_sc_hd__decap_12
XFILLER_0_47_281 VGND VGND VPWR VPWR sky130_fd_sc_hd__decap_4
XFILLER_0_62_284 VGND VGND VPWR VPWR sky130_fd_sc_hd__decap_4
XFILLER_0_22_137 VGND VGND VPWR VPWR sky130_fd_sc_hd__decap_3
XFILLER_0_30_192 VGND VGND VPWR VPWR sky130_fd_sc_hd__decap_4
XTAP_TAPCELL_ROW_85_1005 VGND VPWR sky130_fd_sc_hd__tapvpwrvgnd_1
Xhold91 u_interface.u_compute_core.u_mac.product_reg\[7\] VGND VGND VPWR VPWR net156
+ sky130_fd_sc_hd__dlygate4sd3_1
Xhold80 u_interface.u_compute_core.u_mac.product_reg\[9\] VGND VGND VPWR VPWR net145
+ sky130_fd_sc_hd__dlygate4sd3_1
XFILLER_0_26_68 VPWR VGND VPWR VGND sky130_ef_sc_hd__decap_12
XTAP_TAPCELL_ROW_46_633 VGND VPWR sky130_fd_sc_hd__tapvpwrvgnd_1
XTAP_TAPCELL_ROW_18_368 VGND VPWR sky130_fd_sc_hd__tapvpwrvgnd_1
X_3880_ _0441_ _0445_ _0470_ VGND VGND VPWR VPWR _0471_ sky130_fd_sc_hd__o21ai_1
XFILLER_0_42_45 VPWR VGND VPWR VGND sky130_ef_sc_hd__decap_12
XFILLER_0_26_421 VGND VGND VPWR VPWR sky130_fd_sc_hd__decap_4
XFILLER_0_5_337 VPWR VGND VPWR VGND sky130_ef_sc_hd__decap_12
X_5550_ _1860_ _2111_ VGND VGND VPWR VPWR _2112_ sky130_fd_sc_hd__xnor2_1
X_4501_ _1012_ _1014_ VGND VGND VPWR VPWR _1076_ sky130_fd_sc_hd__nand2_1
X_5481_ _2041_ _2042_ VGND VGND VPWR VPWR _2043_ sky130_fd_sc_hd__or2_1
X_4432_ _0950_ _0952_ VGND VGND VPWR VPWR _1008_ sky130_fd_sc_hd__nand2_1
X_4363_ _0813_ _0889_ _0888_ VGND VGND VPWR VPWR _0940_ sky130_fd_sc_hd__a21boi_1
X_6102_ clknet_leaf_6_clk _0015_ VGND VGND VPWR VPWR u_interface.u_compute_core.relu_data\[15\]
+ sky130_fd_sc_hd__dfxtp_4
XFILLER_0_67_64 VGND VGND VPWR VPWR sky130_fd_sc_hd__fill_2
X_3314_ u_interface.u_compute_core.u_mac.product_reg\[7\] u_interface.u_compute_core.mac_accum\[7\]
+ VGND VGND VPWR VPWR _2783_ sky130_fd_sc_hd__or2_1
X_4294_ _0828_ VGND VGND VPWR VPWR _0872_ sky130_fd_sc_hd__inv_2
XFILLER_0_67_86 VGND VGND VPWR VPWR sky130_fd_sc_hd__decap_4
X_6033_ _2543_ VGND VGND VPWR VPWR _0185_ sky130_fd_sc_hd__clkbuf_1
X_3245_ _2726_ VGND VGND VPWR VPWR _0053_ sky130_fd_sc_hd__clkbuf_1
X_3176_ u_interface.u_compute_core.scaled_data\[3\] u_interface.u_compute_core.mac_accum\[6\]
+ _2669_ VGND VGND VPWR VPWR _2679_ sky130_fd_sc_hd__mux2_1
Xrebuffer12 _1185_ VGND VGND VPWR VPWR net77 sky130_fd_sc_hd__dlygate4sd1_1
Xrebuffer23 _1843_ VGND VGND VPWR VPWR net88 sky130_fd_sc_hd__dlygate4sd1_1
Xrebuffer45 _1172_ VGND VGND VPWR VPWR net110 sky130_fd_sc_hd__dlygate4sd1_1
XFILLER_0_13_3 VGND VGND VPWR VPWR sky130_fd_sc_hd__decap_4
Xrebuffer34 _1177_ VGND VGND VPWR VPWR net99 sky130_fd_sc_hd__dlygate4sd1_1
Xrebuffer56 _1444_ VGND VGND VPWR VPWR net121 sky130_fd_sc_hd__dlymetal6s4s_1
Xrebuffer67 _1037_ VGND VGND VPWR VPWR net132 sky130_fd_sc_hd__dlygate4sd1_1
XTAP_TAPCELL_ROW_80_956 VGND VPWR sky130_fd_sc_hd__tapvpwrvgnd_1
XFILLER_0_64_527 VGND VGND VPWR VPWR sky130_fd_sc_hd__decap_4
X_5817_ net201 _2304_ _2364_ _2365_ _0855_ VGND VGND VPWR VPWR _0147_ sky130_fd_sc_hd__o221a_1
XFILLER_0_29_281 VPWR VGND VPWR VGND sky130_ef_sc_hd__decap_12
X_5748_ u_interface.core_attn_out\[1\] u_interface.u_compute_core.u_av.product_reg\[4\]
+ VGND VGND VPWR VPWR _2305_ sky130_fd_sc_hd__xor2_1
XFILLER_0_44_251 VGND VGND VPWR VPWR sky130_fd_sc_hd__fill_1
XFILLER_0_17_476 VPWR VGND VPWR VGND sky130_ef_sc_hd__decap_12
XFILLER_0_32_424 VGND VGND VPWR VPWR sky130_fd_sc_hd__decap_8
X_5679_ _2237_ _2238_ VGND VGND VPWR VPWR _2239_ sky130_fd_sc_hd__xnor2_1
XFILLER_0_12_181 VGND VGND VPWR VPWR sky130_fd_sc_hd__decap_4
XFILLER_0_79_192 VGND VGND VPWR VPWR sky130_fd_sc_hd__decap_4
XTAP_TAPCELL_ROW_15_338 VGND VPWR sky130_fd_sc_hd__tapvpwrvgnd_1
XFILLER_0_82_313 VGND VGND VPWR VPWR sky130_fd_sc_hd__fill_1
XFILLER_0_12_37 VGND VGND VPWR VPWR sky130_fd_sc_hd__decap_3
XTAP_TAPCELL_ROW_51_680 VGND VPWR sky130_fd_sc_hd__tapvpwrvgnd_1
XFILLER_0_23_413 VPWR VGND VPWR VGND sky130_ef_sc_hd__decap_12
XFILLER_0_2_307 VGND VGND VPWR VPWR sky130_fd_sc_hd__fill_1
XTAP_TAPCELL_ROW_91_1064 VGND VPWR sky130_fd_sc_hd__tapvpwrvgnd_1
X_4981_ _1547_ _1548_ _1486_ _1472_ VGND VGND VPWR VPWR _1550_ sky130_fd_sc_hd__o211a_4
XFILLER_0_53_55 VGND VGND VPWR VPWR sky130_fd_sc_hd__fill_1
XFILLER_0_58_321 VPWR VGND VPWR VGND sky130_ef_sc_hd__decap_12
XFILLER_0_85_151 VGND VGND VPWR VPWR sky130_fd_sc_hd__decap_4
XFILLER_0_46_505 VGND VGND VPWR VPWR sky130_fd_sc_hd__fill_2
X_3932_ _0487_ _0514_ _0517_ _0518_ VGND VGND VPWR VPWR _0519_ sky130_fd_sc_hd__and4_1
XFILLER_0_58_365 VGND VGND VPWR VPWR sky130_fd_sc_hd__decap_6
XFILLER_0_85_173 VGND VGND VPWR VPWR sky130_fd_sc_hd__fill_1
X_3863_ _0436_ _0438_ VGND VGND VPWR VPWR _0454_ sky130_fd_sc_hd__and2b_1
X_5602_ _2157_ _2162_ VGND VGND VPWR VPWR _2163_ sky130_fd_sc_hd__xor2_1
X_3794_ _0346_ _0387_ VGND VGND VPWR VPWR _0388_ sky130_fd_sc_hd__xnor2_1
X_5533_ _2091_ _2092_ _2093_ VGND VGND VPWR VPWR _2095_ sky130_fd_sc_hd__a21oi_1
XFILLER_0_5_156 VGND VGND VPWR VPWR sky130_fd_sc_hd__decap_6
XFILLER_0_78_41 VGND VGND VPWR VPWR sky130_fd_sc_hd__decap_8
XFILLER_0_41_276 VGND VGND VPWR VPWR sky130_fd_sc_hd__fill_1
X_5464_ _1860_ _1943_ VGND VGND VPWR VPWR _2027_ sky130_fd_sc_hd__nand2_1
X_4415_ _2615_ _0989_ _0990_ VGND VGND VPWR VPWR _0991_ sky130_fd_sc_hd__a21bo_1
X_5395_ _1873_ _1880_ VGND VGND VPWR VPWR _1958_ sky130_fd_sc_hd__or2b_1
X_4346_ u_interface.u_compute_core.relu_data\[9\] _0534_ _0625_ _2611_ VGND VGND VPWR
+ VPWR _0923_ sky130_fd_sc_hd__a22o_1
XFILLER_0_1_373 VPWR VGND VPWR VGND sky130_ef_sc_hd__decap_12
X_4277_ _0485_ net221 _0853_ _0854_ _0855_ VGND VGND VPWR VPWR _0117_ sky130_fd_sc_hd__o221a_1
X_6016_ _2516_ _2531_ VGND VGND VPWR VPWR _2532_ sky130_fd_sc_hd__and2_1
X_3228_ _2694_ _2714_ VGND VGND VPWR VPWR _2715_ sky130_fd_sc_hd__and2_1
X_3159_ u_interface.u_compute_core.relu_data\[27\] VGND VGND VPWR VPWR _2667_ sky130_fd_sc_hd__inv_2
XTAP_TAPCELL_ROW_57_739 VGND VPWR sky130_fd_sc_hd__tapvpwrvgnd_1
XFILLER_0_49_310 VGND VGND VPWR VPWR sky130_fd_sc_hd__fill_1
XFILLER_0_76_184 VPWR VGND VPWR VGND sky130_ef_sc_hd__decap_12
XFILLER_0_9_484 VGND VGND VPWR VPWR sky130_fd_sc_hd__decap_8
XTAP_TAPCELL_ROW_20_385 VGND VPWR sky130_fd_sc_hd__tapvpwrvgnd_1
XFILLER_0_32_243 VGND VGND VPWR VPWR sky130_fd_sc_hd__fill_1
XFILLER_0_2_3 VPWR VGND VPWR VGND sky130_ef_sc_hd__decap_12
XFILLER_0_87_405 VPWR VGND VPWR VGND sky130_ef_sc_hd__decap_12
XTAP_TAPCELL_ROW_28_463 VGND VPWR sky130_fd_sc_hd__tapvpwrvgnd_1
XFILLER_0_59_129 VGND VGND VPWR VPWR sky130_fd_sc_hd__decap_8
XFILLER_0_28_505 VGND VGND VPWR VPWR sky130_fd_sc_hd__decap_6
XFILLER_0_82_165 VGND VGND VPWR VPWR sky130_fd_sc_hd__decap_4
Xrebuffer3 _1630_ VGND VGND VPWR VPWR net68 sky130_fd_sc_hd__dlygate4sd1_1
XFILLER_0_23_254 VGND VGND VPWR VPWR sky130_fd_sc_hd__fill_1
XFILLER_0_11_449 VGND VGND VPWR VPWR sky130_fd_sc_hd__decap_4
X_4200_ _0777_ _0778_ _0738_ VGND VGND VPWR VPWR _0780_ sky130_fd_sc_hd__a21bo_1
X_5180_ _1721_ _1745_ VGND VGND VPWR VPWR _1746_ sky130_fd_sc_hd__xor2_1
XFILLER_0_48_55 VPWR VGND VPWR VGND sky130_ef_sc_hd__decap_12
X_4131_ _0667_ _0669_ VGND VGND VPWR VPWR _0712_ sky130_fd_sc_hd__nand2_1
X_4062_ _0609_ _0606_ _0644_ VGND VGND VPWR VPWR _0645_ sky130_fd_sc_hd__a21oi_2
XFILLER_0_3_68 VGND VGND VPWR VPWR sky130_fd_sc_hd__fill_1
XFILLER_0_78_405 VGND VGND VPWR VPWR sky130_fd_sc_hd__decap_3
XTAP_TAPCELL_ROW_54_709 VGND VPWR sky130_fd_sc_hd__tapvpwrvgnd_1
X_4964_ _1445_ _1531_ _1532_ VGND VGND VPWR VPWR _1533_ sky130_fd_sc_hd__nand3_1
Xclkbuf_leaf_16_clk clknet_1_1__leaf_clk VGND VGND VPWR VPWR clknet_leaf_16_clk sky130_fd_sc_hd__clkbuf_8
XFILLER_0_19_505 VGND VGND VPWR VPWR sky130_fd_sc_hd__fill_2
X_3915_ _0492_ VGND VGND VPWR VPWR _0502_ sky130_fd_sc_hd__clkbuf_4
X_4895_ _1462_ _1463_ _1439_ VGND VGND VPWR VPWR _1465_ sky130_fd_sc_hd__a21oi_1
XFILLER_0_73_143 VGND VGND VPWR VPWR sky130_fd_sc_hd__fill_1
XFILLER_0_73_132 VGND VGND VPWR VPWR sky130_fd_sc_hd__fill_1
XFILLER_0_46_357 VGND VGND VPWR VPWR sky130_fd_sc_hd__decap_6
XTAP_TAPCELL_ROW_62_786 VGND VPWR sky130_fd_sc_hd__tapvpwrvgnd_1
X_3846_ _0371_ _0404_ _0437_ VGND VGND VPWR VPWR _0438_ sky130_fd_sc_hd__a21bo_1
XFILLER_0_6_421 VPWR VGND VPWR VGND sky130_ef_sc_hd__decap_12
XFILLER_0_89_51 VGND VGND VPWR VPWR sky130_fd_sc_hd__decap_4
XFILLER_0_14_210 VGND VGND VPWR VPWR sky130_fd_sc_hd__decap_4
X_3777_ _0304_ _0370_ VGND VGND VPWR VPWR _0371_ sky130_fd_sc_hd__xnor2_4
X_5516_ _1911_ _1913_ _2002_ VGND VGND VPWR VPWR _2078_ sky130_fd_sc_hd__a21o_1
XFILLER_0_14_265 VPWR VGND VPWR VGND sky130_ef_sc_hd__decap_12
X_5447_ _2007_ _2008_ _1954_ _1955_ VGND VGND VPWR VPWR _2010_ sky130_fd_sc_hd__o211a_1
X_5378_ _1941_ _1852_ VGND VGND VPWR VPWR _1942_ sky130_fd_sc_hd__nor2_1
XFILLER_0_1_181 VPWR VGND VPWR VGND sky130_ef_sc_hd__decap_12
X_4329_ _0796_ _0846_ _0845_ VGND VGND VPWR VPWR _0907_ sky130_fd_sc_hd__a21bo_1
XFILLER_0_69_449 VPWR VGND VPWR VGND sky130_ef_sc_hd__decap_12
XTAP_TAPCELL_ROW_25_433 VGND VPWR sky130_fd_sc_hd__tapvpwrvgnd_1
XFILLER_0_49_184 VPWR VGND VPWR VGND sky130_ef_sc_hd__decap_12
XFILLER_0_9_281 VGND VGND VPWR VPWR sky130_fd_sc_hd__fill_1
XFILLER_0_37_368 VGND VGND VPWR VPWR sky130_fd_sc_hd__decap_8
XFILLER_0_45_390 VGND VGND VPWR VPWR sky130_fd_sc_hd__fill_2
XFILLER_0_33_541 VGND VGND VPWR VPWR sky130_fd_sc_hd__decap_6
XFILLER_0_87_279 VGND VGND VPWR VPWR sky130_fd_sc_hd__fill_1
XFILLER_0_68_460 VGND VGND VPWR VPWR sky130_fd_sc_hd__decap_6
X_3700_ _0294_ _0295_ VGND VGND VPWR VPWR _0296_ sky130_fd_sc_hd__xnor2_1
X_4680_ _1250_ _1251_ _0918_ VGND VGND VPWR VPWR _1253_ sky130_fd_sc_hd__o21ai_1
X_3631_ _0227_ _0228_ VGND VGND VPWR VPWR _0229_ sky130_fd_sc_hd__xnor2_1
X_3562_ _2990_ _2999_ VGND VGND VPWR VPWR _3001_ sky130_fd_sc_hd__and2_1
XFILLER_0_24_541 VGND VGND VPWR VPWR sky130_fd_sc_hd__fill_2
X_5301_ _0915_ net219 VGND VGND VPWR VPWR _1866_ sky130_fd_sc_hd__or2_1
X_3493_ net4 VGND VGND VPWR VPWR _2935_ sky130_fd_sc_hd__clkbuf_4
X_6281_ clknet_leaf_13_clk _0194_ VGND VGND VPWR VPWR net42 sky130_fd_sc_hd__dfxtp_1
XFILLER_0_51_393 VGND VGND VPWR VPWR sky130_fd_sc_hd__decap_8
X_5232_ _1795_ _1796_ VGND VGND VPWR VPWR _1797_ sky130_fd_sc_hd__xor2_1
XFILLER_0_11_279 VGND VGND VPWR VPWR sky130_fd_sc_hd__fill_1
Xclkbuf_leaf_5_clk clknet_1_0__leaf_clk VGND VGND VPWR VPWR clknet_leaf_5_clk sky130_fd_sc_hd__clkbuf_8
XFILLER_0_59_98 VGND VGND VPWR VPWR sky130_fd_sc_hd__decap_4
X_5163_ _1722_ _1727_ VGND VGND VPWR VPWR _1729_ sky130_fd_sc_hd__and2_1
X_4114_ _0612_ _0516_ VGND VGND VPWR VPWR _0695_ sky130_fd_sc_hd__nand2_1
X_5094_ _1654_ _1660_ VGND VGND VPWR VPWR _1661_ sky130_fd_sc_hd__xnor2_1
XFILLER_0_75_97 VGND VGND VPWR VPWR sky130_fd_sc_hd__decap_8
XTAP_TAPCELL_ROW_67_834 VGND VPWR sky130_fd_sc_hd__tapvpwrvgnd_1
X_4045_ _0626_ _0627_ VGND VGND VPWR VPWR _0628_ sky130_fd_sc_hd__nor2_1
XTAP_TAPCELL_ROW_39_569 VGND VPWR sky130_fd_sc_hd__tapvpwrvgnd_1
X_5996_ _2518_ VGND VGND VPWR VPWR _0173_ sky130_fd_sc_hd__clkbuf_1
X_4947_ _1514_ _1513_ VGND VGND VPWR VPWR _1516_ sky130_fd_sc_hd__and2b_1
X_4878_ net123 _2631_ _0557_ _0595_ VGND VGND VPWR VPWR _1448_ sky130_fd_sc_hd__nand4_2
XFILLER_0_74_485 VGND VGND VPWR VPWR sky130_fd_sc_hd__fill_2
XFILLER_0_19_368 VGND VGND VPWR VPWR sky130_fd_sc_hd__fill_1
X_3829_ _0420_ _0421_ VGND VGND VPWR VPWR _0422_ sky130_fd_sc_hd__or2_1
XFILLER_0_34_349 VGND VGND VPWR VPWR sky130_fd_sc_hd__fill_1
XFILLER_0_15_541 VGND VGND VPWR VPWR sky130_fd_sc_hd__decap_6
XTAP_TAPCELL_ROW_30_480 VGND VPWR sky130_fd_sc_hd__tapvpwrvgnd_1
XFILLER_0_30_500 VGND VGND VPWR VPWR sky130_fd_sc_hd__decap_6
XFILLER_0_30_533 VPWR VGND VPWR VGND sky130_ef_sc_hd__decap_12
XFILLER_0_69_202 VGND VGND VPWR VPWR sky130_fd_sc_hd__decap_3
XFILLER_0_84_227 VGND VGND VPWR VPWR sky130_fd_sc_hd__fill_1
XFILLER_0_84_205 VGND VGND VPWR VPWR sky130_fd_sc_hd__fill_1
XPHY_EDGE_ROW_4_Left_97 VGND VGND VPWR VPWR sky130_fd_sc_hd__decap_3
XFILLER_0_37_110 VGND VGND VPWR VPWR sky130_fd_sc_hd__fill_2
XFILLER_0_65_485 VPWR VGND VPWR VGND sky130_ef_sc_hd__decap_12
XFILLER_0_92_293 VPWR VGND VPWR VGND sky130_ef_sc_hd__decap_12
XFILLER_0_80_444 VGND VGND VPWR VPWR sky130_fd_sc_hd__fill_2
XFILLER_0_80_433 VGND VGND VPWR VPWR sky130_fd_sc_hd__decap_3
XFILLER_0_20_15 VGND VGND VPWR VPWR sky130_fd_sc_hd__decap_4
XFILLER_0_80_477 VGND VGND VPWR VPWR sky130_fd_sc_hd__decap_4
XFILLER_0_20_26 VGND VGND VPWR VPWR sky130_fd_sc_hd__fill_2
XFILLER_0_0_449 VPWR VGND VPWR VGND sky130_ef_sc_hd__decap_12
XTAP_TAPCELL_ROW_88_1036 VGND VPWR sky130_fd_sc_hd__tapvpwrvgnd_1
XFILLER_0_88_533 VPWR VGND VPWR VGND sky130_ef_sc_hd__decap_12
XTAP_TAPCELL_ROW_64_804 VGND VPWR sky130_fd_sc_hd__tapvpwrvgnd_1
XTAP_TAPCELL_ROW_36_539 VGND VPWR sky130_fd_sc_hd__tapvpwrvgnd_1
X_5850_ u_interface.core_attn_out\[14\] u_interface.u_compute_core.u_av.product_reg\[17\]
+ VGND VGND VPWR VPWR _2394_ sky130_fd_sc_hd__nand2_1
X_4801_ _2620_ _1281_ _1282_ _1222_ VGND VGND VPWR VPWR _1372_ sky130_fd_sc_hd__a22o_1
XTAP_TAPCELL_ROW_72_881 VGND VPWR sky130_fd_sc_hd__tapvpwrvgnd_1
XFILLER_0_0_69 VGND VGND VPWR VPWR sky130_fd_sc_hd__decap_8
X_5781_ net157 VGND VGND VPWR VPWR _2334_ sky130_fd_sc_hd__inv_2
X_4732_ u_interface.u_compute_core.relu_data\[18\] _0493_ _1212_ VGND VGND VPWR VPWR
+ _1304_ sky130_fd_sc_hd__a21o_1
XFILLER_0_71_400 VGND VGND VPWR VPWR sky130_fd_sc_hd__fill_2
XFILLER_0_56_452 VGND VGND VPWR VPWR sky130_fd_sc_hd__fill_1
X_4663_ _1228_ _1235_ VGND VGND VPWR VPWR _1236_ sky130_fd_sc_hd__xnor2_1
XFILLER_0_43_113 VPWR VGND VPWR VGND sky130_ef_sc_hd__decap_12
XFILLER_0_9_67 VGND VGND VPWR VPWR sky130_fd_sc_hd__decap_8
X_3614_ net13 _3013_ _2984_ VGND VGND VPWR VPWR _0212_ sky130_fd_sc_hd__and3_1
X_4594_ _1138_ _1166_ VGND VGND VPWR VPWR _1168_ sky130_fd_sc_hd__nand2_1
XFILLER_0_71_499 VGND VGND VPWR VPWR sky130_fd_sc_hd__decap_4
XFILLER_0_24_371 VGND VGND VPWR VPWR sky130_fd_sc_hd__decap_8
XFILLER_0_12_533 VPWR VGND VPWR VGND sky130_ef_sc_hd__decap_12
X_3545_ net12 net6 VGND VGND VPWR VPWR _2984_ sky130_fd_sc_hd__and2_1
X_6264_ clknet_leaf_21_clk net137 VGND VGND VPWR VPWR net55 sky130_fd_sc_hd__dfxtp_1
X_3476_ _2920_ _2921_ VGND VGND VPWR VPWR _2922_ sky130_fd_sc_hd__xor2_1
XFILLER_0_86_41 VPWR VGND VPWR VGND sky130_ef_sc_hd__decap_12
X_5215_ _1712_ _1780_ VGND VGND VPWR VPWR _1781_ sky130_fd_sc_hd__xor2_1
X_6195_ clknet_leaf_2_clk _0108_ VGND VGND VPWR VPWR u_interface.u_compute_core.mac_last
+ sky130_fd_sc_hd__dfxtp_1
XFILLER_0_43_3 VPWR VGND VPWR VGND sky130_ef_sc_hd__decap_12
X_5146_ _1707_ _1708_ _1711_ VGND VGND VPWR VPWR _1712_ sky130_fd_sc_hd__and3_1
X_5077_ u_interface.u_compute_core.relu_data\[23\] VGND VGND VPWR VPWR _1644_ sky130_fd_sc_hd__clkbuf_2
XFILLER_0_79_533 VPWR VGND VPWR VGND sky130_ef_sc_hd__decap_12
X_4028_ _0562_ _0600_ _0601_ VGND VGND VPWR VPWR _0611_ sky130_fd_sc_hd__and3_1
XFILLER_0_39_419 VGND VGND VPWR VPWR sky130_fd_sc_hd__fill_2
Xsplit17 u_interface.u_compute_core.relu_data\[6\] VGND VGND VPWR VPWR net82 sky130_fd_sc_hd__clkbuf_2
X_5979_ _2502_ _2505_ _2506_ VGND VGND VPWR VPWR _0168_ sky130_fd_sc_hd__o21a_1
XFILLER_0_47_485 VPWR VGND VPWR VGND sky130_ef_sc_hd__decap_12
XFILLER_0_62_433 VGND VGND VPWR VPWR sky130_fd_sc_hd__decap_4
XFILLER_0_62_488 VPWR VGND VPWR VGND sky130_ef_sc_hd__decap_12
XFILLER_0_15_393 VGND VGND VPWR VPWR sky130_fd_sc_hd__fill_1
XTAP_TAPCELL_ROW_7_264 VGND VPWR sky130_fd_sc_hd__tapvpwrvgnd_1
XFILLER_0_15_15 VGND VGND VPWR VPWR sky130_fd_sc_hd__fill_1
XTAP_TAPCELL_ROW_33_509 VGND VPWR sky130_fd_sc_hd__tapvpwrvgnd_1
XFILLER_0_38_474 VGND VGND VPWR VPWR sky130_fd_sc_hd__fill_2
XFILLER_0_53_400 VPWR VGND VPWR VGND sky130_ef_sc_hd__decap_12
XFILLER_0_25_113 VGND VGND VPWR VPWR sky130_fd_sc_hd__decap_3
XFILLER_0_31_69 VGND VGND VPWR VPWR sky130_fd_sc_hd__decap_4
XTAP_TAPCELL_ROW_41_586 VGND VPWR sky130_fd_sc_hd__tapvpwrvgnd_1
XFILLER_0_21_363 VGND VGND VPWR VPWR sky130_fd_sc_hd__decap_6
X_3330_ _2795_ _2796_ VGND VGND VPWR VPWR _2797_ sky130_fd_sc_hd__or2_1
X_5000_ _1566_ _1567_ VGND VGND VPWR VPWR _1568_ sky130_fd_sc_hd__xnor2_1
X_3261_ u_interface.u_compute_core.u_mac.product_reg\[0\] net27 net198 VGND VGND VPWR
+ VPWR _2737_ sky130_fd_sc_hd__a21oi_1
X_3192_ _2672_ _2689_ VGND VGND VPWR VPWR _2690_ sky130_fd_sc_hd__and2_1
XTAP_TAPCELL_ROW_49_664 VGND VPWR sky130_fd_sc_hd__tapvpwrvgnd_1
XFILLER_0_76_525 VGND VGND VPWR VPWR sky130_fd_sc_hd__decap_6
XFILLER_0_72_54 VPWR VGND VPWR VGND sky130_ef_sc_hd__decap_12
X_5902_ _2438_ _2439_ _2319_ VGND VGND VPWR VPWR _2440_ sky130_fd_sc_hd__a21oi_1
X_5833_ net207 _2304_ _2378_ _2379_ _0855_ VGND VGND VPWR VPWR _0149_ sky130_fd_sc_hd__o221a_1
XFILLER_0_91_517 VPWR VGND VPWR VGND sky130_ef_sc_hd__decap_12
XFILLER_0_16_113 VPWR VGND VPWR VGND sky130_ef_sc_hd__decap_12
X_5764_ _2318_ VGND VGND VPWR VPWR _2319_ sky130_fd_sc_hd__clkbuf_4
XFILLER_0_44_411 VGND VGND VPWR VPWR sky130_fd_sc_hd__decap_8
X_4715_ _1285_ _1286_ VGND VGND VPWR VPWR _1287_ sky130_fd_sc_hd__nor2b_1
XFILLER_0_71_241 VGND VGND VPWR VPWR sky130_fd_sc_hd__fill_1
XFILLER_0_16_135 VGND VGND VPWR VPWR sky130_fd_sc_hd__decap_4
XFILLER_0_16_157 VGND VGND VPWR VPWR sky130_fd_sc_hd__decap_4
X_5695_ _2252_ _2253_ VGND VGND VPWR VPWR _2254_ sky130_fd_sc_hd__nor2_1
X_4646_ u_interface.u_compute_core.relu_data\[12\] _0556_ _0927_ _0594_ VGND VGND
+ VPWR VPWR _1219_ sky130_fd_sc_hd__a22o_1
XFILLER_0_44_477 VGND VGND VPWR VPWR sky130_fd_sc_hd__decap_4
X_4577_ _1148_ _1149_ _1144_ VGND VGND VPWR VPWR _1151_ sky130_fd_sc_hd__a21o_1
XFILLER_0_12_363 VGND VGND VPWR VPWR sky130_fd_sc_hd__fill_1
X_3528_ _2966_ _2967_ VGND VGND VPWR VPWR _2968_ sky130_fd_sc_hd__nand2_1
XFILLER_0_12_396 VGND VGND VPWR VPWR sky130_fd_sc_hd__decap_6
X_6247_ clknet_leaf_13_clk _0160_ VGND VGND VPWR VPWR u_interface.core_attn_out\[22\]
+ sky130_fd_sc_hd__dfxtp_1
X_3459_ u_interface.u_compute_core.mac_accum\[27\] u_interface.u_compute_core.mac_accum\[26\]
+ _2833_ VGND VGND VPWR VPWR _2907_ sky130_fd_sc_hd__o21a_1
X_6178_ clknet_leaf_22_clk _0091_ VGND VGND VPWR VPWR u_interface.u_compute_core.u_mac.product_reg\[0\]
+ sky130_fd_sc_hd__dfxtp_1
X_5129_ _1693_ _1694_ _1642_ _1619_ VGND VGND VPWR VPWR _1696_ sky130_fd_sc_hd__o211a_1
XTAP_TAPCELL_ROW_4_234 VGND VPWR sky130_fd_sc_hd__tapvpwrvgnd_1
XFILLER_0_67_525 VPWR VGND VPWR VGND sky130_ef_sc_hd__decap_12
XTAP_TAPCELL_ROW_83_987 VGND VPWR sky130_fd_sc_hd__tapvpwrvgnd_1
XFILLER_0_39_249 VPWR VGND VPWR VGND sky130_ef_sc_hd__decap_12
XFILLER_0_35_499 VGND VGND VPWR VPWR sky130_fd_sc_hd__fill_1
XFILLER_0_50_403 VGND VGND VPWR VPWR sky130_fd_sc_hd__decap_3
XFILLER_0_89_105 VGND VGND VPWR VPWR sky130_fd_sc_hd__decap_6
Xhold92 u_interface.core_attn_out\[5\] VGND VGND VPWR VPWR net157 sky130_fd_sc_hd__dlygate4sd3_1
Xhold81 u_interface.u_compute_core.mac_accum\[1\] VGND VGND VPWR VPWR net146 sky130_fd_sc_hd__dlygate4sd3_1
Xhold70 u_interface.u_compute_core.u_mac.product_reg\[8\] VGND VGND VPWR VPWR net135
+ sky130_fd_sc_hd__dlygate4sd3_1
XTAP_TAPCELL_ROW_85_1006 VGND VPWR sky130_fd_sc_hd__tapvpwrvgnd_1
XTAP_TAPCELL_ROW_46_634 VGND VPWR sky130_fd_sc_hd__tapvpwrvgnd_1
XTAP_TAPCELL_ROW_18_369 VGND VPWR sky130_fd_sc_hd__tapvpwrvgnd_1
XFILLER_0_85_355 VPWR VGND VPWR VGND sky130_ef_sc_hd__decap_12
XFILLER_0_73_517 VPWR VGND VPWR VGND sky130_ef_sc_hd__decap_12
XFILLER_0_42_57 VGND VGND VPWR VPWR sky130_fd_sc_hd__decap_8
XFILLER_0_5_305 VPWR VGND VPWR VGND sky130_ef_sc_hd__decap_12
XFILLER_0_53_241 VGND VGND VPWR VPWR sky130_fd_sc_hd__decap_4
X_4500_ _0937_ _1005_ VGND VGND VPWR VPWR _1075_ sky130_fd_sc_hd__and2b_1
XFILLER_0_13_105 VGND VGND VPWR VPWR sky130_fd_sc_hd__decap_6
XFILLER_0_5_349 VPWR VGND VPWR VGND sky130_ef_sc_hd__decap_12
X_5480_ u_interface.u_compute_core.relu_data\[27\] _0516_ _1871_ VGND VGND VPWR VPWR
+ _2042_ sky130_fd_sc_hd__and3_1
X_4431_ _0835_ _0959_ net103 VGND VGND VPWR VPWR _1007_ sky130_fd_sc_hd__a21bo_1
X_4362_ _0937_ _0938_ VGND VGND VPWR VPWR _0939_ sky130_fd_sc_hd__and2_1
XFILLER_0_6_46 VGND VGND VPWR VPWR sky130_fd_sc_hd__decap_3
X_6101_ clknet_leaf_6_clk _0014_ VGND VGND VPWR VPWR u_interface.u_compute_core.relu_data\[14\]
+ sky130_fd_sc_hd__dfxtp_4
XFILLER_0_67_43 VPWR VGND VPWR VGND sky130_ef_sc_hd__decap_12
X_3313_ u_interface.u_compute_core.u_mac.product_reg\[7\] u_interface.u_compute_core.mac_accum\[7\]
+ VGND VGND VPWR VPWR _2782_ sky130_fd_sc_hd__nand2_1
X_4293_ _0813_ _0833_ _0832_ VGND VGND VPWR VPWR _0871_ sky130_fd_sc_hd__a21bo_1
X_6032_ _2539_ _2542_ VGND VGND VPWR VPWR _2543_ sky130_fd_sc_hd__and2_1
X_3244_ _2716_ _2725_ VGND VGND VPWR VPWR _2726_ sky130_fd_sc_hd__and2_1
X_3175_ _2678_ VGND VGND VPWR VPWR _0031_ sky130_fd_sc_hd__clkbuf_1
Xrebuffer46 net110 VGND VGND VPWR VPWR net111 sky130_fd_sc_hd__dlymetal6s2s_1
Xrebuffer13 _0976_ VGND VGND VPWR VPWR net78 sky130_fd_sc_hd__dlygate4sd1_1
Xrebuffer24 _1179_ VGND VGND VPWR VPWR net89 sky130_fd_sc_hd__dlymetal6s2s_1
Xrebuffer35 _1177_ VGND VGND VPWR VPWR net100 sky130_fd_sc_hd__dlygate4sd1_1
Xrebuffer57 _1315_ VGND VGND VPWR VPWR net122 sky130_fd_sc_hd__dlygate4sd1_1
XFILLER_0_76_344 VPWR VGND VPWR VGND sky130_ef_sc_hd__decap_12
XTAP_TAPCELL_ROW_80_957 VGND VPWR sky130_fd_sc_hd__tapvpwrvgnd_1
X_5816_ _2355_ _2360_ _2363_ _2318_ VGND VGND VPWR VPWR _2365_ sky130_fd_sc_hd__a31o_1
X_5747_ _2301_ VGND VGND VPWR VPWR _2304_ sky130_fd_sc_hd__clkbuf_4
XFILLER_0_17_433 VGND VGND VPWR VPWR sky130_fd_sc_hd__fill_1
XFILLER_0_29_293 VGND VGND VPWR VPWR sky130_fd_sc_hd__decap_4
XFILLER_0_17_488 VGND VGND VPWR VPWR sky130_fd_sc_hd__fill_1
X_5678_ _1935_ _2170_ _2168_ VGND VGND VPWR VPWR _2238_ sky130_fd_sc_hd__o21a_1
X_4629_ _1198_ _1199_ _1200_ VGND VGND VPWR VPWR _1202_ sky130_fd_sc_hd__a21o_1
XFILLER_0_12_160 VGND VGND VPWR VPWR sky130_fd_sc_hd__fill_2
XFILLER_0_12_193 VGND VGND VPWR VPWR sky130_fd_sc_hd__decap_3
XFILLER_0_67_322 VGND VGND VPWR VPWR sky130_fd_sc_hd__fill_1
XTAP_TAPCELL_ROW_43_604 VGND VPWR sky130_fd_sc_hd__tapvpwrvgnd_1
XTAP_TAPCELL_ROW_15_339 VGND VPWR sky130_fd_sc_hd__tapvpwrvgnd_1
XFILLER_0_12_27 VGND VGND VPWR VPWR sky130_fd_sc_hd__fill_1
XFILLER_0_55_528 VPWR VGND VPWR VGND sky130_ef_sc_hd__decap_12
XTAP_TAPCELL_ROW_51_681 VGND VPWR sky130_fd_sc_hd__tapvpwrvgnd_1
XFILLER_0_23_425 VGND VGND VPWR VPWR sky130_fd_sc_hd__decap_8
XFILLER_0_23_447 VGND VGND VPWR VPWR sky130_fd_sc_hd__fill_1
XFILLER_0_50_288 VGND VGND VPWR VPWR sky130_fd_sc_hd__decap_6
Xoutput60 net60 VGND VGND VPWR VPWR m_tvalid sky130_fd_sc_hd__buf_2
XTAP_TAPCELL_ROW_91_1065 VGND VPWR sky130_fd_sc_hd__tapvpwrvgnd_1
X_4980_ net106 _1486_ _1547_ net115 VGND VGND VPWR VPWR _1549_ sky130_fd_sc_hd__a211oi_4
XFILLER_0_58_333 VPWR VGND VPWR VGND sky130_ef_sc_hd__decap_12
X_3931_ _2592_ _0515_ _0496_ _2589_ VGND VGND VPWR VPWR _0518_ sky130_fd_sc_hd__a22o_1
XFILLER_0_73_314 VGND VGND VPWR VPWR sky130_fd_sc_hd__decap_4
X_3862_ _0439_ VGND VGND VPWR VPWR _0453_ sky130_fd_sc_hd__inv_2
X_5601_ _2159_ _2161_ VGND VGND VPWR VPWR _2162_ sky130_fd_sc_hd__xnor2_1
XFILLER_0_5_113 VPWR VGND VPWR VGND sky130_ef_sc_hd__decap_12
X_3793_ _0385_ _0386_ VGND VGND VPWR VPWR _0387_ sky130_fd_sc_hd__nor2_1
X_5532_ _2091_ _2092_ _2093_ VGND VGND VPWR VPWR _2094_ sky130_fd_sc_hd__and3_1
XFILLER_0_41_222 VGND VGND VPWR VPWR sky130_fd_sc_hd__fill_2
X_5463_ _1938_ _1939_ _1942_ VGND VGND VPWR VPWR _2026_ sky130_fd_sc_hd__or3_1
X_5394_ _1956_ VGND VGND VPWR VPWR _1957_ sky130_fd_sc_hd__inv_2
X_4414_ u_interface.u_compute_core.relu_data\[9\] _0625_ _0819_ _2610_ VGND VGND VPWR
+ VPWR _0990_ sky130_fd_sc_hd__a22o_1
X_4345_ u_interface.u_compute_core.relu_data\[9\] _2610_ _0586_ _0625_ VGND VGND VPWR
+ VPWR _0922_ sky130_fd_sc_hd__and4_1
XFILLER_0_1_385 VGND VGND VPWR VPWR sky130_fd_sc_hd__decap_6
X_4276_ _2580_ VGND VGND VPWR VPWR _0855_ sky130_fd_sc_hd__clkbuf_4
X_6015_ net58 u_interface.core_attn_out\[8\] _2521_ VGND VGND VPWR VPWR _2531_ sky130_fd_sc_hd__mux2_1
X_3227_ u_interface.u_compute_core.scaled_data\[19\] u_interface.u_compute_core.mac_accum\[22\]
+ _2713_ VGND VGND VPWR VPWR _2714_ sky130_fd_sc_hd__mux2_1
X_3158_ _2643_ _2666_ VGND VGND VPWR VPWR _0026_ sky130_fd_sc_hd__nor2_1
X_3089_ u_interface.u_compute_core.relu_data\[9\] VGND VGND VPWR VPWR _2615_ sky130_fd_sc_hd__buf_4
XFILLER_0_76_141 VGND VGND VPWR VPWR sky130_fd_sc_hd__fill_2
XFILLER_0_91_111 VGND VGND VPWR VPWR sky130_fd_sc_hd__fill_1
XTAP_TAPCELL_ROW_12_309 VGND VPWR sky130_fd_sc_hd__tapvpwrvgnd_1
XFILLER_0_9_441 VGND VGND VPWR VPWR sky130_fd_sc_hd__decap_6
XFILLER_0_72_391 VPWR VGND VPWR VGND sky130_ef_sc_hd__decap_12
XFILLER_0_60_531 VGND VGND VPWR VPWR sky130_fd_sc_hd__fill_1
XTAP_TAPCELL_ROW_20_386 VGND VPWR sky130_fd_sc_hd__tapvpwrvgnd_1
XFILLER_0_20_406 VGND VGND VPWR VPWR sky130_fd_sc_hd__decap_8
XFILLER_0_20_439 VGND VGND VPWR VPWR sky130_fd_sc_hd__fill_1
XFILLER_0_32_277 VGND VGND VPWR VPWR sky130_fd_sc_hd__fill_1
XFILLER_0_87_417 VGND VGND VPWR VPWR sky130_fd_sc_hd__fill_1
XTAP_TAPCELL_ROW_28_464 VGND VPWR sky130_fd_sc_hd__tapvpwrvgnd_1
XFILLER_0_23_37 VGND VGND VPWR VPWR sky130_fd_sc_hd__fill_2
XFILLER_0_82_122 VPWR VGND VPWR VGND sky130_ef_sc_hd__decap_12
XFILLER_0_70_317 VGND VGND VPWR VPWR sky130_fd_sc_hd__fill_1
XFILLER_0_23_200 VGND VGND VPWR VPWR sky130_fd_sc_hd__fill_1
Xrebuffer4 _0687_ VGND VGND VPWR VPWR net69 sky130_fd_sc_hd__dlygate4sd1_1
X_4130_ _0709_ _0710_ VGND VGND VPWR VPWR _0711_ sky130_fd_sc_hd__or2_2
XFILLER_0_48_67 VPWR VGND VPWR VGND sky130_ef_sc_hd__decap_12
XPHY_EDGE_ROW_79_Left_172 VGND VGND VPWR VPWR sky130_fd_sc_hd__decap_3
X_4061_ _0641_ _0643_ VGND VGND VPWR VPWR _0644_ sky130_fd_sc_hd__xnor2_1
XFILLER_0_78_417 VGND VGND VPWR VPWR sky130_fd_sc_hd__decap_3
X_4963_ _1529_ _1530_ _1520_ VGND VGND VPWR VPWR _1532_ sky130_fd_sc_hd__a21o_1
X_3914_ _2589_ _0500_ VGND VGND VPWR VPWR _0501_ sky130_fd_sc_hd__nand2_1
X_4894_ _1462_ _1439_ _1463_ VGND VGND VPWR VPWR _1464_ sky130_fd_sc_hd__and3_1
XPHY_EDGE_ROW_88_Left_181 VGND VGND VPWR VPWR sky130_fd_sc_hd__decap_3
XTAP_TAPCELL_ROW_62_787 VGND VPWR sky130_fd_sc_hd__tapvpwrvgnd_1
XFILLER_0_13_81 VPWR VGND VPWR VGND sky130_ef_sc_hd__decap_12
X_3845_ _0403_ _0402_ VGND VGND VPWR VPWR _0437_ sky130_fd_sc_hd__or2b_1
XFILLER_0_6_433 VPWR VGND VPWR VGND sky130_ef_sc_hd__decap_12
X_3776_ _0337_ _0369_ _0265_ VGND VGND VPWR VPWR _0370_ sky130_fd_sc_hd__and3b_1
XFILLER_0_6_477 VPWR VGND VPWR VGND sky130_ef_sc_hd__decap_12
XFILLER_0_42_531 VGND VGND VPWR VPWR sky130_fd_sc_hd__fill_1
XFILLER_0_54_391 VPWR VGND VPWR VGND sky130_ef_sc_hd__decap_12
XFILLER_0_61_328 VGND VGND VPWR VPWR sky130_fd_sc_hd__fill_1
X_5515_ _2074_ _2075_ _2038_ _2039_ VGND VGND VPWR VPWR _2077_ sky130_fd_sc_hd__a211oi_1
XFILLER_0_73_3 VPWR VGND VPWR VGND sky130_ef_sc_hd__decap_12
X_5446_ _1954_ _1955_ _2007_ _2008_ VGND VGND VPWR VPWR _2009_ sky130_fd_sc_hd__a211oi_1
XFILLER_0_14_277 VGND VGND VPWR VPWR sky130_fd_sc_hd__decap_8
X_5377_ _1765_ _1785_ _1848_ _1849_ VGND VGND VPWR VPWR _1941_ sky130_fd_sc_hd__o211a_1
X_4328_ _0904_ _0902_ _0903_ VGND VGND VPWR VPWR _0906_ sky130_fd_sc_hd__nand3_1
X_4259_ _0834_ _0836_ _0808_ VGND VGND VPWR VPWR _0838_ sky130_fd_sc_hd__a21oi_1
XFILLER_0_77_461 VPWR VGND VPWR VGND sky130_ef_sc_hd__decap_12
XTAP_TAPCELL_ROW_25_434 VGND VPWR sky130_fd_sc_hd__tapvpwrvgnd_1
XFILLER_0_37_303 VPWR VGND VPWR VGND sky130_ef_sc_hd__decap_12
XFILLER_0_49_196 VGND VGND VPWR VPWR sky130_fd_sc_hd__decap_8
XFILLER_0_64_155 VGND VGND VPWR VPWR sky130_fd_sc_hd__fill_2
XFILLER_0_68_494 VGND VGND VPWR VPWR sky130_fd_sc_hd__fill_2
XFILLER_0_7_208 VPWR VGND VPWR VGND sky130_ef_sc_hd__decap_12
XFILLER_0_55_122 VGND VGND VPWR VPWR sky130_fd_sc_hd__decap_6
XFILLER_0_83_453 VGND VGND VPWR VPWR sky130_fd_sc_hd__fill_1
XFILLER_0_83_497 VGND VGND VPWR VPWR sky130_fd_sc_hd__decap_6
X_3630_ net24 net18 VGND VGND VPWR VPWR _0228_ sky130_fd_sc_hd__nand2_1
XFILLER_0_24_531 VGND VGND VPWR VPWR sky130_fd_sc_hd__fill_1
XFILLER_0_55_199 VGND VGND VPWR VPWR sky130_fd_sc_hd__decap_3
X_3561_ _2990_ _2999_ VGND VGND VPWR VPWR _3000_ sky130_fd_sc_hd__nor2_1
XFILLER_0_3_447 VGND VGND VPWR VPWR sky130_fd_sc_hd__fill_1
X_5300_ _1862_ _1864_ VGND VGND VPWR VPWR _1865_ sky130_fd_sc_hd__xor2_1
XFILLER_0_11_225 VPWR VGND VPWR VGND sky130_ef_sc_hd__decap_12
X_3492_ _2890_ _2933_ _2934_ _2867_ net149 VGND VGND VPWR VPWR _0092_ sky130_fd_sc_hd__a32o_1
X_6280_ clknet_leaf_11_clk _0193_ VGND VGND VPWR VPWR net41 sky130_fd_sc_hd__dfxtp_1
XFILLER_0_59_55 VGND VGND VPWR VPWR sky130_fd_sc_hd__fill_1
X_5231_ _2655_ _0516_ _1724_ _1723_ VGND VGND VPWR VPWR _1796_ sky130_fd_sc_hd__a31o_1
X_5162_ _1722_ _1727_ VGND VGND VPWR VPWR _1728_ sky130_fd_sc_hd__nor2_1
X_5093_ _1658_ _1659_ VGND VGND VPWR VPWR _1660_ sky130_fd_sc_hd__and2_1
X_4113_ _0679_ _0681_ VGND VGND VPWR VPWR _0694_ sky130_fd_sc_hd__nand2_1
XTAP_TAPCELL_ROW_67_835 VGND VPWR sky130_fd_sc_hd__tapvpwrvgnd_1
X_4044_ _2595_ _0534_ _0557_ u_interface.u_compute_core.relu_data\[2\] VGND VGND VPWR
+ VPWR _0627_ sky130_fd_sc_hd__a22oi_1
X_5995_ _2516_ _2517_ VGND VGND VPWR VPWR _2518_ sky130_fd_sc_hd__and2_1
X_4946_ _1513_ _1514_ VGND VGND VPWR VPWR _1515_ sky130_fd_sc_hd__and2b_1
XTAP_TAPCELL_ROW_22_404 VGND VPWR sky130_fd_sc_hd__tapvpwrvgnd_1
X_4877_ u_interface.u_compute_core.relu_data\[13\] _0656_ VGND VGND VPWR VPWR _1447_
+ sky130_fd_sc_hd__nand2_4
XFILLER_0_34_317 VGND VGND VPWR VPWR sky130_fd_sc_hd__decap_8
X_3828_ _0418_ _0419_ VGND VGND VPWR VPWR _0421_ sky130_fd_sc_hd__and2_1
XFILLER_0_27_391 VGND VGND VPWR VPWR sky130_fd_sc_hd__fill_1
XTAP_TAPCELL_ROW_30_481 VGND VPWR sky130_fd_sc_hd__tapvpwrvgnd_1
XFILLER_0_61_147 VGND VGND VPWR VPWR sky130_fd_sc_hd__fill_2
XFILLER_0_61_169 VGND VGND VPWR VPWR sky130_fd_sc_hd__decap_4
X_3759_ _0311_ _0353_ VGND VGND VPWR VPWR _0354_ sky130_fd_sc_hd__xnor2_1
XFILLER_0_30_545 VGND VGND VPWR VPWR sky130_fd_sc_hd__fill_2
X_5429_ _1957_ _1902_ _1991_ VGND VGND VPWR VPWR _1992_ sky130_fd_sc_hd__a21oi_1
XFILLER_0_69_225 VGND VGND VPWR VPWR sky130_fd_sc_hd__decap_8
XFILLER_0_65_497 VGND VGND VPWR VPWR sky130_fd_sc_hd__fill_1
XFILLER_0_20_49 VGND VGND VPWR VPWR sky130_fd_sc_hd__fill_2
XFILLER_0_0_406 VGND VGND VPWR VPWR sky130_fd_sc_hd__decap_3
XFILLER_0_88_501 VPWR VGND VPWR VGND sky130_ef_sc_hd__decap_12
XTAP_TAPCELL_ROW_88_1037 VGND VPWR sky130_fd_sc_hd__tapvpwrvgnd_1
XFILLER_0_45_46 VGND VGND VPWR VPWR sky130_fd_sc_hd__fill_1
XTAP_TAPCELL_ROW_64_805 VGND VPWR sky130_fd_sc_hd__tapvpwrvgnd_1
XFILLER_0_45_57 VGND VGND VPWR VPWR sky130_fd_sc_hd__fill_1
XFILLER_0_88_545 VGND VGND VPWR VPWR sky130_fd_sc_hd__fill_2
XFILLER_0_0_15 VPWR VGND VPWR VGND sky130_ef_sc_hd__decap_12
X_4800_ _1369_ _1370_ VGND VGND VPWR VPWR _1371_ sky130_fd_sc_hd__or2_1
XFILLER_0_75_239 VGND VGND VPWR VPWR sky130_fd_sc_hd__decap_4
XTAP_TAPCELL_ROW_72_882 VGND VPWR sky130_fd_sc_hd__tapvpwrvgnd_1
XFILLER_0_68_291 VGND VGND VPWR VPWR sky130_fd_sc_hd__decap_6
X_5780_ _2320_ _2332_ _2333_ _2327_ VGND VGND VPWR VPWR _0142_ sky130_fd_sc_hd__o211a_1
XFILLER_0_56_442 VGND VGND VPWR VPWR sky130_fd_sc_hd__fill_1
X_4731_ _1300_ _1301_ _1279_ _1237_ VGND VGND VPWR VPWR _1303_ sky130_fd_sc_hd__o211a_1
XFILLER_0_83_261 VGND VGND VPWR VPWR sky130_fd_sc_hd__fill_1
X_4662_ _1229_ _1234_ VGND VGND VPWR VPWR _1235_ sky130_fd_sc_hd__xor2_1
XFILLER_0_43_125 VGND VGND VPWR VPWR sky130_fd_sc_hd__fill_2
XFILLER_0_71_445 VGND VGND VPWR VPWR sky130_fd_sc_hd__decap_3
XFILLER_0_9_57 VGND VGND VPWR VPWR sky130_fd_sc_hd__decap_4
X_3613_ _0210_ VGND VGND VPWR VPWR _0211_ sky130_fd_sc_hd__inv_2
X_4593_ _1138_ _1166_ VGND VGND VPWR VPWR _1167_ sky130_fd_sc_hd__or2_4
XFILLER_0_24_350 VGND VGND VPWR VPWR sky130_fd_sc_hd__fill_1
XFILLER_0_12_545 VGND VGND VPWR VPWR sky130_fd_sc_hd__fill_2
XFILLER_0_10_82 VGND VGND VPWR VPWR sky130_fd_sc_hd__fill_2
X_3544_ _2936_ net5 _2970_ _2931_ VGND VGND VPWR VPWR _2983_ sky130_fd_sc_hd__a22oi_1
X_6263_ clknet_leaf_16_clk _0176_ VGND VGND VPWR VPWR net54 sky130_fd_sc_hd__dfxtp_1
X_3475_ _2911_ _2915_ _2914_ _2909_ VGND VGND VPWR VPWR _2921_ sky130_fd_sc_hd__o211a_1
XFILLER_0_86_53 VGND VGND VPWR VPWR sky130_fd_sc_hd__decap_8
X_5214_ _1776_ _1779_ VGND VGND VPWR VPWR _1780_ sky130_fd_sc_hd__xor2_1
X_6194_ clknet_leaf_10_clk _0107_ VGND VGND VPWR VPWR u_interface.u_compute_core.relu_valid
+ sky130_fd_sc_hd__dfxtp_2
XFILLER_0_36_3 VGND VGND VPWR VPWR sky130_fd_sc_hd__decap_8
X_5145_ _1702_ _1709_ net81 _1632_ _1710_ VGND VGND VPWR VPWR _1711_ sky130_fd_sc_hd__o221a_1
X_5076_ _1570_ _1588_ _1589_ VGND VGND VPWR VPWR _1643_ sky130_fd_sc_hd__or3b_1
X_4027_ net64 _0602_ VGND VGND VPWR VPWR _0610_ sky130_fd_sc_hd__nand2_1
XFILLER_0_79_545 VGND VGND VPWR VPWR sky130_fd_sc_hd__fill_2
X_5978_ _2502_ _2505_ _2581_ VGND VGND VPWR VPWR _2506_ sky130_fd_sc_hd__a21oi_1
XFILLER_0_19_111 VGND VGND VPWR VPWR sky130_fd_sc_hd__fill_1
X_4929_ _1418_ _1494_ _1496_ _1497_ VGND VGND VPWR VPWR _1498_ sky130_fd_sc_hd__a31o_1
XFILLER_0_19_188 VGND VGND VPWR VPWR sky130_fd_sc_hd__decap_4
XFILLER_0_47_497 VGND VGND VPWR VPWR sky130_fd_sc_hd__decap_6
XTAP_TAPCELL_ROW_7_265 VGND VPWR sky130_fd_sc_hd__tapvpwrvgnd_1
XFILLER_0_65_250 VGND VGND VPWR VPWR sky130_fd_sc_hd__decap_8
XFILLER_0_31_15 VPWR VGND VPWR VGND sky130_ef_sc_hd__decap_12
XFILLER_0_65_272 VGND VGND VPWR VPWR sky130_fd_sc_hd__fill_1
XFILLER_0_38_497 VGND VGND VPWR VPWR sky130_fd_sc_hd__fill_2
XFILLER_0_53_412 VPWR VGND VPWR VGND sky130_ef_sc_hd__decap_12
XTAP_TAPCELL_ROW_41_587 VGND VPWR sky130_fd_sc_hd__tapvpwrvgnd_1
XFILLER_0_80_275 VGND VGND VPWR VPWR sky130_fd_sc_hd__decap_8
XFILLER_0_0_203 VPWR VGND VPWR VGND sky130_ef_sc_hd__decap_12
XFILLER_0_33_180 VGND VGND VPWR VPWR sky130_fd_sc_hd__decap_3
XFILLER_0_0_225 VPWR VGND VPWR VGND sky130_ef_sc_hd__decap_12
X_3260_ _2736_ _2582_ VGND VGND VPWR VPWR _0058_ sky130_fd_sc_hd__nor2_1
X_3191_ u_interface.u_compute_core.scaled_data\[8\] u_interface.u_compute_core.mac_accum\[11\]
+ _2669_ VGND VGND VPWR VPWR _2689_ sky130_fd_sc_hd__mux2_1
XTAP_TAPCELL_ROW_77_930 VGND VPWR sky130_fd_sc_hd__tapvpwrvgnd_1
XTAP_TAPCELL_ROW_49_665 VGND VPWR sky130_fd_sc_hd__tapvpwrvgnd_1
X_5901_ _2428_ _2432_ _2437_ VGND VGND VPWR VPWR _2439_ sky130_fd_sc_hd__a21bo_1
XFILLER_0_72_66 VGND VGND VPWR VPWR sky130_fd_sc_hd__fill_2
X_5832_ _2376_ _2377_ _2319_ VGND VGND VPWR VPWR _2379_ sky130_fd_sc_hd__a21o_1
X_5763_ u_interface.u_compute_core.u_av.valid_a VGND VGND VPWR VPWR _2318_ sky130_fd_sc_hd__inv_2
XFILLER_0_91_529 VPWR VGND VPWR VGND sky130_ef_sc_hd__decap_12
X_4714_ _1283_ _1284_ _1280_ VGND VGND VPWR VPWR _1286_ sky130_fd_sc_hd__a21o_1
XFILLER_0_8_358 VGND VGND VPWR VPWR sky130_fd_sc_hd__fill_1
XFILLER_0_16_125 VGND VGND VPWR VPWR sky130_fd_sc_hd__decap_6
XFILLER_0_16_147 VGND VGND VPWR VPWR sky130_fd_sc_hd__decap_4
XFILLER_0_44_434 VGND VGND VPWR VPWR sky130_fd_sc_hd__decap_8
X_5694_ _2238_ _2237_ VGND VGND VPWR VPWR _2253_ sky130_fd_sc_hd__and2b_1
X_4645_ net114 u_interface.u_compute_core.relu_data\[12\] net22 net23 VGND VGND VPWR
+ VPWR _1218_ sky130_fd_sc_hd__and4_1
XPHY_EDGE_ROW_15_Left_108 VGND VGND VPWR VPWR sky130_fd_sc_hd__decap_3
XFILLER_0_4_531 VGND VGND VPWR VPWR sky130_fd_sc_hd__fill_1
XFILLER_0_21_70 VGND VGND VPWR VPWR sky130_fd_sc_hd__decap_6
X_4576_ _1148_ _1144_ _1149_ VGND VGND VPWR VPWR _1150_ sky130_fd_sc_hd__and3_1
X_3527_ _2950_ _2965_ VGND VGND VPWR VPWR _2967_ sky130_fd_sc_hd__or2_1
XFILLER_0_12_353 VGND VGND VPWR VPWR sky130_fd_sc_hd__decap_4
XFILLER_0_24_191 VGND VGND VPWR VPWR sky130_fd_sc_hd__decap_4
X_3458_ net187 _2805_ _2905_ _2906_ VGND VGND VPWR VPWR _0086_ sky130_fd_sc_hd__a22o_1
X_6246_ clknet_leaf_12_clk _0159_ VGND VGND VPWR VPWR u_interface.core_attn_out\[21\]
+ sky130_fd_sc_hd__dfxtp_1
X_6177_ clknet_leaf_21_clk _0090_ VGND VGND VPWR VPWR u_interface.u_compute_core.mac_accum\[31\]
+ sky130_fd_sc_hd__dfxtp_1
X_3389_ _2846_ _2847_ net213 _2756_ VGND VGND VPWR VPWR _0076_ sky130_fd_sc_hd__a2bb2o_1
X_5128_ _1642_ _1619_ _1693_ _1694_ VGND VGND VPWR VPWR _1695_ sky130_fd_sc_hd__a211oi_1
XTAP_TAPCELL_ROW_4_235 VGND VPWR sky130_fd_sc_hd__tapvpwrvgnd_1
XPHY_EDGE_ROW_24_Left_117 VGND VGND VPWR VPWR sky130_fd_sc_hd__decap_3
X_5059_ _1625_ _1626_ VGND VGND VPWR VPWR _1627_ sky130_fd_sc_hd__xor2_2
XTAP_TAPCELL_ROW_83_988 VGND VPWR sky130_fd_sc_hd__tapvpwrvgnd_1
XFILLER_0_67_537 VGND VGND VPWR VPWR sky130_fd_sc_hd__decap_8
XFILLER_0_1_80 VGND VGND VPWR VPWR sky130_fd_sc_hd__fill_2
XPHY_EDGE_ROW_33_Left_126 VGND VGND VPWR VPWR sky130_fd_sc_hd__decap_3
XFILLER_0_35_445 VGND VGND VPWR VPWR sky130_fd_sc_hd__decap_3
XFILLER_0_62_242 VGND VGND VPWR VPWR sky130_fd_sc_hd__decap_8
XFILLER_0_50_415 VGND VGND VPWR VPWR sky130_fd_sc_hd__decap_4
XFILLER_0_50_437 VGND VGND VPWR VPWR sky130_fd_sc_hd__decap_8
XPHY_EDGE_ROW_42_Left_135 VGND VGND VPWR VPWR sky130_fd_sc_hd__decap_3
XFILLER_0_89_117 VGND VGND VPWR VPWR sky130_fd_sc_hd__fill_1
XTAP_TAPCELL_ROW_74_900 VGND VPWR sky130_fd_sc_hd__tapvpwrvgnd_1
Xhold71 net55 VGND VGND VPWR VPWR net136 sky130_fd_sc_hd__dlygate4sd3_1
Xhold82 u_interface.u_compute_core.u_mac.product_reg\[4\] VGND VGND VPWR VPWR net147
+ sky130_fd_sc_hd__dlygate4sd3_1
XTAP_TAPCELL_ROW_85_1007 VGND VPWR sky130_fd_sc_hd__tapvpwrvgnd_1
Xhold93 u_interface.u_compute_core.u_av.product_reg\[7\] VGND VGND VPWR VPWR net158
+ sky130_fd_sc_hd__dlygate4sd3_1
XTAP_TAPCELL_ROW_46_635 VGND VPWR sky130_fd_sc_hd__tapvpwrvgnd_1
XFILLER_0_85_323 VGND VGND VPWR VPWR sky130_fd_sc_hd__fill_1
XFILLER_0_85_334 VGND VGND VPWR VPWR sky130_fd_sc_hd__fill_2
XFILLER_0_85_367 VGND VGND VPWR VPWR sky130_fd_sc_hd__decap_8
XFILLER_0_73_529 VPWR VGND VPWR VGND sky130_ef_sc_hd__decap_12
XFILLER_0_38_261 VGND VGND VPWR VPWR sky130_fd_sc_hd__decap_3
XPHY_EDGE_ROW_51_Left_144 VGND VGND VPWR VPWR sky130_fd_sc_hd__decap_3
XFILLER_0_5_317 VPWR VGND VPWR VGND sky130_ef_sc_hd__decap_12
XFILLER_0_53_220 VGND VGND VPWR VPWR sky130_fd_sc_hd__fill_1
X_4430_ _0937_ _1005_ VGND VGND VPWR VPWR _1006_ sky130_fd_sc_hd__xnor2_2
X_6100_ clknet_leaf_6_clk _0013_ VGND VGND VPWR VPWR u_interface.u_compute_core.relu_data\[13\]
+ sky130_fd_sc_hd__dfxtp_1
X_4361_ _0920_ _0936_ VGND VGND VPWR VPWR _0938_ sky130_fd_sc_hd__nand2_1
X_4292_ _0861_ _0869_ VGND VGND VPWR VPWR _0870_ sky130_fd_sc_hd__xnor2_1
XFILLER_0_67_55 VGND VGND VPWR VPWR sky130_fd_sc_hd__fill_1
XFILLER_0_21_194 VPWR VGND VPWR VGND sky130_ef_sc_hd__decap_12
X_3312_ _2740_ VGND VGND VPWR VPWR _2781_ sky130_fd_sc_hd__clkbuf_4
XPHY_EDGE_ROW_60_Left_153 VGND VGND VPWR VPWR sky130_fd_sc_hd__decap_3
X_6031_ net32 u_interface.core_attn_out\[13\] _2521_ VGND VGND VPWR VPWR _2542_ sky130_fd_sc_hd__mux2_1
X_3243_ u_interface.u_compute_core.scaled_data\[24\] u_interface.u_compute_core.mac_accum\[27\]
+ _2713_ VGND VGND VPWR VPWR _2725_ sky130_fd_sc_hd__mux2_1
XTAP_TAPCELL_ROW_1_205 VGND VPWR sky130_fd_sc_hd__tapvpwrvgnd_1
X_3174_ _2672_ _2677_ VGND VGND VPWR VPWR _2678_ sky130_fd_sc_hd__and2_1
Xrebuffer36 _1174_ VGND VGND VPWR VPWR net101 sky130_fd_sc_hd__clkbuf_2
Xrebuffer25 _1025_ VGND VGND VPWR VPWR net90 sky130_fd_sc_hd__dlygate4sd1_1
Xrebuffer14 net78 VGND VGND VPWR VPWR net79 sky130_fd_sc_hd__dlygate4sd1_1
Xrebuffer47 _1174_ VGND VGND VPWR VPWR net112 sky130_fd_sc_hd__clkbuf_1
XFILLER_0_16_70 VGND VGND VPWR VPWR sky130_fd_sc_hd__decap_4
XFILLER_0_16_92 VGND VGND VPWR VPWR sky130_fd_sc_hd__fill_2
XTAP_TAPCELL_ROW_80_958 VGND VPWR sky130_fd_sc_hd__tapvpwrvgnd_1
XFILLER_0_76_378 VPWR VGND VPWR VGND sky130_ef_sc_hd__decap_12
XFILLER_0_76_356 VGND VGND VPWR VPWR sky130_fd_sc_hd__fill_1
X_5815_ _2355_ _2360_ _2363_ VGND VGND VPWR VPWR _2364_ sky130_fd_sc_hd__a21oi_1
XFILLER_0_36_209 VPWR VGND VPWR VGND sky130_ef_sc_hd__decap_12
XFILLER_0_91_337 VGND VGND VPWR VPWR sky130_fd_sc_hd__decap_8
XFILLER_0_8_133 VGND VGND VPWR VPWR sky130_fd_sc_hd__decap_6
XFILLER_0_8_177 VGND VGND VPWR VPWR sky130_fd_sc_hd__fill_1
XFILLER_0_8_166 VGND VGND VPWR VPWR sky130_fd_sc_hd__fill_2
X_5746_ _2302_ _2303_ VGND VGND VPWR VPWR _0138_ sky130_fd_sc_hd__nor2_1
X_5677_ _2234_ _2236_ VGND VGND VPWR VPWR _2237_ sky130_fd_sc_hd__xnor2_1
X_4628_ _1198_ _1199_ _1200_ VGND VGND VPWR VPWR _1201_ sky130_fd_sc_hd__nand3_1
X_4559_ _1130_ _1131_ _0812_ VGND VGND VPWR VPWR _1133_ sky130_fd_sc_hd__a21o_1
X_6229_ clknet_leaf_15_clk _0142_ VGND VGND VPWR VPWR u_interface.core_attn_out\[4\]
+ sky130_fd_sc_hd__dfxtp_1
XTAP_TAPCELL_ROW_43_605 VGND VPWR sky130_fd_sc_hd__tapvpwrvgnd_1
XFILLER_0_82_348 VGND VGND VPWR VPWR sky130_fd_sc_hd__decap_4
XTAP_TAPCELL_ROW_51_682 VGND VPWR sky130_fd_sc_hd__tapvpwrvgnd_1
XFILLER_0_35_275 VGND VGND VPWR VPWR sky130_fd_sc_hd__decap_4
XFILLER_0_2_309 VPWR VGND VPWR VGND sky130_ef_sc_hd__decap_12
XFILLER_0_50_267 VGND VGND VPWR VPWR sky130_fd_sc_hd__fill_1
XFILLER_0_50_278 VGND VGND VPWR VPWR sky130_fd_sc_hd__decap_6
Xoutput61 net61 VGND VGND VPWR VPWR s_tready sky130_fd_sc_hd__buf_2
Xoutput50 net50 VGND VGND VPWR VPWR m_tdata[2] sky130_fd_sc_hd__buf_2
XTAP_TAPCELL_ROW_91_1066 VGND VPWR sky130_fd_sc_hd__tapvpwrvgnd_1
XFILLER_0_37_25 VGND VGND VPWR VPWR sky130_fd_sc_hd__fill_2
XTAP_TAPCELL_ROW_59_760 VGND VPWR sky130_fd_sc_hd__tapvpwrvgnd_1
X_3930_ _2593_ _0515_ _0516_ VGND VGND VPWR VPWR _0517_ sky130_fd_sc_hd__a21o_1
XFILLER_0_58_345 VPWR VGND VPWR VGND sky130_ef_sc_hd__decap_12
X_3861_ _0448_ _0446_ VGND VGND VPWR VPWR _0452_ sky130_fd_sc_hd__and2b_1
XFILLER_0_85_197 VGND VGND VPWR VPWR sky130_fd_sc_hd__decap_6
XFILLER_0_73_337 VGND VGND VPWR VPWR sky130_fd_sc_hd__decap_4
X_5600_ _1593_ _2160_ VGND VGND VPWR VPWR _2161_ sky130_fd_sc_hd__xnor2_2
X_3792_ _0383_ _0384_ VGND VGND VPWR VPWR _0386_ sky130_fd_sc_hd__and2_1
X_5531_ _1992_ _2007_ VGND VGND VPWR VPWR _2093_ sky130_fd_sc_hd__or2_1
XFILLER_0_5_125 VPWR VGND VPWR VGND sky130_ef_sc_hd__decap_12
XFILLER_0_26_242 VGND VGND VPWR VPWR sky130_fd_sc_hd__decap_8
XFILLER_0_26_253 VGND VGND VPWR VPWR sky130_fd_sc_hd__decap_3
XFILLER_0_5_169 VPWR VGND VPWR VGND sky130_ef_sc_hd__decap_12
XFILLER_0_41_245 VGND VGND VPWR VPWR sky130_fd_sc_hd__fill_2
X_5462_ _1042_ _2024_ VGND VGND VPWR VPWR _2025_ sky130_fd_sc_hd__xnor2_1
X_4413_ _2611_ _0625_ _0594_ VGND VGND VPWR VPWR _0989_ sky130_fd_sc_hd__and3_1
X_5393_ _1869_ _1881_ VGND VGND VPWR VPWR _1956_ sky130_fd_sc_hd__and2b_1
XFILLER_0_78_98 VGND VGND VPWR VPWR sky130_fd_sc_hd__fill_1
X_4344_ _0612_ _0596_ VGND VGND VPWR VPWR _0921_ sky130_fd_sc_hd__nand2_1
X_6014_ _2530_ VGND VGND VPWR VPWR _0179_ sky130_fd_sc_hd__clkbuf_1
X_4275_ net134 _0850_ net98 _0521_ VGND VGND VPWR VPWR _0854_ sky130_fd_sc_hd__o31ai_1
X_3226_ u_interface.u_compute_core.mac_last VGND VGND VPWR VPWR _2713_ sky130_fd_sc_hd__clkbuf_4
X_3157_ u_interface.u_compute_core.scaled_data\[26\] _2583_ _2665_ _2586_ VGND VGND
+ VPWR VPWR _2666_ sky130_fd_sc_hd__o2bb2a_1
XFILLER_0_68_109 VGND VGND VPWR VPWR sky130_fd_sc_hd__fill_1
X_3088_ _2609_ _2614_ VGND VGND VPWR VPWR _0008_ sky130_fd_sc_hd__nor2_1
XFILLER_0_76_153 VGND VGND VPWR VPWR sky130_fd_sc_hd__fill_1
XFILLER_0_49_389 VGND VGND VPWR VPWR sky130_fd_sc_hd__decap_3
XFILLER_0_17_220 VGND VGND VPWR VPWR sky130_fd_sc_hd__decap_4
XFILLER_0_91_167 VGND VGND VPWR VPWR sky130_fd_sc_hd__fill_1
XFILLER_0_9_497 VGND VGND VPWR VPWR sky130_fd_sc_hd__decap_6
X_5729_ _2284_ _2287_ VGND VGND VPWR VPWR _2288_ sky130_fd_sc_hd__xnor2_1
XFILLER_0_17_275 VGND VGND VPWR VPWR sky130_fd_sc_hd__decap_4
XTAP_TAPCELL_ROW_20_387 VGND VPWR sky130_fd_sc_hd__tapvpwrvgnd_1
XTAP_TAPCELL_ROW_56_730 VGND VPWR sky130_fd_sc_hd__tapvpwrvgnd_1
XFILLER_0_59_109 VGND VGND VPWR VPWR sky130_fd_sc_hd__decap_3
XTAP_TAPCELL_ROW_28_465 VGND VPWR sky130_fd_sc_hd__tapvpwrvgnd_1
XFILLER_0_67_153 VGND VGND VPWR VPWR sky130_fd_sc_hd__fill_1
XFILLER_0_82_134 VGND VGND VPWR VPWR sky130_fd_sc_hd__decap_6
XFILLER_0_70_307 VGND VGND VPWR VPWR sky130_fd_sc_hd__fill_1
Xrebuffer5 net69 VGND VGND VPWR VPWR net70 sky130_fd_sc_hd__dlymetal6s2s_1
XFILLER_0_11_407 VPWR VGND VPWR VGND sky130_ef_sc_hd__decap_12
XFILLER_0_48_79 VGND VGND VPWR VPWR sky130_fd_sc_hd__decap_4
XFILLER_0_3_15 VPWR VGND VPWR VGND sky130_ef_sc_hd__decap_12
X_4060_ _0487_ _0597_ _0593_ _0642_ VGND VGND VPWR VPWR _0643_ sky130_fd_sc_hd__a31oi_2
X_4962_ _1520_ _1529_ _1530_ VGND VGND VPWR VPWR _1531_ sky130_fd_sc_hd__nand3_1
X_4893_ _1460_ _1461_ _1441_ VGND VGND VPWR VPWR _1463_ sky130_fd_sc_hd__o21ai_1
X_3913_ _0499_ VGND VGND VPWR VPWR _0500_ sky130_fd_sc_hd__clkbuf_4
XFILLER_0_80_88 VPWR VGND VPWR VGND sky130_ef_sc_hd__decap_12
X_3844_ _0434_ _0435_ VGND VGND VPWR VPWR _0436_ sky130_fd_sc_hd__nand2_1
XTAP_TAPCELL_ROW_62_788 VGND VPWR sky130_fd_sc_hd__tapvpwrvgnd_1
XFILLER_0_73_167 VGND VGND VPWR VPWR sky130_fd_sc_hd__fill_1
XFILLER_0_13_93 VGND VGND VPWR VPWR sky130_fd_sc_hd__decap_6
XFILLER_0_6_445 VPWR VGND VPWR VGND sky130_ef_sc_hd__decap_12
X_3775_ _2945_ _2970_ VGND VGND VPWR VPWR _0369_ sky130_fd_sc_hd__or2_1
XFILLER_0_6_489 VPWR VGND VPWR VGND sky130_ef_sc_hd__decap_12
X_5514_ _2038_ _2039_ _2074_ _2075_ VGND VGND VPWR VPWR _2076_ sky130_fd_sc_hd__o211a_1
X_5445_ _1992_ _1993_ _2006_ VGND VGND VPWR VPWR _2008_ sky130_fd_sc_hd__o21a_1
XFILLER_0_66_3 VPWR VGND VPWR VGND sky130_ef_sc_hd__decap_12
X_5376_ _1938_ _1939_ VGND VGND VPWR VPWR _1940_ sky130_fd_sc_hd__nor2_1
XFILLER_0_10_451 VGND VGND VPWR VPWR sky130_fd_sc_hd__fill_2
X_4327_ _0902_ _0903_ _0904_ VGND VGND VPWR VPWR _0905_ sky130_fd_sc_hd__a21o_1
X_4258_ _0836_ _0834_ _0808_ VGND VGND VPWR VPWR _0837_ sky130_fd_sc_hd__and3_1
X_3209_ _2694_ _2701_ VGND VGND VPWR VPWR _2702_ sky130_fd_sc_hd__and2_1
X_4189_ _0672_ _0721_ _0767_ _0768_ VGND VGND VPWR VPWR _0769_ sky130_fd_sc_hd__nand4bb_2
XTAP_TAPCELL_ROW_53_700 VGND VPWR sky130_fd_sc_hd__tapvpwrvgnd_1
XFILLER_0_77_473 VGND VGND VPWR VPWR sky130_fd_sc_hd__decap_4
XTAP_TAPCELL_ROW_25_435 VGND VPWR sky130_fd_sc_hd__tapvpwrvgnd_1
XFILLER_0_37_315 VGND VGND VPWR VPWR sky130_fd_sc_hd__fill_2
XFILLER_0_92_421 VPWR VGND VPWR VGND sky130_ef_sc_hd__decap_12
XFILLER_0_77_495 VGND VGND VPWR VPWR sky130_fd_sc_hd__fill_1
XFILLER_0_64_112 VGND VGND VPWR VPWR sky130_fd_sc_hd__fill_2
XFILLER_0_52_307 VGND VGND VPWR VPWR sky130_fd_sc_hd__fill_1
XPHY_EDGE_ROW_16_Right_16 VGND VGND VPWR VPWR sky130_fd_sc_hd__decap_3
XFILLER_0_34_15 VGND VGND VPWR VPWR sky130_fd_sc_hd__fill_1
XFILLER_0_68_473 VGND VGND VPWR VPWR sky130_fd_sc_hd__decap_3
XFILLER_0_28_359 VGND VGND VPWR VPWR sky130_fd_sc_hd__decap_4
XFILLER_0_55_167 VGND VGND VPWR VPWR sky130_fd_sc_hd__fill_1
XFILLER_0_70_104 VGND VGND VPWR VPWR sky130_fd_sc_hd__decap_4
XFILLER_0_43_329 VGND VGND VPWR VPWR sky130_fd_sc_hd__fill_1
X_3560_ _2997_ _2998_ VGND VGND VPWR VPWR _2999_ sky130_fd_sc_hd__nand2_1
XPHY_EDGE_ROW_25_Right_25 VGND VGND VPWR VPWR sky130_fd_sc_hd__decap_3
X_5230_ _1793_ _1794_ VGND VGND VPWR VPWR _1795_ sky130_fd_sc_hd__xnor2_1
X_3491_ _2929_ _2930_ _2931_ _2928_ VGND VGND VPWR VPWR _2934_ sky130_fd_sc_hd__a22o_1
XFILLER_0_11_237 VPWR VGND VPWR VGND sky130_ef_sc_hd__decap_12
XFILLER_0_59_89 VGND VGND VPWR VPWR sky130_fd_sc_hd__fill_2
X_5161_ _1725_ _1726_ VGND VGND VPWR VPWR _1727_ sky130_fd_sc_hd__xnor2_1
X_5092_ _1656_ _1657_ _1655_ VGND VGND VPWR VPWR _1659_ sky130_fd_sc_hd__o21ai_1
X_4112_ _0487_ _0648_ _0664_ _0692_ VGND VGND VPWR VPWR _0693_ sky130_fd_sc_hd__a31o_1
XFILLER_0_75_66 VGND VGND VPWR VPWR sky130_fd_sc_hd__fill_1
X_4043_ u_interface.u_compute_core.relu_data\[3\] u_interface.u_compute_core.relu_data\[2\]
+ _0534_ _0625_ VGND VGND VPWR VPWR _0626_ sky130_fd_sc_hd__and4_1
XTAP_TAPCELL_ROW_67_836 VGND VPWR sky130_fd_sc_hd__tapvpwrvgnd_1
XPHY_EDGE_ROW_34_Right_34 VGND VGND VPWR VPWR sky130_fd_sc_hd__decap_3
X_5994_ net39 u_interface.core_attn_out\[1\] _2512_ VGND VGND VPWR VPWR _2517_ sky130_fd_sc_hd__mux2_1
X_4945_ _1430_ _1436_ _1427_ VGND VGND VPWR VPWR _1514_ sky130_fd_sc_hd__a21bo_1
XTAP_TAPCELL_ROW_22_405 VGND VPWR sky130_fd_sc_hd__tapvpwrvgnd_1
XFILLER_0_46_101 VGND VGND VPWR VPWR sky130_fd_sc_hd__fill_1
X_4876_ _1376_ _1378_ VGND VGND VPWR VPWR _1446_ sky130_fd_sc_hd__nand2_1
XFILLER_0_34_307 VGND VGND VPWR VPWR sky130_fd_sc_hd__fill_1
XFILLER_0_6_253 VPWR VGND VPWR VGND sky130_ef_sc_hd__decap_12
X_3827_ _0418_ _0419_ VGND VGND VPWR VPWR _0420_ sky130_fd_sc_hd__nor2_1
XPHY_EDGE_ROW_43_Right_43 VGND VGND VPWR VPWR sky130_fd_sc_hd__decap_3
X_3758_ _0351_ _0352_ VGND VGND VPWR VPWR _0353_ sky130_fd_sc_hd__nor2_1
XTAP_TAPCELL_ROW_30_482 VGND VPWR sky130_fd_sc_hd__tapvpwrvgnd_1
XFILLER_0_61_159 VGND VGND VPWR VPWR sky130_fd_sc_hd__decap_3
XFILLER_0_42_362 VGND VGND VPWR VPWR sky130_fd_sc_hd__fill_2
XFILLER_0_42_373 VPWR VGND VPWR VGND sky130_ef_sc_hd__decap_12
X_3689_ _2753_ _0284_ _0285_ VGND VGND VPWR VPWR _0286_ sky130_fd_sc_hd__or3_1
X_5428_ _1973_ _1990_ VGND VGND VPWR VPWR _1991_ sky130_fd_sc_hd__xnor2_1
X_5359_ _1920_ _1921_ _1907_ VGND VGND VPWR VPWR _1923_ sky130_fd_sc_hd__o21a_1
XPHY_EDGE_ROW_52_Right_52 VGND VGND VPWR VPWR sky130_fd_sc_hd__decap_3
XFILLER_0_69_237 VGND VGND VPWR VPWR sky130_fd_sc_hd__fill_1
XTAP_TAPCELL_ROW_38_560 VGND VPWR sky130_fd_sc_hd__tapvpwrvgnd_1
XFILLER_0_92_251 VGND VGND VPWR VPWR sky130_fd_sc_hd__fill_1
XFILLER_0_37_145 VGND VGND VPWR VPWR sky130_fd_sc_hd__fill_2
XPHY_EDGE_ROW_61_Right_61 VGND VGND VPWR VPWR sky130_fd_sc_hd__decap_3
XFILLER_0_52_137 VGND VGND VPWR VPWR sky130_fd_sc_hd__decap_3
XFILLER_0_33_373 VPWR VGND VPWR VGND sky130_ef_sc_hd__decap_12
XFILLER_0_21_524 VPWR VGND VPWR VGND sky130_ef_sc_hd__decap_12
XFILLER_0_29_15 VGND VGND VPWR VPWR sky130_fd_sc_hd__decap_6
XPHY_EDGE_ROW_70_Right_70 VGND VGND VPWR VPWR sky130_fd_sc_hd__decap_3
XTAP_TAPCELL_ROW_88_1038 VGND VPWR sky130_fd_sc_hd__tapvpwrvgnd_1
XFILLER_0_88_513 VPWR VGND VPWR VGND sky130_ef_sc_hd__decap_12
XTAP_TAPCELL_ROW_64_806 VGND VPWR sky130_fd_sc_hd__tapvpwrvgnd_1
XFILLER_0_45_69 VGND VGND VPWR VPWR sky130_fd_sc_hd__decap_8
XFILLER_0_0_27 VGND VGND VPWR VPWR sky130_fd_sc_hd__fill_1
XTAP_TAPCELL_ROW_72_883 VGND VPWR sky130_fd_sc_hd__tapvpwrvgnd_1
X_4730_ _1279_ _1237_ _1300_ _1301_ VGND VGND VPWR VPWR _1302_ sky130_fd_sc_hd__a211oi_4
X_4661_ _1230_ _1233_ VGND VGND VPWR VPWR _1234_ sky130_fd_sc_hd__xnor2_1
XFILLER_0_9_25 VGND VGND VPWR VPWR sky130_fd_sc_hd__decap_8
X_3612_ _2936_ net7 net6 net13 VGND VGND VPWR VPWR _0210_ sky130_fd_sc_hd__a22o_1
X_4592_ _1164_ _1165_ VGND VGND VPWR VPWR _1166_ sky130_fd_sc_hd__or2_4
X_3543_ net10 net7 VGND VGND VPWR VPWR _2982_ sky130_fd_sc_hd__nand2_1
X_6262_ clknet_leaf_16_clk _0175_ VGND VGND VPWR VPWR net53 sky130_fd_sc_hd__dfxtp_1
X_3474_ _2918_ _2919_ VGND VGND VPWR VPWR _2920_ sky130_fd_sc_hd__nand2_1
X_6193_ clknet_leaf_0_clk _0106_ VGND VGND VPWR VPWR u_interface.u_compute_core.u_mac.product_reg\[15\]
+ sky130_fd_sc_hd__dfxtp_2
X_5213_ _1777_ _1778_ VGND VGND VPWR VPWR _1779_ sky130_fd_sc_hd__nor2_1
XFILLER_0_86_98 VGND VGND VPWR VPWR sky130_fd_sc_hd__fill_1
X_5144_ net66 _1700_ VGND VGND VPWR VPWR _1710_ sky130_fd_sc_hd__nand2_1
X_5075_ _1539_ _1615_ _1616_ VGND VGND VPWR VPWR _1642_ sky130_fd_sc_hd__or3_1
XFILLER_0_79_502 VGND VGND VPWR VPWR sky130_fd_sc_hd__fill_2
XFILLER_0_29_3 VPWR VGND VPWR VGND sky130_ef_sc_hd__decap_12
X_4026_ _0604_ _0576_ VGND VGND VPWR VPWR _0609_ sky130_fd_sc_hd__or2b_1
XTAP_TAPCELL_ROW_35_530 VGND VPWR sky130_fd_sc_hd__tapvpwrvgnd_1
X_5977_ u_interface.u_compute_core.u_av.product_reg\[31\] _2503_ _2504_ _2318_ VGND
+ VGND VPWR VPWR _2505_ sky130_fd_sc_hd__a211o_1
XFILLER_0_59_281 VGND VGND VPWR VPWR sky130_fd_sc_hd__decap_8
X_4928_ _1418_ _1494_ VGND VGND VPWR VPWR _1497_ sky130_fd_sc_hd__nor2_1
XFILLER_0_74_240 VPWR VGND VPWR VGND sky130_ef_sc_hd__decap_12
XFILLER_0_19_167 VGND VGND VPWR VPWR sky130_fd_sc_hd__fill_1
X_4859_ _1426_ _1428_ VGND VGND VPWR VPWR _1429_ sky130_fd_sc_hd__xor2_1
XFILLER_0_42_170 VGND VGND VPWR VPWR sky130_fd_sc_hd__fill_1
XTAP_TAPCELL_ROW_7_266 VGND VPWR sky130_fd_sc_hd__tapvpwrvgnd_1
XFILLER_0_85_505 VPWR VGND VPWR VGND sky130_ef_sc_hd__decap_12
XFILLER_0_38_421 VGND VGND VPWR VPWR sky130_fd_sc_hd__decap_8
XFILLER_0_31_27 VGND VGND VPWR VPWR sky130_fd_sc_hd__decap_3
XFILLER_0_53_424 VGND VGND VPWR VPWR sky130_fd_sc_hd__decap_8
XTAP_TAPCELL_ROW_41_588 VGND VPWR sky130_fd_sc_hd__tapvpwrvgnd_1
XFILLER_0_53_479 VPWR VGND VPWR VGND sky130_ef_sc_hd__decap_12
XFILLER_0_80_298 VGND VGND VPWR VPWR sky130_fd_sc_hd__decap_6
XFILLER_0_0_237 VPWR VGND VPWR VGND sky130_ef_sc_hd__decap_12
XFILLER_0_0_215 VGND VGND VPWR VPWR sky130_fd_sc_hd__decap_4
X_3190_ _2688_ VGND VGND VPWR VPWR _0036_ sky130_fd_sc_hd__clkbuf_1
XTAP_TAPCELL_ROW_77_931 VGND VPWR sky130_fd_sc_hd__tapvpwrvgnd_1
XTAP_TAPCELL_ROW_49_666 VGND VPWR sky130_fd_sc_hd__tapvpwrvgnd_1
X_5900_ _2427_ _2437_ _2432_ VGND VGND VPWR VPWR _2438_ sky130_fd_sc_hd__or3b_1
XFILLER_0_88_365 VPWR VGND VPWR VGND sky130_ef_sc_hd__decap_12
X_5831_ _2376_ _2377_ VGND VGND VPWR VPWR _2378_ sky130_fd_sc_hd__nor2_1
XFILLER_0_29_421 VPWR VGND VPWR VGND sky130_ef_sc_hd__decap_12
X_5762_ net174 _2304_ _0981_ _2317_ VGND VGND VPWR VPWR _0140_ sky130_fd_sc_hd__o211a_1
XTAP_TAPCELL_ROW_32_500 VGND VPWR sky130_fd_sc_hd__tapvpwrvgnd_1
X_4713_ _1280_ _1283_ _1284_ VGND VGND VPWR VPWR _1285_ sky130_fd_sc_hd__and3_1
X_5693_ _2236_ _2234_ VGND VGND VPWR VPWR _2252_ sky130_fd_sc_hd__and2b_1
X_4644_ u_interface.u_compute_core.relu_data\[10\] _0632_ VGND VGND VPWR VPWR _1217_
+ sky130_fd_sc_hd__nand2_1
X_4575_ _1146_ _1147_ _1145_ VGND VGND VPWR VPWR _1149_ sky130_fd_sc_hd__o21ai_1
XFILLER_0_21_93 VGND VGND VPWR VPWR sky130_fd_sc_hd__decap_6
X_3526_ _2950_ _2965_ VGND VGND VPWR VPWR _2966_ sky130_fd_sc_hd__nand2_1
XFILLER_0_12_365 VGND VGND VPWR VPWR sky130_fd_sc_hd__fill_2
X_6245_ clknet_leaf_13_clk _0158_ VGND VGND VPWR VPWR u_interface.core_attn_out\[20\]
+ sky130_fd_sc_hd__dfxtp_1
X_3457_ _2903_ _2904_ _2754_ VGND VGND VPWR VPWR _2906_ sky130_fd_sc_hd__a21oi_1
X_6176_ clknet_leaf_21_clk _0089_ VGND VGND VPWR VPWR u_interface.u_compute_core.mac_accum\[30\]
+ sky130_fd_sc_hd__dfxtp_1
X_3388_ _2839_ _2843_ _2845_ _2754_ VGND VGND VPWR VPWR _2847_ sky130_fd_sc_hd__a31o_1
X_5127_ _1686_ _1687_ _1692_ VGND VGND VPWR VPWR _1694_ sky130_fd_sc_hd__o21a_1
XTAP_TAPCELL_ROW_4_236 VGND VPWR sky130_fd_sc_hd__tapvpwrvgnd_1
X_5058_ _1545_ _1547_ VGND VGND VPWR VPWR _1626_ sky130_fd_sc_hd__nor2_1
XPHY_EDGE_ROW_2_Right_2 VGND VGND VPWR VPWR sky130_fd_sc_hd__decap_3
X_4009_ _0591_ _0592_ VGND VGND VPWR VPWR _0593_ sky130_fd_sc_hd__xnor2_2
XFILLER_0_67_505 VGND VGND VPWR VPWR sky130_fd_sc_hd__decap_8
XTAP_TAPCELL_ROW_83_989 VGND VPWR sky130_fd_sc_hd__tapvpwrvgnd_1
XFILLER_0_35_457 VGND VGND VPWR VPWR sky130_fd_sc_hd__fill_2
XFILLER_0_22_107 VGND VGND VPWR VPWR sky130_fd_sc_hd__fill_1
Xhold72 _0177_ VGND VGND VPWR VPWR net137 sky130_fd_sc_hd__dlygate4sd3_1
Xhold83 u_interface.u_compute_core.u_mac.product_reg\[12\] VGND VGND VPWR VPWR net148
+ sky130_fd_sc_hd__dlygate4sd3_1
XTAP_TAPCELL_ROW_85_1008 VGND VPWR sky130_fd_sc_hd__tapvpwrvgnd_1
XTAP_TAPCELL_ROW_74_901 VGND VPWR sky130_fd_sc_hd__tapvpwrvgnd_1
Xhold94 u_interface.u_compute_core.mac_accum\[4\] VGND VGND VPWR VPWR net159 sky130_fd_sc_hd__dlygate4sd3_1
XTAP_TAPCELL_ROW_46_636 VGND VPWR sky130_fd_sc_hd__tapvpwrvgnd_1
XFILLER_0_81_541 VGND VGND VPWR VPWR sky130_fd_sc_hd__decap_6
XFILLER_0_5_329 VGND VGND VPWR VPWR sky130_fd_sc_hd__decap_6
XFILLER_0_41_449 VGND VGND VPWR VPWR sky130_fd_sc_hd__fill_1
X_4360_ _0920_ _0936_ VGND VGND VPWR VPWR _0937_ sky130_fd_sc_hd__or2_1
XFILLER_0_6_37 VGND VGND VPWR VPWR sky130_fd_sc_hd__fill_1
X_3311_ _2779_ _2780_ net161 _2756_ VGND VGND VPWR VPWR _0065_ sky130_fd_sc_hd__a2bb2o_1
X_4291_ _0867_ _0868_ VGND VGND VPWR VPWR _0869_ sky130_fd_sc_hd__or2b_1
XFILLER_0_67_78 VGND VGND VPWR VPWR sky130_fd_sc_hd__fill_1
X_6030_ _2541_ VGND VGND VPWR VPWR _0184_ sky130_fd_sc_hd__clkbuf_1
X_3242_ _2724_ VGND VGND VPWR VPWR _0052_ sky130_fd_sc_hd__clkbuf_1
X_3173_ u_interface.u_compute_core.scaled_data\[2\] u_interface.u_compute_core.mac_accum\[5\]
+ _2669_ VGND VGND VPWR VPWR _2677_ sky130_fd_sc_hd__mux2_1
XTAP_TAPCELL_ROW_1_206 VGND VPWR sky130_fd_sc_hd__tapvpwrvgnd_1
XFILLER_0_83_66 VGND VGND VPWR VPWR sky130_fd_sc_hd__fill_2
Xrebuffer15 _0962_ VGND VGND VPWR VPWR net80 sky130_fd_sc_hd__dlygate4sd1_1
Xrebuffer26 _0638_ VGND VGND VPWR VPWR net91 sky130_fd_sc_hd__dlymetal6s2s_1
Xrebuffer37 net112 VGND VGND VPWR VPWR net102 sky130_fd_sc_hd__clkbuf_1
Xrebuffer48 _1631_ VGND VGND VPWR VPWR net113 sky130_fd_sc_hd__dlygate4sd1_1
XFILLER_0_49_505 VGND VGND VPWR VPWR sky130_fd_sc_hd__decap_3
XTAP_TAPCELL_ROW_80_959 VGND VPWR sky130_fd_sc_hd__tapvpwrvgnd_1
XFILLER_0_8_112 VGND VGND VPWR VPWR sky130_fd_sc_hd__decap_3
X_5814_ _2361_ _2362_ VGND VGND VPWR VPWR _2363_ sky130_fd_sc_hd__nor2_1
XTAP_TAPCELL_ROW_17_360 VGND VPWR sky130_fd_sc_hd__tapvpwrvgnd_1
XFILLER_0_8_145 VGND VGND VPWR VPWR sky130_fd_sc_hd__fill_1
XFILLER_0_8_123 VGND VGND VPWR VPWR sky130_fd_sc_hd__fill_1
XFILLER_0_29_251 VGND VGND VPWR VPWR sky130_fd_sc_hd__decap_3
XFILLER_0_29_262 VGND VGND VPWR VPWR sky130_fd_sc_hd__decap_4
XFILLER_0_17_424 VGND VGND VPWR VPWR sky130_fd_sc_hd__decap_3
X_5745_ u_interface.core_attn_out\[0\] _2301_ u_interface.u_compute_core.u_av.product_reg\[3\]
+ net2 VGND VGND VPWR VPWR _2303_ sky130_fd_sc_hd__a31o_1
XFILLER_0_44_221 VGND VGND VPWR VPWR sky130_fd_sc_hd__decap_8
XFILLER_0_8_189 VGND VGND VPWR VPWR sky130_fd_sc_hd__decap_3
X_5676_ _2166_ _2171_ _2235_ VGND VGND VPWR VPWR _2236_ sky130_fd_sc_hd__o21ba_1
X_4627_ _1119_ _1127_ _1126_ VGND VGND VPWR VPWR _1200_ sky130_fd_sc_hd__a21bo_1
XFILLER_0_44_287 VGND VGND VPWR VPWR sky130_fd_sc_hd__decap_6
X_4558_ _0835_ _1130_ _1131_ VGND VGND VPWR VPWR _1132_ sky130_fd_sc_hd__nand3_1
X_4489_ _1061_ _1062_ _1063_ VGND VGND VPWR VPWR _1064_ sky130_fd_sc_hd__and3_1
X_3509_ _2928_ _2930_ _2936_ _2949_ VGND VGND VPWR VPWR _2950_ sky130_fd_sc_hd__nand4_2
X_6228_ clknet_leaf_17_clk _0141_ VGND VGND VPWR VPWR u_interface.core_attn_out\[3\]
+ sky130_fd_sc_hd__dfxtp_1
X_6159_ clknet_leaf_0_clk _0072_ VGND VGND VPWR VPWR u_interface.u_compute_core.mac_accum\[13\]
+ sky130_fd_sc_hd__dfxtp_1
XFILLER_0_67_335 VGND VGND VPWR VPWR sky130_fd_sc_hd__fill_1
XTAP_TAPCELL_ROW_43_606 VGND VPWR sky130_fd_sc_hd__tapvpwrvgnd_1
XFILLER_0_63_541 VGND VGND VPWR VPWR sky130_fd_sc_hd__decap_6
XFILLER_0_12_29 VGND VGND VPWR VPWR sky130_fd_sc_hd__decap_8
XFILLER_0_35_221 VGND VGND VPWR VPWR sky130_fd_sc_hd__decap_3
XTAP_TAPCELL_ROW_51_683 VGND VPWR sky130_fd_sc_hd__tapvpwrvgnd_1
XFILLER_0_35_243 VGND VGND VPWR VPWR sky130_fd_sc_hd__fill_1
XFILLER_0_90_371 VGND VGND VPWR VPWR sky130_fd_sc_hd__fill_1
XFILLER_0_23_449 VGND VGND VPWR VPWR sky130_fd_sc_hd__fill_2
Xoutput51 net51 VGND VGND VPWR VPWR m_tdata[30] sky130_fd_sc_hd__buf_2
Xoutput40 net40 VGND VGND VPWR VPWR m_tdata[20] sky130_fd_sc_hd__buf_2
XTAP_TAPCELL_ROW_91_1067 VGND VPWR sky130_fd_sc_hd__tapvpwrvgnd_1
XTAP_TAPCELL_ROW_59_761 VGND VPWR sky130_fd_sc_hd__tapvpwrvgnd_1
XFILLER_0_85_110 VGND VGND VPWR VPWR sky130_fd_sc_hd__fill_2
XFILLER_0_58_357 VGND VGND VPWR VPWR sky130_fd_sc_hd__decap_6
XTAP_TAPCELL_ROW_14_330 VGND VPWR sky130_fd_sc_hd__tapvpwrvgnd_1
X_3860_ _0450_ _0451_ net180 _2756_ VGND VGND VPWR VPWR _0104_ sky130_fd_sc_hd__a2bb2o_1
X_3791_ _0383_ _0384_ VGND VGND VPWR VPWR _0385_ sky130_fd_sc_hd__nor2_1
XFILLER_0_54_530 VGND VGND VPWR VPWR sky130_fd_sc_hd__fill_2
XFILLER_0_5_137 VGND VGND VPWR VPWR sky130_fd_sc_hd__fill_1
X_5530_ _2076_ _2077_ _2090_ VGND VGND VPWR VPWR _2092_ sky130_fd_sc_hd__o21ai_1
XFILLER_0_81_393 VGND VGND VPWR VPWR sky130_fd_sc_hd__fill_2
XFILLER_0_81_360 VPWR VGND VPWR VGND sky130_ef_sc_hd__decap_12
XFILLER_0_41_202 VGND VGND VPWR VPWR sky130_fd_sc_hd__fill_1
X_5461_ _2022_ _2023_ VGND VGND VPWR VPWR _2024_ sky130_fd_sc_hd__xor2_2
X_4412_ _0987_ VGND VGND VPWR VPWR _0988_ sky130_fd_sc_hd__clkbuf_2
X_5392_ _1904_ _1905_ _1922_ _1923_ VGND VGND VPWR VPWR _1955_ sky130_fd_sc_hd__or4_1
X_4343_ _2628_ _0515_ VGND VGND VPWR VPWR _0920_ sky130_fd_sc_hd__nand2_1
X_4274_ _0850_ net98 net134 VGND VGND VPWR VPWR _0853_ sky130_fd_sc_hd__o21a_1
X_6013_ _2516_ _2529_ VGND VGND VPWR VPWR _2530_ sky130_fd_sc_hd__and2_1
X_3225_ _2712_ VGND VGND VPWR VPWR _0047_ sky130_fd_sc_hd__clkbuf_1
X_3156_ u_interface.u_compute_core.relu_data\[26\] VGND VGND VPWR VPWR _2665_ sky130_fd_sc_hd__inv_2
Xclkbuf_leaf_19_clk clknet_1_1__leaf_clk VGND VGND VPWR VPWR clknet_leaf_19_clk sky130_fd_sc_hd__clkbuf_8
X_3087_ u_interface.u_compute_core.scaled_data\[8\] _2584_ _2612_ _2613_ VGND VGND
+ VPWR VPWR _2614_ sky130_fd_sc_hd__o2bb2a_1
XFILLER_0_11_3 VPWR VGND VPWR VGND sky130_ef_sc_hd__decap_12
XFILLER_0_76_121 VGND VGND VPWR VPWR sky130_fd_sc_hd__decap_3
XFILLER_0_9_421 VGND VGND VPWR VPWR sky130_fd_sc_hd__decap_4
XFILLER_0_91_113 VPWR VGND VPWR VGND sky130_ef_sc_hd__decap_12
X_3989_ _0567_ _0566_ VGND VGND VPWR VPWR _0573_ sky130_fd_sc_hd__or2b_1
X_5728_ _2285_ _2286_ VGND VGND VPWR VPWR _2287_ sky130_fd_sc_hd__xnor2_1
XFILLER_0_60_533 VPWR VGND VPWR VGND sky130_ef_sc_hd__decap_12
XTAP_TAPCELL_ROW_20_388 VGND VPWR sky130_fd_sc_hd__tapvpwrvgnd_1
X_5659_ _2148_ _2218_ _2161_ VGND VGND VPWR VPWR _2219_ sky130_fd_sc_hd__o21a_1
XFILLER_0_13_471 VGND VGND VPWR VPWR sky130_fd_sc_hd__fill_1
XFILLER_0_40_290 VGND VGND VPWR VPWR sky130_fd_sc_hd__fill_1
XTAP_TAPCELL_ROW_56_731 VGND VPWR sky130_fd_sc_hd__tapvpwrvgnd_1
XTAP_TAPCELL_ROW_28_466 VGND VPWR sky130_fd_sc_hd__tapvpwrvgnd_1
XFILLER_0_67_187 VGND VGND VPWR VPWR sky130_fd_sc_hd__fill_1
XTAP_TAPCELL_ROW_11_300 VGND VPWR sky130_fd_sc_hd__tapvpwrvgnd_1
XFILLER_0_63_393 VPWR VGND VPWR VGND sky130_ef_sc_hd__decap_12
XFILLER_0_2_129 VGND VGND VPWR VPWR sky130_fd_sc_hd__fill_1
Xrebuffer6 _0852_ VGND VGND VPWR VPWR net134 sky130_fd_sc_hd__dlygate4sd1_1
XFILLER_0_51_533 VPWR VGND VPWR VGND sky130_ef_sc_hd__decap_12
XFILLER_0_23_268 VGND VGND VPWR VPWR sky130_fd_sc_hd__fill_1
XFILLER_0_3_27 VPWR VGND VPWR VGND sky130_ef_sc_hd__decap_12
X_4961_ _1527_ _1528_ _1521_ VGND VGND VPWR VPWR _1530_ sky130_fd_sc_hd__a21o_1
XFILLER_0_58_121 VGND VGND VPWR VPWR sky130_fd_sc_hd__fill_1
X_4892_ _1441_ _1460_ _1461_ VGND VGND VPWR VPWR _1462_ sky130_fd_sc_hd__or3_4
XFILLER_0_86_474 VGND VGND VPWR VPWR sky130_fd_sc_hd__fill_2
XFILLER_0_80_45 VGND VGND VPWR VPWR sky130_fd_sc_hd__fill_1
X_3912_ _0498_ VGND VGND VPWR VPWR _0499_ sky130_fd_sc_hd__clkbuf_4
X_3843_ _0371_ _0433_ VGND VGND VPWR VPWR _0435_ sky130_fd_sc_hd__or2_1
XTAP_TAPCELL_ROW_62_789 VGND VPWR sky130_fd_sc_hd__tapvpwrvgnd_1
X_3774_ _0366_ _0367_ VGND VGND VPWR VPWR _0368_ sky130_fd_sc_hd__xnor2_1
XFILLER_0_6_457 VPWR VGND VPWR VGND sky130_ef_sc_hd__decap_12
XFILLER_0_42_500 VGND VGND VPWR VPWR sky130_fd_sc_hd__decap_8
XFILLER_0_42_511 VGND VGND VPWR VPWR sky130_fd_sc_hd__fill_2
XFILLER_0_42_533 VPWR VGND VPWR VGND sky130_ef_sc_hd__decap_12
X_5513_ _2059_ _2073_ VGND VGND VPWR VPWR _2075_ sky130_fd_sc_hd__or2_1
X_5444_ _1992_ _1993_ _2006_ VGND VGND VPWR VPWR _2007_ sky130_fd_sc_hd__nor3_1
Xclkbuf_leaf_8_clk clknet_1_0__leaf_clk VGND VGND VPWR VPWR clknet_leaf_8_clk sky130_fd_sc_hd__clkbuf_8
X_5375_ _1933_ _1934_ _1937_ VGND VGND VPWR VPWR _1939_ sky130_fd_sc_hd__o21ba_1
XFILLER_0_59_3 VPWR VGND VPWR VGND sky130_ef_sc_hd__decap_12
X_4326_ _0795_ _0810_ VGND VGND VPWR VPWR _0904_ sky130_fd_sc_hd__or2_1
X_4257_ _0833_ _0832_ _0835_ VGND VGND VPWR VPWR _0836_ sky130_fd_sc_hd__a21o_1
X_3208_ u_interface.u_compute_core.scaled_data\[13\] u_interface.u_compute_core.mac_accum\[16\]
+ _2691_ VGND VGND VPWR VPWR _2701_ sky130_fd_sc_hd__mux2_1
X_4188_ _0765_ _0766_ _0755_ VGND VGND VPWR VPWR _0768_ sky130_fd_sc_hd__a21o_1
X_3139_ u_interface.u_compute_core.relu_data\[21\] VGND VGND VPWR VPWR _2653_ sky130_fd_sc_hd__inv_2
XFILLER_0_49_110 VGND VGND VPWR VPWR sky130_fd_sc_hd__fill_2
XTAP_TAPCELL_ROW_53_701 VGND VPWR sky130_fd_sc_hd__tapvpwrvgnd_1
XTAP_TAPCELL_ROW_25_436 VGND VPWR sky130_fd_sc_hd__tapvpwrvgnd_1
XFILLER_0_92_433 VPWR VGND VPWR VGND sky130_ef_sc_hd__decap_12
XFILLER_0_64_135 VGND VGND VPWR VPWR sky130_fd_sc_hd__fill_1
XFILLER_0_37_349 VGND VGND VPWR VPWR sky130_fd_sc_hd__decap_3
XFILLER_0_92_477 VPWR VGND VPWR VGND sky130_ef_sc_hd__decap_12
XFILLER_0_18_530 VGND VGND VPWR VPWR sky130_fd_sc_hd__fill_2
XFILLER_0_45_393 VPWR VGND VPWR VGND sky130_ef_sc_hd__decap_12
XFILLER_0_0_3 VPWR VGND VPWR VGND sky130_ef_sc_hd__decap_12
XFILLER_0_34_27 VGND VGND VPWR VPWR sky130_fd_sc_hd__fill_1
XFILLER_0_50_15 VPWR VGND VPWR VGND sky130_ef_sc_hd__decap_12
XFILLER_0_55_113 VGND VGND VPWR VPWR sky130_fd_sc_hd__decap_3
XFILLER_0_24_511 VPWR VGND VPWR VGND sky130_ef_sc_hd__decap_12
XFILLER_0_55_179 VGND VGND VPWR VPWR sky130_fd_sc_hd__decap_4
XFILLER_0_3_405 VPWR VGND VPWR VGND sky130_ef_sc_hd__decap_12
XFILLER_0_24_533 VGND VGND VPWR VPWR sky130_fd_sc_hd__decap_8
XFILLER_0_3_449 VPWR VGND VPWR VGND sky130_ef_sc_hd__decap_12
X_3490_ _2928_ _2929_ _2932_ VGND VGND VPWR VPWR _2933_ sky130_fd_sc_hd__nand3_1
XFILLER_0_59_35 VGND VGND VPWR VPWR sky130_fd_sc_hd__fill_1
XFILLER_0_59_57 VGND VGND VPWR VPWR sky130_fd_sc_hd__decap_3
XFILLER_0_11_249 VPWR VGND VPWR VGND sky130_ef_sc_hd__decap_12
X_5160_ _2655_ _0500_ VGND VGND VPWR VPWR _1726_ sky130_fd_sc_hd__nand2_1
X_5091_ _1655_ _1656_ _1657_ VGND VGND VPWR VPWR _1658_ sky130_fd_sc_hd__or3_1
X_4111_ _0663_ _0662_ VGND VGND VPWR VPWR _0692_ sky130_fd_sc_hd__and2b_1
X_4042_ net22 VGND VGND VPWR VPWR _0625_ sky130_fd_sc_hd__clkbuf_4
XTAP_TAPCELL_ROW_67_837 VGND VPWR sky130_fd_sc_hd__tapvpwrvgnd_1
XFILLER_0_91_55 VGND VGND VPWR VPWR sky130_fd_sc_hd__fill_1
X_5993_ _2579_ VGND VGND VPWR VPWR _2516_ sky130_fd_sc_hd__clkbuf_2
X_4944_ _1506_ _1512_ VGND VGND VPWR VPWR _1513_ sky130_fd_sc_hd__xor2_1
XFILLER_0_74_400 VGND VGND VPWR VPWR sky130_fd_sc_hd__decap_8
XFILLER_0_19_327 VGND VGND VPWR VPWR sky130_fd_sc_hd__fill_1
XTAP_TAPCELL_ROW_22_406 VGND VPWR sky130_fd_sc_hd__tapvpwrvgnd_1
XFILLER_0_24_82 VGND VGND VPWR VPWR sky130_fd_sc_hd__fill_2
X_4875_ _1444_ VGND VGND VPWR VPWR _1445_ sky130_fd_sc_hd__buf_6
XFILLER_0_6_210 VGND VGND VPWR VPWR sky130_fd_sc_hd__decap_4
XFILLER_0_46_157 VGND VGND VPWR VPWR sky130_fd_sc_hd__fill_1
XFILLER_0_74_477 VGND VGND VPWR VPWR sky130_fd_sc_hd__decap_8
X_3826_ _0346_ _0387_ _0385_ VGND VGND VPWR VPWR _0419_ sky130_fd_sc_hd__a21oi_1
X_3757_ _0349_ _0350_ VGND VGND VPWR VPWR _0352_ sky130_fd_sc_hd__and2_1
XFILLER_0_6_265 VPWR VGND VPWR VGND sky130_ef_sc_hd__decap_12
XFILLER_0_27_393 VGND VGND VPWR VPWR sky130_fd_sc_hd__fill_1
XFILLER_0_42_330 VGND VGND VPWR VPWR sky130_fd_sc_hd__fill_2
XFILLER_0_54_190 VGND VGND VPWR VPWR sky130_fd_sc_hd__fill_1
XTAP_TAPCELL_ROW_30_483 VGND VPWR sky130_fd_sc_hd__tapvpwrvgnd_1
X_3688_ _0242_ _0246_ _0283_ VGND VGND VPWR VPWR _0285_ sky130_fd_sc_hd__a21oi_1
XFILLER_0_42_385 VGND VGND VPWR VPWR sky130_fd_sc_hd__decap_3
X_5427_ _1974_ _1989_ VGND VGND VPWR VPWR _1990_ sky130_fd_sc_hd__xnor2_1
X_5358_ _1907_ _1920_ _1921_ VGND VGND VPWR VPWR _1922_ sky130_fd_sc_hd__nor3_1
X_4309_ _0884_ _0885_ _0873_ VGND VGND VPWR VPWR _0887_ sky130_fd_sc_hd__a21o_1
X_5289_ _1853_ _1852_ VGND VGND VPWR VPWR _1854_ sky130_fd_sc_hd__nor2_2
XFILLER_0_4_81 VGND VGND VPWR VPWR sky130_fd_sc_hd__decap_3
XTAP_TAPCELL_ROW_38_561 VGND VPWR sky130_fd_sc_hd__tapvpwrvgnd_1
XFILLER_0_84_219 VGND VGND VPWR VPWR sky130_fd_sc_hd__decap_8
XFILLER_0_80_425 VGND VGND VPWR VPWR sky130_fd_sc_hd__decap_8
XFILLER_0_80_403 VPWR VGND VPWR VGND sky130_ef_sc_hd__decap_12
XFILLER_0_25_308 VGND VGND VPWR VPWR sky130_fd_sc_hd__fill_1
XFILLER_0_20_29 VPWR VGND VPWR VGND sky130_ef_sc_hd__decap_12
XFILLER_0_52_127 VGND VGND VPWR VPWR sky130_fd_sc_hd__fill_1
XFILLER_0_52_149 VPWR VGND VPWR VGND sky130_ef_sc_hd__decap_12
XFILLER_0_0_419 VGND VGND VPWR VPWR sky130_fd_sc_hd__fill_1
XFILLER_0_21_536 VGND VGND VPWR VPWR sky130_fd_sc_hd__decap_6
XFILLER_0_33_385 VGND VGND VPWR VPWR sky130_fd_sc_hd__fill_2
XFILLER_0_29_38 VGND VGND VPWR VPWR sky130_fd_sc_hd__fill_2
XTAP_TAPCELL_ROW_88_1039 VGND VPWR sky130_fd_sc_hd__tapvpwrvgnd_1
XFILLER_0_45_15 VPWR VGND VPWR VGND sky130_ef_sc_hd__decap_12
XFILLER_0_88_525 VGND VGND VPWR VPWR sky130_fd_sc_hd__decap_6
XTAP_TAPCELL_ROW_64_807 VGND VPWR sky130_fd_sc_hd__tapvpwrvgnd_1
XTAP_TAPCELL_ROW_72_884 VGND VPWR sky130_fd_sc_hd__tapvpwrvgnd_1
XFILLER_0_61_47 VGND VGND VPWR VPWR sky130_fd_sc_hd__fill_1
X_4660_ _1231_ _1232_ VGND VGND VPWR VPWR _1233_ sky130_fd_sc_hd__and2b_1
XFILLER_0_9_15 VGND VGND VPWR VPWR sky130_fd_sc_hd__decap_4
XFILLER_0_56_477 VPWR VGND VPWR VGND sky130_ef_sc_hd__decap_12
XFILLER_0_83_296 VPWR VGND VPWR VGND sky130_ef_sc_hd__decap_12
XFILLER_0_9_48 VGND VGND VPWR VPWR sky130_fd_sc_hd__decap_8
X_3611_ _3016_ _3022_ VGND VGND VPWR VPWR _0209_ sky130_fd_sc_hd__or2b_1
XFILLER_0_3_202 VGND VGND VPWR VPWR sky130_fd_sc_hd__fill_1
X_4591_ _1162_ _1163_ _1068_ VGND VGND VPWR VPWR _1165_ sky130_fd_sc_hd__o21a_1
XFILLER_0_24_363 VGND VGND VPWR VPWR sky130_fd_sc_hd__fill_1
X_3542_ _2980_ VGND VGND VPWR VPWR _2981_ sky130_fd_sc_hd__inv_2
XFILLER_0_10_62 VGND VGND VPWR VPWR sky130_fd_sc_hd__fill_1
XFILLER_0_24_396 VGND VGND VPWR VPWR sky130_fd_sc_hd__decap_6
XFILLER_0_3_279 VGND VGND VPWR VPWR sky130_fd_sc_hd__fill_1
X_3473_ _2834_ u_interface.u_compute_core.mac_accum\[30\] VGND VGND VPWR VPWR _2919_
+ sky130_fd_sc_hd__or2_1
X_6261_ clknet_leaf_17_clk _0174_ VGND VGND VPWR VPWR net50 sky130_fd_sc_hd__dfxtp_1
X_6192_ clknet_leaf_0_clk _0105_ VGND VGND VPWR VPWR u_interface.u_compute_core.u_mac.product_reg\[14\]
+ sky130_fd_sc_hd__dfxtp_1
X_5212_ _0982_ net116 VGND VGND VPWR VPWR _1778_ sky130_fd_sc_hd__nor2_1
X_5143_ net66 _1700_ VGND VGND VPWR VPWR _1709_ sky130_fd_sc_hd__nor2_1
XFILLER_0_19_82 VPWR VGND VPWR VGND sky130_ef_sc_hd__decap_12
X_5074_ _1639_ _1567_ _1640_ VGND VGND VPWR VPWR _1641_ sky130_fd_sc_hd__o21a_1
X_4025_ _0485_ net152 _0486_ _0608_ VGND VGND VPWR VPWR _0112_ sky130_fd_sc_hd__o211a_1
XTAP_TAPCELL_ROW_35_531 VGND VPWR sky130_fd_sc_hd__tapvpwrvgnd_1
X_5976_ u_interface.core_attn_out\[29\] _2496_ u_interface.u_compute_core.u_av.product_reg\[31\]
+ VGND VGND VPWR VPWR _2504_ sky130_fd_sc_hd__a21oi_1
XFILLER_0_19_113 VGND VGND VPWR VPWR sky130_fd_sc_hd__fill_1
XFILLER_0_47_400 VPWR VGND VPWR VGND sky130_ef_sc_hd__decap_12
X_4927_ _1416_ _1495_ VGND VGND VPWR VPWR _1496_ sky130_fd_sc_hd__nand2_1
X_4858_ _1209_ _0816_ VGND VGND VPWR VPWR _1428_ sky130_fd_sc_hd__nand2_1
XFILLER_0_7_541 VGND VGND VPWR VPWR sky130_fd_sc_hd__decap_6
XFILLER_0_34_105 VGND VGND VPWR VPWR sky130_fd_sc_hd__decap_6
X_3809_ _0399_ _0401_ VGND VGND VPWR VPWR _0402_ sky130_fd_sc_hd__nor2_1
X_4789_ _1306_ _1359_ VGND VGND VPWR VPWR _1360_ sky130_fd_sc_hd__xnor2_1
XFILLER_0_27_190 VGND VGND VPWR VPWR sky130_fd_sc_hd__fill_2
XTAP_TAPCELL_ROW_7_267 VGND VPWR sky130_fd_sc_hd__tapvpwrvgnd_1
XFILLER_0_85_517 VPWR VGND VPWR VGND sky130_ef_sc_hd__decap_12
XFILLER_0_57_219 VGND VGND VPWR VPWR sky130_fd_sc_hd__decap_4
XFILLER_0_38_477 VPWR VGND VPWR VGND sky130_ef_sc_hd__decap_12
XTAP_TAPCELL_ROW_41_589 VGND VPWR sky130_fd_sc_hd__tapvpwrvgnd_1
XFILLER_0_53_469 VGND VGND VPWR VPWR sky130_fd_sc_hd__fill_2
XFILLER_0_21_300 VPWR VGND VPWR VGND sky130_ef_sc_hd__decap_12
XFILLER_0_21_344 VGND VGND VPWR VPWR sky130_fd_sc_hd__fill_1
XFILLER_0_0_249 VGND VGND VPWR VPWR sky130_fd_sc_hd__decap_3
XTAP_TAPCELL_ROW_77_932 VGND VPWR sky130_fd_sc_hd__tapvpwrvgnd_1
XTAP_TAPCELL_ROW_49_667 VGND VPWR sky130_fd_sc_hd__tapvpwrvgnd_1
XFILLER_0_88_344 VGND VGND VPWR VPWR sky130_fd_sc_hd__decap_8
X_5830_ _2368_ _2371_ _2367_ VGND VGND VPWR VPWR _2377_ sky130_fd_sc_hd__o21a_1
XFILLER_0_8_327 VGND VGND VPWR VPWR sky130_fd_sc_hd__fill_1
X_5761_ _2315_ _2316_ _2309_ VGND VGND VPWR VPWR _2317_ sky130_fd_sc_hd__o21ai_1
XFILLER_0_29_433 VPWR VGND VPWR VGND sky130_ef_sc_hd__decap_12
XTAP_TAPCELL_ROW_32_501 VGND VPWR sky130_fd_sc_hd__tapvpwrvgnd_1
X_4712_ _1217_ _1281_ _1282_ VGND VGND VPWR VPWR _1284_ sky130_fd_sc_hd__or3_1
X_5692_ _1860_ _2241_ _2250_ VGND VGND VPWR VPWR _2251_ sky130_fd_sc_hd__a21o_1
X_4643_ _1145_ _1146_ _1147_ VGND VGND VPWR VPWR _1216_ sky130_fd_sc_hd__nor3_1
XFILLER_0_71_266 VPWR VGND VPWR VGND sky130_ef_sc_hd__decap_12
XFILLER_0_4_533 VPWR VGND VPWR VGND sky130_ef_sc_hd__decap_12
XFILLER_0_21_61 VGND VGND VPWR VPWR sky130_fd_sc_hd__fill_1
X_4574_ _1145_ _1146_ _1147_ VGND VGND VPWR VPWR _1148_ sky130_fd_sc_hd__or3_4
XFILLER_0_12_300 VGND VGND VPWR VPWR sky130_fd_sc_hd__decap_4
X_3525_ _2948_ _2964_ VGND VGND VPWR VPWR _2965_ sky130_fd_sc_hd__xnor2_1
X_6244_ clknet_leaf_13_clk _0157_ VGND VGND VPWR VPWR u_interface.core_attn_out\[19\]
+ sky130_fd_sc_hd__dfxtp_1
X_3456_ _2903_ _2904_ VGND VGND VPWR VPWR _2905_ sky130_fd_sc_hd__or2_1
X_6175_ clknet_leaf_20_clk _0088_ VGND VGND VPWR VPWR u_interface.u_compute_core.mac_accum\[29\]
+ sky130_fd_sc_hd__dfxtp_1
X_3387_ _2839_ _2843_ _2845_ VGND VGND VPWR VPWR _2846_ sky130_fd_sc_hd__a21oi_1
XFILLER_0_41_3 VPWR VGND VPWR VGND sky130_ef_sc_hd__decap_12
X_5126_ _1686_ _1687_ _1692_ VGND VGND VPWR VPWR _1693_ sky130_fd_sc_hd__nor3_1
XTAP_TAPCELL_ROW_4_237 VGND VPWR sky130_fd_sc_hd__tapvpwrvgnd_1
X_5057_ _1624_ _1623_ VGND VGND VPWR VPWR _1625_ sky130_fd_sc_hd__nand2_2
X_4008_ _0550_ _0552_ _0549_ VGND VGND VPWR VPWR _0592_ sky130_fd_sc_hd__o21ba_1
XFILLER_0_79_366 VGND VGND VPWR VPWR sky130_fd_sc_hd__fill_1
X_5959_ _2476_ _2480_ _2484_ VGND VGND VPWR VPWR _2489_ sky130_fd_sc_hd__or3b_1
XFILLER_0_90_531 VGND VGND VPWR VPWR sky130_fd_sc_hd__fill_1
XFILLER_0_35_436 VGND VGND VPWR VPWR sky130_fd_sc_hd__fill_1
XFILLER_0_47_285 VGND VGND VPWR VPWR sky130_fd_sc_hd__fill_1
XFILLER_0_62_211 VGND VGND VPWR VPWR sky130_fd_sc_hd__fill_1
XFILLER_0_62_233 VGND VGND VPWR VPWR sky130_fd_sc_hd__decap_3
XFILLER_0_7_393 VPWR VGND VPWR VGND sky130_ef_sc_hd__decap_12
XFILLER_0_15_182 VPWR VGND VPWR VGND sky130_ef_sc_hd__decap_12
XFILLER_0_43_491 VPWR VGND VPWR VGND sky130_ef_sc_hd__decap_12
Xhold73 u_interface.u_compute_core.u_mac.product_reg\[2\] VGND VGND VPWR VPWR net138
+ sky130_fd_sc_hd__dlygate4sd3_1
XTAP_TAPCELL_ROW_85_1009 VGND VPWR sky130_fd_sc_hd__tapvpwrvgnd_1
XTAP_TAPCELL_ROW_74_902 VGND VPWR sky130_fd_sc_hd__tapvpwrvgnd_1
Xhold84 u_interface.u_compute_core.u_mac.product_reg\[1\] VGND VGND VPWR VPWR net149
+ sky130_fd_sc_hd__dlygate4sd3_1
Xhold95 u_interface.u_compute_core.u_mac.product_reg\[11\] VGND VGND VPWR VPWR net160
+ sky130_fd_sc_hd__dlygate4sd3_1
XTAP_TAPCELL_ROW_46_637 VGND VPWR sky130_fd_sc_hd__tapvpwrvgnd_1
XFILLER_0_26_414 VGND VGND VPWR VPWR sky130_fd_sc_hd__decap_6
XFILLER_0_38_274 VGND VGND VPWR VPWR sky130_fd_sc_hd__decap_6
XFILLER_0_1_503 VGND VGND VPWR VPWR sky130_fd_sc_hd__fill_1
X_3310_ _2769_ _2778_ _2775_ _2754_ VGND VGND VPWR VPWR _2780_ sky130_fd_sc_hd__a31o_1
X_4290_ _0865_ _0866_ _0803_ VGND VGND VPWR VPWR _0868_ sky130_fd_sc_hd__a21o_1
X_3241_ _2716_ _2723_ VGND VGND VPWR VPWR _2724_ sky130_fd_sc_hd__and2_1
X_3172_ _2676_ VGND VGND VPWR VPWR _0030_ sky130_fd_sc_hd__clkbuf_1
XTAP_TAPCELL_ROW_1_207 VGND VPWR sky130_fd_sc_hd__tapvpwrvgnd_1
Xrebuffer16 net105 VGND VGND VPWR VPWR net81 sky130_fd_sc_hd__dlymetal6s2s_1
Xrebuffer27 _0845_ VGND VGND VPWR VPWR net92 sky130_fd_sc_hd__clkbuf_1
Xrebuffer38 _0958_ VGND VGND VPWR VPWR net103 sky130_fd_sc_hd__clkbuf_1
XFILLER_0_13_7 VGND VGND VPWR VPWR sky130_fd_sc_hd__fill_1
XFILLER_0_64_509 VGND VGND VPWR VPWR sky130_fd_sc_hd__fill_1
X_5813_ u_interface.core_attn_out\[9\] u_interface.u_compute_core.u_av.product_reg\[12\]
+ VGND VGND VPWR VPWR _2362_ sky130_fd_sc_hd__and2_1
XTAP_TAPCELL_ROW_17_361 VGND VPWR sky130_fd_sc_hd__tapvpwrvgnd_1
XFILLER_0_17_447 VGND VGND VPWR VPWR sky130_fd_sc_hd__fill_1
X_5744_ _2301_ u_interface.u_compute_core.u_av.product_reg\[3\] net206 VGND VGND VPWR
+ VPWR _2302_ sky130_fd_sc_hd__a21oi_1
XFILLER_0_32_82 VGND VGND VPWR VPWR sky130_fd_sc_hd__fill_2
XFILLER_0_17_469 VGND VGND VPWR VPWR sky130_fd_sc_hd__fill_1
XFILLER_0_44_244 VGND VGND VPWR VPWR sky130_fd_sc_hd__fill_1
X_5675_ _2165_ _2164_ VGND VGND VPWR VPWR _2235_ sky130_fd_sc_hd__and2b_1
XFILLER_0_89_3 VPWR VGND VPWR VGND sky130_ef_sc_hd__decap_12
X_4626_ _1196_ _1197_ _1189_ VGND VGND VPWR VPWR _1199_ sky130_fd_sc_hd__a21o_1
XFILLER_0_4_363 VGND VGND VPWR VPWR sky130_fd_sc_hd__fill_1
X_4557_ _1128_ _1129_ _1118_ VGND VGND VPWR VPWR _1131_ sky130_fd_sc_hd__a21o_1
XFILLER_0_12_141 VPWR VGND VPWR VGND sky130_ef_sc_hd__decap_12
X_4488_ _0993_ _0995_ _0994_ VGND VGND VPWR VPWR _1063_ sky130_fd_sc_hd__o21bai_1
XFILLER_0_12_185 VGND VGND VPWR VPWR sky130_fd_sc_hd__fill_1
X_3508_ net13 VGND VGND VPWR VPWR _2949_ sky130_fd_sc_hd__buf_2
X_6227_ clknet_leaf_17_clk _0140_ VGND VGND VPWR VPWR u_interface.core_attn_out\[2\]
+ sky130_fd_sc_hd__dfxtp_1
X_3439_ _2740_ VGND VGND VPWR VPWR _2890_ sky130_fd_sc_hd__buf_2
X_6158_ clknet_leaf_0_clk _0071_ VGND VGND VPWR VPWR u_interface.u_compute_core.mac_accum\[12\]
+ sky130_fd_sc_hd__dfxtp_1
X_5109_ _1673_ _1674_ _1675_ VGND VGND VPWR VPWR _1676_ sky130_fd_sc_hd__nand3_1
X_6089_ clknet_leaf_8_clk _0002_ VGND VGND VPWR VPWR u_interface.u_compute_core.relu_data\[2\]
+ sky130_fd_sc_hd__dfxtp_2
XFILLER_0_67_303 VGND VGND VPWR VPWR sky130_fd_sc_hd__fill_2
XTAP_TAPCELL_ROW_43_607 VGND VPWR sky130_fd_sc_hd__tapvpwrvgnd_1
XTAP_TAPCELL_ROW_51_684 VGND VPWR sky130_fd_sc_hd__tapvpwrvgnd_1
XFILLER_0_50_203 VPWR VGND VPWR VGND sky130_ef_sc_hd__decap_12
Xoutput30 net30 VGND VGND VPWR VPWR m_tdata[11] sky130_fd_sc_hd__buf_2
Xoutput52 net52 VGND VGND VPWR VPWR m_tdata[31] sky130_fd_sc_hd__buf_2
Xoutput41 net41 VGND VGND VPWR VPWR m_tdata[21] sky130_fd_sc_hd__buf_2
XTAP_TAPCELL_ROW_91_1068 VGND VPWR sky130_fd_sc_hd__tapvpwrvgnd_1
XTAP_TAPCELL_ROW_59_762 VGND VPWR sky130_fd_sc_hd__tapvpwrvgnd_1
XFILLER_0_53_15 VPWR VGND VPWR VGND sky130_ef_sc_hd__decap_12
XFILLER_0_85_155 VGND VGND VPWR VPWR sky130_fd_sc_hd__fill_1
XTAP_TAPCELL_ROW_14_331 VGND VPWR sky130_fd_sc_hd__tapvpwrvgnd_1
X_3790_ _0344_ _0348_ _0342_ VGND VGND VPWR VPWR _0384_ sky130_fd_sc_hd__a21oi_1
XFILLER_0_5_105 VGND VGND VPWR VPWR sky130_fd_sc_hd__decap_6
XFILLER_0_81_372 VPWR VGND VPWR VGND sky130_ef_sc_hd__decap_12
X_5460_ _1933_ _1938_ VGND VGND VPWR VPWR _2023_ sky130_fd_sc_hd__nor2_1
X_4411_ u_interface.u_compute_core.relu_data\[7\] _0632_ VGND VGND VPWR VPWR _0987_
+ sky130_fd_sc_hd__and2_1
XFILLER_0_41_225 VPWR VGND VPWR VGND sky130_ef_sc_hd__decap_12
X_5391_ _1904_ VGND VGND VPWR VPWR _1954_ sky130_fd_sc_hd__inv_2
XFILLER_0_41_269 VGND VGND VPWR VPWR sky130_fd_sc_hd__fill_1
XFILLER_0_22_472 VGND VGND VPWR VPWR sky130_fd_sc_hd__decap_4
X_4342_ _0856_ _0896_ VGND VGND VPWR VPWR _0919_ sky130_fd_sc_hd__nor2_1
X_4273_ _0789_ _0792_ _0788_ VGND VGND VPWR VPWR _0852_ sky130_fd_sc_hd__a21o_1
X_6012_ net57 u_interface.core_attn_out\[7\] _2521_ VGND VGND VPWR VPWR _2529_ sky130_fd_sc_hd__mux2_1
X_3224_ _2694_ _2711_ VGND VGND VPWR VPWR _2712_ sky130_fd_sc_hd__and2_1
.ends
